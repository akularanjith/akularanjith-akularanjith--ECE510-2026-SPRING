* NGSPICE file created from crossbar_mac.ext - technology: sky130A

* Black-box entry subcircuit for sky130_fd_sc_hd__decap_3 abstract view
.subckt sky130_fd_sc_hd__decap_3 VGND VNB VPB VPWR
.ends

* Black-box entry subcircuit for sky130_fd_sc_hd__a32o_1 abstract view
.subckt sky130_fd_sc_hd__a32o_1 A1 A2 A3 B1 B2 VGND VNB VPB VPWR X
.ends

* Black-box entry subcircuit for sky130_fd_sc_hd__nand4_1 abstract view
.subckt sky130_fd_sc_hd__nand4_1 A B C D VGND VNB VPB VPWR Y
.ends

* Black-box entry subcircuit for sky130_fd_sc_hd__decap_8 abstract view
.subckt sky130_fd_sc_hd__decap_8 VGND VNB VPB VPWR
.ends

* Black-box entry subcircuit for sky130_fd_sc_hd__a22o_1 abstract view
.subckt sky130_fd_sc_hd__a22o_1 A1 A2 B1 B2 VGND VNB VPB VPWR X
.ends

* Black-box entry subcircuit for sky130_fd_sc_hd__nand3_1 abstract view
.subckt sky130_fd_sc_hd__nand3_1 A B C VGND VNB VPB VPWR Y
.ends

* Black-box entry subcircuit for sky130_fd_sc_hd__a22oi_1 abstract view
.subckt sky130_fd_sc_hd__a22oi_1 A1 A2 B1 B2 VGND VNB VPB VPWR Y
.ends

* Black-box entry subcircuit for sky130_fd_sc_hd__fill_1 abstract view
.subckt sky130_fd_sc_hd__fill_1 VGND VNB VPB VPWR
.ends

* Black-box entry subcircuit for sky130_fd_sc_hd__nand3_2 abstract view
.subckt sky130_fd_sc_hd__nand3_2 A B C VGND VNB VPB VPWR Y
.ends

* Black-box entry subcircuit for sky130_fd_sc_hd__decap_4 abstract view
.subckt sky130_fd_sc_hd__decap_4 VGND VNB VPB VPWR
.ends

* Black-box entry subcircuit for sky130_fd_sc_hd__xnor2_1 abstract view
.subckt sky130_fd_sc_hd__xnor2_1 A B VGND VNB VPB VPWR Y
.ends

* Black-box entry subcircuit for sky130_ef_sc_hd__decap_12 abstract view
.subckt sky130_ef_sc_hd__decap_12 VPWR VGND VPB VNB
.ends

* Black-box entry subcircuit for sky130_fd_sc_hd__and2_1 abstract view
.subckt sky130_fd_sc_hd__and2_1 A B VGND VNB VPB VPWR X
.ends

* Black-box entry subcircuit for sky130_fd_sc_hd__nand2_4 abstract view
.subckt sky130_fd_sc_hd__nand2_4 A B VGND VNB VPB VPWR Y
.ends

* Black-box entry subcircuit for sky130_fd_sc_hd__and4b_1 abstract view
.subckt sky130_fd_sc_hd__and4b_1 A_N B C D VGND VNB VPB VPWR X
.ends

* Black-box entry subcircuit for sky130_fd_sc_hd__tapvpwrvgnd_1 abstract view
.subckt sky130_fd_sc_hd__tapvpwrvgnd_1 VGND VPWR
.ends

* Black-box entry subcircuit for sky130_fd_sc_hd__and2b_1 abstract view
.subckt sky130_fd_sc_hd__and2b_1 A_N B VGND VNB VPB VPWR X
.ends

* Black-box entry subcircuit for sky130_fd_sc_hd__decap_6 abstract view
.subckt sky130_fd_sc_hd__decap_6 VGND VNB VPB VPWR
.ends

* Black-box entry subcircuit for sky130_fd_sc_hd__xor2_1 abstract view
.subckt sky130_fd_sc_hd__xor2_1 A B VGND VNB VPB VPWR X
.ends

* Black-box entry subcircuit for sky130_fd_sc_hd__o21ai_1 abstract view
.subckt sky130_fd_sc_hd__o21ai_1 A1 A2 B1 VGND VNB VPB VPWR Y
.ends

* Black-box entry subcircuit for sky130_fd_sc_hd__a21o_1 abstract view
.subckt sky130_fd_sc_hd__a21o_1 A1 A2 B1 VGND VNB VPB VPWR X
.ends

* Black-box entry subcircuit for sky130_fd_sc_hd__and4_1 abstract view
.subckt sky130_fd_sc_hd__and4_1 A B C D VGND VNB VPB VPWR X
.ends

* Black-box entry subcircuit for sky130_fd_sc_hd__or2_4 abstract view
.subckt sky130_fd_sc_hd__or2_4 A B VGND VNB VPB VPWR X
.ends

* Black-box entry subcircuit for sky130_fd_sc_hd__dfrtp_1 abstract view
.subckt sky130_fd_sc_hd__dfrtp_1 CLK D RESET_B VGND VNB VPB VPWR Q
.ends

* Black-box entry subcircuit for sky130_fd_sc_hd__fill_2 abstract view
.subckt sky130_fd_sc_hd__fill_2 VGND VNB VPB VPWR
.ends

* Black-box entry subcircuit for sky130_fd_sc_hd__clkbuf_2 abstract view
.subckt sky130_fd_sc_hd__clkbuf_2 A VGND VNB VPB VPWR X
.ends

* Black-box entry subcircuit for sky130_fd_sc_hd__inv_2 abstract view
.subckt sky130_fd_sc_hd__inv_2 A VGND VNB VPB VPWR Y
.ends

* Black-box entry subcircuit for sky130_fd_sc_hd__nand2b_1 abstract view
.subckt sky130_fd_sc_hd__nand2b_1 A_N B VGND VNB VPB VPWR Y
.ends

* Black-box entry subcircuit for sky130_fd_sc_hd__nor2_1 abstract view
.subckt sky130_fd_sc_hd__nor2_1 A B VGND VNB VPB VPWR Y
.ends

* Black-box entry subcircuit for sky130_fd_sc_hd__a21bo_1 abstract view
.subckt sky130_fd_sc_hd__a21bo_1 A1 A2 B1_N VGND VNB VPB VPWR X
.ends

* Black-box entry subcircuit for sky130_fd_sc_hd__a211o_4 abstract view
.subckt sky130_fd_sc_hd__a211o_4 A1 A2 B1 C1 VGND VNB VPB VPWR X
.ends

* Black-box entry subcircuit for sky130_fd_sc_hd__nor3_2 abstract view
.subckt sky130_fd_sc_hd__nor3_2 A B C VGND VNB VPB VPWR Y
.ends

* Black-box entry subcircuit for sky130_fd_sc_hd__or3_4 abstract view
.subckt sky130_fd_sc_hd__or3_4 A B C VGND VNB VPB VPWR X
.ends

* Black-box entry subcircuit for sky130_fd_sc_hd__a21oi_1 abstract view
.subckt sky130_fd_sc_hd__a21oi_1 A1 A2 B1 VGND VNB VPB VPWR Y
.ends

* Black-box entry subcircuit for sky130_fd_sc_hd__and2_4 abstract view
.subckt sky130_fd_sc_hd__and2_4 A B VGND VNB VPB VPWR X
.ends

* Black-box entry subcircuit for sky130_fd_sc_hd__buf_2 abstract view
.subckt sky130_fd_sc_hd__buf_2 A VGND VNB VPB VPWR X
.ends

* Black-box entry subcircuit for sky130_fd_sc_hd__dlymetal6s2s_1 abstract view
.subckt sky130_fd_sc_hd__dlymetal6s2s_1 A VGND VNB VPB VPWR X
.ends

* Black-box entry subcircuit for sky130_fd_sc_hd__nand2_1 abstract view
.subckt sky130_fd_sc_hd__nand2_1 A B VGND VNB VPB VPWR Y
.ends

* Black-box entry subcircuit for sky130_fd_sc_hd__o21bai_1 abstract view
.subckt sky130_fd_sc_hd__o21bai_1 A1 A2 B1_N VGND VNB VPB VPWR Y
.ends

* Black-box entry subcircuit for sky130_fd_sc_hd__a211o_1 abstract view
.subckt sky130_fd_sc_hd__a211o_1 A1 A2 B1 C1 VGND VNB VPB VPWR X
.ends

* Black-box entry subcircuit for sky130_fd_sc_hd__o21a_1 abstract view
.subckt sky130_fd_sc_hd__o21a_1 A1 A2 B1 VGND VNB VPB VPWR X
.ends

* Black-box entry subcircuit for sky130_fd_sc_hd__a211oi_4 abstract view
.subckt sky130_fd_sc_hd__a211oi_4 A1 A2 B1 C1 VGND VNB VPB VPWR Y
.ends

* Black-box entry subcircuit for sky130_fd_sc_hd__nand3_4 abstract view
.subckt sky130_fd_sc_hd__nand3_4 A B C VGND VNB VPB VPWR Y
.ends

* Black-box entry subcircuit for sky130_fd_sc_hd__or2_1 abstract view
.subckt sky130_fd_sc_hd__or2_1 A B VGND VNB VPB VPWR X
.ends

* Black-box entry subcircuit for sky130_fd_sc_hd__xnor2_2 abstract view
.subckt sky130_fd_sc_hd__xnor2_2 A B VGND VNB VPB VPWR Y
.ends

* Black-box entry subcircuit for sky130_fd_sc_hd__a2bb2o_1 abstract view
.subckt sky130_fd_sc_hd__a2bb2o_1 A1_N A2_N B1 B2 VGND VNB VPB VPWR X
.ends

* Black-box entry subcircuit for sky130_fd_sc_hd__o2bb2a_1 abstract view
.subckt sky130_fd_sc_hd__o2bb2a_1 A1_N A2_N B1 B2 VGND VNB VPB VPWR X
.ends

* Black-box entry subcircuit for sky130_fd_sc_hd__o211a_4 abstract view
.subckt sky130_fd_sc_hd__o211a_4 A1 A2 B1 C1 VGND VNB VPB VPWR X
.ends

* Black-box entry subcircuit for sky130_fd_sc_hd__clkbuf_4 abstract view
.subckt sky130_fd_sc_hd__clkbuf_4 A VGND VNB VPB VPWR X
.ends

* Black-box entry subcircuit for sky130_fd_sc_hd__a21oi_2 abstract view
.subckt sky130_fd_sc_hd__a21oi_2 A1 A2 B1 VGND VNB VPB VPWR Y
.ends

* Black-box entry subcircuit for sky130_fd_sc_hd__or3_1 abstract view
.subckt sky130_fd_sc_hd__or3_1 A B C VGND VNB VPB VPWR X
.ends

* Black-box entry subcircuit for sky130_fd_sc_hd__o211ai_2 abstract view
.subckt sky130_fd_sc_hd__o211ai_2 A1 A2 B1 C1 VGND VNB VPB VPWR Y
.ends

* Black-box entry subcircuit for sky130_fd_sc_hd__a31o_1 abstract view
.subckt sky130_fd_sc_hd__a31o_1 A1 A2 A3 B1 VGND VNB VPB VPWR X
.ends

* Black-box entry subcircuit for sky130_fd_sc_hd__a22oi_2 abstract view
.subckt sky130_fd_sc_hd__a22oi_2 A1 A2 B1 B2 VGND VNB VPB VPWR Y
.ends

* Black-box entry subcircuit for sky130_fd_sc_hd__and3_1 abstract view
.subckt sky130_fd_sc_hd__and3_1 A B C VGND VNB VPB VPWR X
.ends

* Black-box entry subcircuit for sky130_fd_sc_hd__o211a_1 abstract view
.subckt sky130_fd_sc_hd__o211a_1 A1 A2 B1 C1 VGND VNB VPB VPWR X
.ends

* Black-box entry subcircuit for sky130_fd_sc_hd__nand4_2 abstract view
.subckt sky130_fd_sc_hd__nand4_2 A B C D VGND VNB VPB VPWR Y
.ends

* Black-box entry subcircuit for sky130_fd_sc_hd__xor2_2 abstract view
.subckt sky130_fd_sc_hd__xor2_2 A B VGND VNB VPB VPWR X
.ends

* Black-box entry subcircuit for sky130_fd_sc_hd__o21a_4 abstract view
.subckt sky130_fd_sc_hd__o21a_4 A1 A2 B1 VGND VNB VPB VPWR X
.ends

* Black-box entry subcircuit for sky130_fd_sc_hd__diode_2 abstract view
.subckt sky130_fd_sc_hd__diode_2 DIODE VGND VNB VPB VPWR
.ends

* Black-box entry subcircuit for sky130_fd_sc_hd__buf_6 abstract view
.subckt sky130_fd_sc_hd__buf_6 A VGND VNB VPB VPWR X
.ends

* Black-box entry subcircuit for sky130_fd_sc_hd__clkbuf_1 abstract view
.subckt sky130_fd_sc_hd__clkbuf_1 A VGND VNB VPB VPWR X
.ends

* Black-box entry subcircuit for sky130_fd_sc_hd__buf_8 abstract view
.subckt sky130_fd_sc_hd__buf_8 A VGND VNB VPB VPWR X
.ends

* Black-box entry subcircuit for sky130_fd_sc_hd__buf_1 abstract view
.subckt sky130_fd_sc_hd__buf_1 A VGND VNB VPB VPWR X
.ends

* Black-box entry subcircuit for sky130_fd_sc_hd__o21ba_1 abstract view
.subckt sky130_fd_sc_hd__o21ba_1 A1 A2 B1_N VGND VNB VPB VPWR X
.ends

* Black-box entry subcircuit for sky130_fd_sc_hd__and2_2 abstract view
.subckt sky130_fd_sc_hd__and2_2 A B VGND VNB VPB VPWR X
.ends

* Black-box entry subcircuit for sky130_fd_sc_hd__clkbuf_16 abstract view
.subckt sky130_fd_sc_hd__clkbuf_16 A VGND VNB VPB VPWR X
.ends

* Black-box entry subcircuit for sky130_fd_sc_hd__o211ai_4 abstract view
.subckt sky130_fd_sc_hd__o211ai_4 A1 A2 B1 C1 VGND VNB VPB VPWR Y
.ends

* Black-box entry subcircuit for sky130_fd_sc_hd__nor2_2 abstract view
.subckt sky130_fd_sc_hd__nor2_2 A B VGND VNB VPB VPWR Y
.ends

* Black-box entry subcircuit for sky130_fd_sc_hd__nand3b_1 abstract view
.subckt sky130_fd_sc_hd__nand3b_1 A_N B C VGND VNB VPB VPWR Y
.ends

* Black-box entry subcircuit for sky130_fd_sc_hd__or2_2 abstract view
.subckt sky130_fd_sc_hd__or2_2 A B VGND VNB VPB VPWR X
.ends

* Black-box entry subcircuit for sky130_fd_sc_hd__or4bb_1 abstract view
.subckt sky130_fd_sc_hd__or4bb_1 A B C_N D_N VGND VNB VPB VPWR X
.ends

* Black-box entry subcircuit for sky130_fd_sc_hd__o211ai_1 abstract view
.subckt sky130_fd_sc_hd__o211ai_1 A1 A2 B1 C1 VGND VNB VPB VPWR Y
.ends

* Black-box entry subcircuit for sky130_fd_sc_hd__nor3_1 abstract view
.subckt sky130_fd_sc_hd__nor3_1 A B C VGND VNB VPB VPWR Y
.ends

* Black-box entry subcircuit for sky130_fd_sc_hd__a211oi_2 abstract view
.subckt sky130_fd_sc_hd__a211oi_2 A1 A2 B1 C1 VGND VNB VPB VPWR Y
.ends

* Black-box entry subcircuit for sky130_fd_sc_hd__dlygate4sd1_1 abstract view
.subckt sky130_fd_sc_hd__dlygate4sd1_1 A VGND VNB VPB VPWR X
.ends

* Black-box entry subcircuit for sky130_fd_sc_hd__o22a_1 abstract view
.subckt sky130_fd_sc_hd__o22a_1 A1 A2 B1 B2 VGND VNB VPB VPWR X
.ends

* Black-box entry subcircuit for sky130_fd_sc_hd__nand2_2 abstract view
.subckt sky130_fd_sc_hd__nand2_2 A B VGND VNB VPB VPWR Y
.ends

* Black-box entry subcircuit for sky130_fd_sc_hd__o21bai_2 abstract view
.subckt sky130_fd_sc_hd__o21bai_2 A1 A2 B1_N VGND VNB VPB VPWR Y
.ends

* Black-box entry subcircuit for sky130_fd_sc_hd__nor3b_2 abstract view
.subckt sky130_fd_sc_hd__nor3b_2 A B C_N VGND VNB VPB VPWR Y
.ends

* Black-box entry subcircuit for sky130_fd_sc_hd__a21boi_2 abstract view
.subckt sky130_fd_sc_hd__a21boi_2 A1 A2 B1_N VGND VNB VPB VPWR Y
.ends

* Black-box entry subcircuit for sky130_fd_sc_hd__nand2b_4 abstract view
.subckt sky130_fd_sc_hd__nand2b_4 A_N B VGND VNB VPB VPWR Y
.ends

* Black-box entry subcircuit for sky130_fd_sc_hd__o21ai_2 abstract view
.subckt sky130_fd_sc_hd__o21ai_2 A1 A2 B1 VGND VNB VPB VPWR Y
.ends

* Black-box entry subcircuit for sky130_fd_sc_hd__o31a_2 abstract view
.subckt sky130_fd_sc_hd__o31a_2 A1 A2 A3 B1 VGND VNB VPB VPWR X
.ends

* Black-box entry subcircuit for sky130_fd_sc_hd__a21boi_1 abstract view
.subckt sky130_fd_sc_hd__a21boi_1 A1 A2 B1_N VGND VNB VPB VPWR Y
.ends

* Black-box entry subcircuit for sky130_fd_sc_hd__or4_1 abstract view
.subckt sky130_fd_sc_hd__or4_1 A B C D VGND VNB VPB VPWR X
.ends

* Black-box entry subcircuit for sky130_fd_sc_hd__a21oi_4 abstract view
.subckt sky130_fd_sc_hd__a21oi_4 A1 A2 B1 VGND VNB VPB VPWR Y
.ends

* Black-box entry subcircuit for sky130_fd_sc_hd__o22a_4 abstract view
.subckt sky130_fd_sc_hd__o22a_4 A1 A2 B1 B2 VGND VNB VPB VPWR X
.ends

* Black-box entry subcircuit for sky130_fd_sc_hd__and4bb_1 abstract view
.subckt sky130_fd_sc_hd__and4bb_1 A_N B_N C D VGND VNB VPB VPWR X
.ends

* Black-box entry subcircuit for sky130_fd_sc_hd__buf_4 abstract view
.subckt sky130_fd_sc_hd__buf_4 A VGND VNB VPB VPWR X
.ends

* Black-box entry subcircuit for sky130_fd_sc_hd__or3b_2 abstract view
.subckt sky130_fd_sc_hd__or3b_2 A B C_N VGND VNB VPB VPWR X
.ends

* Black-box entry subcircuit for sky130_fd_sc_hd__o21ba_4 abstract view
.subckt sky130_fd_sc_hd__o21ba_4 A1 A2 B1_N VGND VNB VPB VPWR X
.ends

* Black-box entry subcircuit for sky130_fd_sc_hd__and3_4 abstract view
.subckt sky130_fd_sc_hd__and3_4 A B C VGND VNB VPB VPWR X
.ends

* Black-box entry subcircuit for sky130_fd_sc_hd__nor4_4 abstract view
.subckt sky130_fd_sc_hd__nor4_4 A B C D VGND VNB VPB VPWR Y
.ends

* Black-box entry subcircuit for sky130_fd_sc_hd__o311a_4 abstract view
.subckt sky130_fd_sc_hd__o311a_4 A1 A2 A3 B1 C1 VGND VNB VPB VPWR X
.ends

* Black-box entry subcircuit for sky130_fd_sc_hd__clkinv_2 abstract view
.subckt sky130_fd_sc_hd__clkinv_2 A VGND VNB VPB VPWR Y
.ends

* Black-box entry subcircuit for sky130_fd_sc_hd__or3b_4 abstract view
.subckt sky130_fd_sc_hd__or3b_4 A B C_N VGND VNB VPB VPWR X
.ends

* Black-box entry subcircuit for sky130_fd_sc_hd__a31oi_1 abstract view
.subckt sky130_fd_sc_hd__a31oi_1 A1 A2 A3 B1 VGND VNB VPB VPWR Y
.ends

* Black-box entry subcircuit for sky130_fd_sc_hd__a221oi_4 abstract view
.subckt sky130_fd_sc_hd__a221oi_4 A1 A2 B1 B2 C1 VGND VNB VPB VPWR Y
.ends

* Black-box entry subcircuit for sky130_fd_sc_hd__mux2_1 abstract view
.subckt sky130_fd_sc_hd__mux2_1 A0 A1 S VGND VNB VPB VPWR X
.ends

* Black-box entry subcircuit for sky130_fd_sc_hd__clkbuf_8 abstract view
.subckt sky130_fd_sc_hd__clkbuf_8 A VGND VNB VPB VPWR X
.ends

* Black-box entry subcircuit for sky130_fd_sc_hd__or3b_1 abstract view
.subckt sky130_fd_sc_hd__or3b_1 A B C_N VGND VNB VPB VPWR X
.ends

* Black-box entry subcircuit for sky130_fd_sc_hd__o41a_1 abstract view
.subckt sky130_fd_sc_hd__o41a_1 A1 A2 A3 A4 B1 VGND VNB VPB VPWR X
.ends

* Black-box entry subcircuit for sky130_fd_sc_hd__a41o_1 abstract view
.subckt sky130_fd_sc_hd__a41o_1 A1 A2 A3 A4 B1 VGND VNB VPB VPWR X
.ends

* Black-box entry subcircuit for sky130_fd_sc_hd__bufinv_16 abstract view
.subckt sky130_fd_sc_hd__bufinv_16 A VGND VNB VPB VPWR Y
.ends

* Black-box entry subcircuit for sky130_fd_sc_hd__o21ai_4 abstract view
.subckt sky130_fd_sc_hd__o21ai_4 A1 A2 B1 VGND VNB VPB VPWR Y
.ends

* Black-box entry subcircuit for sky130_fd_sc_hd__nor3_4 abstract view
.subckt sky130_fd_sc_hd__nor3_4 A B C VGND VNB VPB VPWR Y
.ends

* Black-box entry subcircuit for sky130_fd_sc_hd__o31ai_2 abstract view
.subckt sky130_fd_sc_hd__o31ai_2 A1 A2 A3 B1 VGND VNB VPB VPWR Y
.ends

* Black-box entry subcircuit for sky130_fd_sc_hd__nand2b_2 abstract view
.subckt sky130_fd_sc_hd__nand2b_2 A_N B VGND VNB VPB VPWR Y
.ends

* Black-box entry subcircuit for sky130_fd_sc_hd__o2bb2ai_1 abstract view
.subckt sky130_fd_sc_hd__o2bb2ai_1 A1_N A2_N B1 B2 VGND VNB VPB VPWR Y
.ends

* Black-box entry subcircuit for sky130_fd_sc_hd__inv_6 abstract view
.subckt sky130_fd_sc_hd__inv_6 A VGND VNB VPB VPWR Y
.ends

* Black-box entry subcircuit for sky130_fd_sc_hd__or4b_1 abstract view
.subckt sky130_fd_sc_hd__or4b_1 A B C D_N VGND VNB VPB VPWR X
.ends

* Black-box entry subcircuit for sky130_fd_sc_hd__clkinvlp_4 abstract view
.subckt sky130_fd_sc_hd__clkinvlp_4 A VGND VNB VPB VPWR Y
.ends

* Black-box entry subcircuit for sky130_fd_sc_hd__nor2_8 abstract view
.subckt sky130_fd_sc_hd__nor2_8 A B VGND VNB VPB VPWR Y
.ends

* Black-box entry subcircuit for sky130_fd_sc_hd__o32a_1 abstract view
.subckt sky130_fd_sc_hd__o32a_1 A1 A2 A3 B1 B2 VGND VNB VPB VPWR X
.ends

* Black-box entry subcircuit for sky130_fd_sc_hd__o21bai_4 abstract view
.subckt sky130_fd_sc_hd__o21bai_4 A1 A2 B1_N VGND VNB VPB VPWR Y
.ends

* Black-box entry subcircuit for sky130_fd_sc_hd__and2b_2 abstract view
.subckt sky130_fd_sc_hd__and2b_2 A_N B VGND VNB VPB VPWR X
.ends

* Black-box entry subcircuit for sky130_fd_sc_hd__o22ai_1 abstract view
.subckt sky130_fd_sc_hd__o22ai_1 A1 A2 B1 B2 VGND VNB VPB VPWR Y
.ends

* Black-box entry subcircuit for sky130_fd_sc_hd__inv_4 abstract view
.subckt sky130_fd_sc_hd__inv_4 A VGND VNB VPB VPWR Y
.ends

* Black-box entry subcircuit for sky130_fd_sc_hd__nor2_4 abstract view
.subckt sky130_fd_sc_hd__nor2_4 A B VGND VNB VPB VPWR Y
.ends

* Black-box entry subcircuit for sky130_fd_sc_hd__o2111a_1 abstract view
.subckt sky130_fd_sc_hd__o2111a_1 A1 A2 B1 C1 D1 VGND VNB VPB VPWR X
.ends

* Black-box entry subcircuit for sky130_fd_sc_hd__o221a_1 abstract view
.subckt sky130_fd_sc_hd__o221a_1 A1 A2 B1 B2 C1 VGND VNB VPB VPWR X
.ends

* Black-box entry subcircuit for sky130_fd_sc_hd__o32a_2 abstract view
.subckt sky130_fd_sc_hd__o32a_2 A1 A2 A3 B1 B2 VGND VNB VPB VPWR X
.ends

* Black-box entry subcircuit for sky130_fd_sc_hd__a2111o_1 abstract view
.subckt sky130_fd_sc_hd__a2111o_1 A1 A2 B1 C1 D1 VGND VNB VPB VPWR X
.ends

* Black-box entry subcircuit for sky130_fd_sc_hd__o31ai_4 abstract view
.subckt sky130_fd_sc_hd__o31ai_4 A1 A2 A3 B1 VGND VNB VPB VPWR Y
.ends

* Black-box entry subcircuit for sky130_fd_sc_hd__nor4_2 abstract view
.subckt sky130_fd_sc_hd__nor4_2 A B C D VGND VNB VPB VPWR Y
.ends

* Black-box entry subcircuit for sky130_fd_sc_hd__clkinv_4 abstract view
.subckt sky130_fd_sc_hd__clkinv_4 A VGND VNB VPB VPWR Y
.ends

* Black-box entry subcircuit for sky130_fd_sc_hd__clkdlybuf4s18_2 abstract view
.subckt sky130_fd_sc_hd__clkdlybuf4s18_2 A VGND VNB VPB VPWR X
.ends

* Black-box entry subcircuit for sky130_fd_sc_hd__buf_12 abstract view
.subckt sky130_fd_sc_hd__buf_12 A VGND VNB VPB VPWR X
.ends

* Black-box entry subcircuit for sky130_fd_sc_hd__a2bb2oi_1 abstract view
.subckt sky130_fd_sc_hd__a2bb2oi_1 A1_N A2_N B1 B2 VGND VNB VPB VPWR Y
.ends

* Black-box entry subcircuit for sky130_fd_sc_hd__and3_2 abstract view
.subckt sky130_fd_sc_hd__and3_2 A B C VGND VNB VPB VPWR X
.ends

* Black-box entry subcircuit for sky130_fd_sc_hd__or4_2 abstract view
.subckt sky130_fd_sc_hd__or4_2 A B C D VGND VNB VPB VPWR X
.ends

* Black-box entry subcircuit for sky130_fd_sc_hd__a21o_2 abstract view
.subckt sky130_fd_sc_hd__a21o_2 A1 A2 B1 VGND VNB VPB VPWR X
.ends

* Black-box entry subcircuit for sky130_fd_sc_hd__or4bb_4 abstract view
.subckt sky130_fd_sc_hd__or4bb_4 A B C_N D_N VGND VNB VPB VPWR X
.ends

* Black-box entry subcircuit for sky130_fd_sc_hd__nor3b_4 abstract view
.subckt sky130_fd_sc_hd__nor3b_4 A B C_N VGND VNB VPB VPWR Y
.ends

* Black-box entry subcircuit for sky130_fd_sc_hd__o31ai_1 abstract view
.subckt sky130_fd_sc_hd__o31ai_1 A1 A2 A3 B1 VGND VNB VPB VPWR Y
.ends

* Black-box entry subcircuit for sky130_fd_sc_hd__o31a_1 abstract view
.subckt sky130_fd_sc_hd__o31a_1 A1 A2 A3 B1 VGND VNB VPB VPWR X
.ends

* Black-box entry subcircuit for sky130_fd_sc_hd__o21ba_2 abstract view
.subckt sky130_fd_sc_hd__o21ba_2 A1 A2 B1_N VGND VNB VPB VPWR X
.ends

* Black-box entry subcircuit for sky130_fd_sc_hd__nor4_1 abstract view
.subckt sky130_fd_sc_hd__nor4_1 A B C D VGND VNB VPB VPWR Y
.ends

* Black-box entry subcircuit for sky130_fd_sc_hd__or4b_4 abstract view
.subckt sky130_fd_sc_hd__or4b_4 A B C D_N VGND VNB VPB VPWR X
.ends

* Black-box entry subcircuit for sky130_fd_sc_hd__nand4_4 abstract view
.subckt sky130_fd_sc_hd__nand4_4 A B C D VGND VNB VPB VPWR Y
.ends

* Black-box entry subcircuit for sky130_fd_sc_hd__nand3b_2 abstract view
.subckt sky130_fd_sc_hd__nand3b_2 A_N B C VGND VNB VPB VPWR Y
.ends

* Black-box entry subcircuit for sky130_fd_sc_hd__o2111ai_1 abstract view
.subckt sky130_fd_sc_hd__o2111ai_1 A1 A2 B1 C1 D1 VGND VNB VPB VPWR Y
.ends

* Black-box entry subcircuit for sky130_fd_sc_hd__a311o_1 abstract view
.subckt sky130_fd_sc_hd__a311o_1 A1 A2 A3 B1 C1 VGND VNB VPB VPWR X
.ends

* Black-box entry subcircuit for sky130_fd_sc_hd__dlymetal6s4s_1 abstract view
.subckt sky130_fd_sc_hd__dlymetal6s4s_1 A VGND VNB VPB VPWR X
.ends

* Black-box entry subcircuit for sky130_fd_sc_hd__and4_2 abstract view
.subckt sky130_fd_sc_hd__and4_2 A B C D VGND VNB VPB VPWR X
.ends

* Black-box entry subcircuit for sky130_fd_sc_hd__a22o_2 abstract view
.subckt sky130_fd_sc_hd__a22o_2 A1 A2 B1 B2 VGND VNB VPB VPWR X
.ends

* Black-box entry subcircuit for sky130_fd_sc_hd__and3b_1 abstract view
.subckt sky130_fd_sc_hd__and3b_1 A_N B C VGND VNB VPB VPWR X
.ends

* Black-box entry subcircuit for sky130_fd_sc_hd__or4_4 abstract view
.subckt sky130_fd_sc_hd__or4_4 A B C D VGND VNB VPB VPWR X
.ends

* Black-box entry subcircuit for sky130_fd_sc_hd__o32ai_4 abstract view
.subckt sky130_fd_sc_hd__o32ai_4 A1 A2 A3 B1 B2 VGND VNB VPB VPWR Y
.ends

* Black-box entry subcircuit for sky130_fd_sc_hd__and4b_2 abstract view
.subckt sky130_fd_sc_hd__and4b_2 A_N B C D VGND VNB VPB VPWR X
.ends

* Black-box entry subcircuit for sky130_fd_sc_hd__a2bb2o_4 abstract view
.subckt sky130_fd_sc_hd__a2bb2o_4 A1_N A2_N B1 B2 VGND VNB VPB VPWR X
.ends

* Black-box entry subcircuit for sky130_fd_sc_hd__a211oi_1 abstract view
.subckt sky130_fd_sc_hd__a211oi_1 A1 A2 B1 C1 VGND VNB VPB VPWR Y
.ends

* Black-box entry subcircuit for sky130_fd_sc_hd__o22a_2 abstract view
.subckt sky130_fd_sc_hd__o22a_2 A1 A2 B1 B2 VGND VNB VPB VPWR X
.ends

.subckt crossbar_mac VGND VPWR clk in0[0] in0[1] in0[2] in0[3] in0[4] in0[5] in0[6]
+ in0[7] in1[0] in1[1] in1[2] in1[3] in1[4] in1[5] in1[6] in1[7] in2[0] in2[1] in2[2]
+ in2[3] in2[4] in2[5] in2[6] in2[7] in3[0] in3[1] in3[2] in3[3] in3[4] in3[5] in3[6]
+ in3[7] out0[0] out0[10] out0[11] out0[12] out0[13] out0[14] out0[15] out0[1] out0[2]
+ out0[3] out0[4] out0[5] out0[6] out0[7] out0[8] out0[9] out1[0] out1[10] out1[11]
+ out1[12] out1[13] out1[14] out1[15] out1[1] out1[2] out1[3] out1[4] out1[5] out1[6]
+ out1[7] out1[8] out1[9] out2[0] out2[10] out2[11] out2[12] out2[13] out2[14] out2[15]
+ out2[1] out2[2] out2[3] out2[4] out2[5] out2[6] out2[7] out2[8] out2[9] out3[0]
+ out3[10] out3[11] out3[12] out3[13] out3[14] out3[15] out3[1] out3[2] out3[3] out3[4]
+ out3[5] out3[6] out3[7] out3[8] out3[9] rst w00[0] w00[1] w00[2] w00[3] w00[4] w00[5]
+ w00[6] w00[7] w01[0] w01[1] w01[2] w01[3] w01[4] w01[5] w01[6] w01[7] w02[0] w02[1]
+ w02[2] w02[3] w02[4] w02[5] w02[6] w02[7] w03[0] w03[1] w03[2] w03[3] w03[4] w03[5]
+ w03[6] w03[7] w10[0] w10[1] w10[2] w10[3] w10[4] w10[5] w10[6] w10[7] w11[0] w11[1]
+ w11[2] w11[3] w11[4] w11[5] w11[6] w11[7] w12[0] w12[1] w12[2] w12[3] w12[4] w12[5]
+ w12[6] w12[7] w13[0] w13[1] w13[2] w13[3] w13[4] w13[5] w13[6] w13[7] w20[0] w20[1]
+ w20[2] w20[3] w20[4] w20[5] w20[6] w20[7] w21[0] w21[1] w21[2] w21[3] w21[4] w21[5]
+ w21[6] w21[7] w22[0] w22[1] w22[2] w22[3] w22[4] w22[5] w22[6] w22[7] w23[0] w23[1]
+ w23[2] w23[3] w23[4] w23[5] w23[6] w23[7] w30[0] w30[1] w30[2] w30[3] w30[4] w30[5]
+ w30[6] w30[7] w31[0] w31[1] w31[2] w31[3] w31[4] w31[5] w31[6] w31[7] w32[0] w32[1]
+ w32[2] w32[3] w32[4] w32[5] w32[6] w32[7] w33[0] w33[1] w33[2] w33[3] w33[4] w33[5]
+ w33[6] w33[7]
XFILLER_94_361 VGND VGND VPWR VPWR sky130_fd_sc_hd__decap_3
X_09671_ net423 net537 _02311_ _02310_ net415 VGND VGND VPWR VPWR _02429_ sky130_fd_sc_hd__a32o_1
X_06883_ net804 net389 net427 net378 VGND VGND VPWR VPWR _04254_ sky130_fd_sc_hd__nand4_1
XFILLER_67_575 VGND VGND VPWR VPWR sky130_fd_sc_hd__decap_8
XFILLER_39_255 VGND VGND VPWR VPWR sky130_fd_sc_hd__decap_3
X_08622_ net596 net264 net262 net622 VGND VGND VPWR VPWR _01350_ sky130_fd_sc_hd__a22o_1
XFILLER_54_236 VGND VGND VPWR VPWR sky130_fd_sc_hd__decap_8
X_08553_ _01128_ _01275_ _01281_ VGND VGND VPWR VPWR _01282_ sky130_fd_sc_hd__nand3_1
XFILLER_54_269 VGND VGND VPWR VPWR sky130_fd_sc_hd__decap_3
X_08484_ net523 net632 net630 net530 VGND VGND VPWR VPWR _01213_ sky130_fd_sc_hd__a22oi_1
XFILLER_82_589 VGND VGND VPWR VPWR sky130_fd_sc_hd__fill_1
X_07504_ _00242_ _00243_ _00244_ VGND VGND VPWR VPWR _00245_ sky130_fd_sc_hd__nand3_2
XFILLER_23_612 VGND VGND VPWR VPWR sky130_fd_sc_hd__decap_4
X_07435_ _00174_ _00175_ VGND VGND VPWR VPWR _00176_ sky130_fd_sc_hd__xnor2_1
XFILLER_50_442 VGND VGND VPWR VPWR sky130_fd_sc_hd__fill_1
X_07366_ _06654_ _06655_ VGND VGND VPWR VPWR _06657_ sky130_fd_sc_hd__xnor2_1
XFILLER_109_706 VGND VGND VPWR VPWR sky130_fd_sc_hd__decap_3
XFILLER_10_328 VPWR VGND VPWR VGND sky130_ef_sc_hd__decap_12
XFILLER_108_216 VPWR VGND VPWR VGND sky130_ef_sc_hd__decap_12
X_09105_ _01661_ _01663_ VGND VGND VPWR VPWR _01830_ sky130_fd_sc_hd__and2_1
X_07297_ net614 net403 VGND VGND VPWR VPWR _06588_ sky130_fd_sc_hd__nand2_4
X_09036_ net693 net670 net254 net97 VGND VGND VPWR VPWR _01761_ sky130_fd_sc_hd__and4b_1
XTAP_TAPCELL_ROW_94_1609 VGND VPWR sky130_fd_sc_hd__tapvpwrvgnd_1
XFILLER_89_111 VGND VGND VPWR VPWR sky130_fd_sc_hd__fill_1
XFILLER_117_77 VGND VGND VPWR VPWR sky130_fd_sc_hd__fill_1
XFILLER_117_55 VGND VGND VPWR VPWR sky130_fd_sc_hd__fill_1
XFILLER_116_293 VGND VGND VPWR VPWR sky130_fd_sc_hd__decap_8
XFILLER_78_807 VGND VGND VPWR VPWR sky130_fd_sc_hd__fill_1
XFILLER_77_26 VPWR VGND VPWR VGND sky130_ef_sc_hd__decap_12
X_09938_ _02719_ _02718_ VGND VGND VPWR VPWR _02720_ sky130_fd_sc_hd__and2b_1
XFILLER_104_477 VGND VGND VPWR VPWR sky130_fd_sc_hd__decap_6
XFILLER_92_309 VGND VGND VPWR VPWR sky130_fd_sc_hd__decap_4
X_09869_ _02637_ _02643_ VGND VGND VPWR VPWR _02645_ sky130_fd_sc_hd__xor2_1
XTAP_TAPCELL_ROW_5_365 VGND VPWR sky130_fd_sc_hd__tapvpwrvgnd_1
XFILLER_93_25 VPWR VGND VPWR VGND sky130_ef_sc_hd__decap_12
X_11900_ _04709_ _04712_ _04706_ VGND VGND VPWR VPWR _04854_ sky130_fd_sc_hd__o21ai_1
X_12880_ net440 net145 VGND VGND VPWR VPWR _05925_ sky130_fd_sc_hd__and2b_1
X_11831_ _04776_ _04777_ _04764_ VGND VGND VPWR VPWR _04779_ sky130_fd_sc_hd__a21o_1
XTAP_TAPCELL_ROW_44_905 VGND VPWR sky130_fd_sc_hd__tapvpwrvgnd_1
XFILLER_61_729 VPWR VGND VPWR VGND sky130_ef_sc_hd__decap_12
XFILLER_60_228 VGND VGND VPWR VPWR sky130_fd_sc_hd__decap_3
XTAP_TAPCELL_ROW_44_916 VGND VPWR sky130_fd_sc_hd__tapvpwrvgnd_1
XFILLER_26_52 VGND VGND VPWR VPWR sky130_fd_sc_hd__fill_1
XTAP_TAPCELL_ROW_103_1738 VGND VPWR sky130_fd_sc_hd__tapvpwrvgnd_1
X_11762_ _04696_ _04700_ _04702_ VGND VGND VPWR VPWR _04703_ sky130_fd_sc_hd__a21o_1
XFILLER_53_291 VGND VGND VPWR VPWR sky130_fd_sc_hd__decap_3
XFILLER_13_111 VGND VGND VPWR VPWR sky130_fd_sc_hd__fill_1
XFILLER_14_645 VPWR VGND VPWR VGND sky130_ef_sc_hd__decap_12
X_11693_ net471 net462 net598 net588 VGND VGND VPWR VPWR _04628_ sky130_fd_sc_hd__and4_1
X_10713_ _03537_ _03559_ VGND VGND VPWR VPWR _03561_ sky130_fd_sc_hd__xnor2_1
XTAP_TAPCELL_ROW_136_2215 VGND VPWR sky130_fd_sc_hd__tapvpwrvgnd_1
XTAP_TAPCELL_ROW_136_2204 VGND VPWR sky130_fd_sc_hd__tapvpwrvgnd_1
X_10644_ _03485_ _03424_ VGND VGND VPWR VPWR _03486_ sky130_fd_sc_hd__or2_4
X_13363_ clknet_3_2__leaf_clk _00050_ _00073_ VGND VGND VPWR VPWR net177 sky130_fd_sc_hd__dfrtp_1
XFILLER_127_503 VGND VGND VPWR VPWR sky130_fd_sc_hd__fill_1
X_10575_ _03407_ _03408_ _03404_ VGND VGND VPWR VPWR _03410_ sky130_fd_sc_hd__a21o_1
XFILLER_127_558 VGND VGND VPWR VPWR sky130_fd_sc_hd__fill_2
Xrebuffer7 _00229_ VGND VGND VPWR VPWR net707 sky130_fd_sc_hd__clkbuf_2
X_12314_ _05304_ _05305_ VGND VGND VPWR VPWR _00035_ sky130_fd_sc_hd__xor2_1
X_13294_ net394 VGND VGND VPWR VPWR _00068_ sky130_fd_sc_hd__inv_2
XFILLER_115_709 VPWR VGND VPWR VGND sky130_ef_sc_hd__decap_12
XFILLER_114_219 VGND VGND VPWR VPWR sky130_fd_sc_hd__decap_3
XFILLER_107_260 VGND VGND VPWR VPWR sky130_fd_sc_hd__fill_1
X_12245_ _05063_ _05229_ VGND VGND VPWR VPWR _05230_ sky130_fd_sc_hd__xnor2_1
XPHY_EDGE_ROW_39_Left_176 VGND VGND VPWR VPWR sky130_fd_sc_hd__decap_3
XTAP_TAPCELL_ROW_114_1889 VGND VPWR sky130_fd_sc_hd__tapvpwrvgnd_1
X_12176_ _05153_ _05152_ VGND VGND VPWR VPWR _05154_ sky130_fd_sc_hd__nand2b_1
XFILLER_123_797 VGND VGND VPWR VPWR sky130_fd_sc_hd__decap_8
X_11127_ _04011_ _04012_ VGND VGND VPWR VPWR _04015_ sky130_fd_sc_hd__and2_1
XFILLER_95_125 VPWR VGND VPWR VGND sky130_ef_sc_hd__decap_12
XFILLER_95_169 VPWR VGND VPWR VGND sky130_ef_sc_hd__decap_12
XFILLER_95_158 VGND VGND VPWR VPWR sky130_fd_sc_hd__decap_8
XFILLER_67_70 VPWR VGND VPWR VGND sky130_ef_sc_hd__decap_12
XFILLER_64_501 VPWR VGND VPWR VGND sky130_ef_sc_hd__decap_12
X_11058_ _03925_ _03938_ VGND VGND VPWR VPWR _03939_ sky130_fd_sc_hd__xor2_1
X_10009_ net458 net579 _02789_ _02792_ VGND VGND VPWR VPWR _02794_ sky130_fd_sc_hd__a22oi_1
XFILLER_36_247 VGND VGND VPWR VPWR sky130_fd_sc_hd__fill_1
XFILLER_64_589 VPWR VGND VPWR VGND sky130_ef_sc_hd__decap_12
XPHY_EDGE_ROW_48_Left_185 VGND VGND VPWR VPWR sky130_fd_sc_hd__decap_3
X_07220_ _06509_ _06510_ VGND VGND VPWR VPWR _06511_ sky130_fd_sc_hd__xnor2_1
X_07151_ _06440_ _06441_ _06438_ VGND VGND VPWR VPWR _06443_ sky130_fd_sc_hd__o21ai_1
XFILLER_133_517 VPWR VGND VPWR VGND sky130_ef_sc_hd__decap_12
X_07082_ _06373_ _06372_ VGND VGND VPWR VPWR _06374_ sky130_fd_sc_hd__nand2b_1
XFILLER_106_709 VGND VGND VPWR VPWR sky130_fd_sc_hd__decap_3
XPHY_EDGE_ROW_57_Left_194 VGND VGND VPWR VPWR sky130_fd_sc_hd__decap_3
XFILLER_87_626 VGND VGND VPWR VPWR sky130_fd_sc_hd__fill_1
XFILLER_101_447 VGND VGND VPWR VPWR sky130_fd_sc_hd__fill_1
X_07984_ _00719_ _00720_ VGND VGND VPWR VPWR _00721_ sky130_fd_sc_hd__nor2_1
X_09723_ _02279_ _02358_ _02357_ VGND VGND VPWR VPWR _02486_ sky130_fd_sc_hd__a21bo_1
X_06935_ _04697_ _04708_ _04741_ _04785_ VGND VGND VPWR VPWR _04818_ sky130_fd_sc_hd__a211o_4
XFILLER_95_670 VGND VGND VPWR VPWR sky130_fd_sc_hd__fill_2
XFILLER_74_309 VGND VGND VPWR VPWR sky130_fd_sc_hd__decap_6
XFILLER_67_361 VPWR VGND VPWR VGND sky130_ef_sc_hd__decap_12
X_06866_ _03926_ _04046_ VGND VGND VPWR VPWR _04068_ sky130_fd_sc_hd__xnor2_1
X_09654_ _02400_ _02409_ VGND VGND VPWR VPWR _02410_ sky130_fd_sc_hd__nand2b_1
XTAP_TAPCELL_ROW_2_324 VGND VPWR sky130_fd_sc_hd__tapvpwrvgnd_1
XFILLER_103_57 VGND VGND VPWR VPWR sky130_fd_sc_hd__fill_1
X_08605_ _01162_ _01330_ _01332_ VGND VGND VPWR VPWR _01334_ sky130_fd_sc_hd__nor3_2
XFILLER_55_556 VGND VGND VPWR VPWR sky130_fd_sc_hd__decap_4
X_09585_ _02330_ _02335_ VGND VGND VPWR VPWR _02336_ sky130_fd_sc_hd__xnor2_1
X_06797_ _03292_ _03303_ VGND VGND VPWR VPWR _03314_ sky130_fd_sc_hd__xor2_1
XFILLER_43_729 VPWR VGND VPWR VGND sky130_ef_sc_hd__decap_12
X_08536_ _01263_ _01262_ _01264_ VGND VGND VPWR VPWR _01265_ sky130_fd_sc_hd__or3_4
X_08467_ _01192_ _01194_ _01191_ VGND VGND VPWR VPWR _01196_ sky130_fd_sc_hd__a21oi_1
XFILLER_11_615 VGND VGND VPWR VPWR sky130_fd_sc_hd__fill_1
X_07418_ _00156_ _00157_ VGND VGND VPWR VPWR _00159_ sky130_fd_sc_hd__xnor2_1
X_08398_ _01096_ _01127_ VGND VGND VPWR VPWR _01128_ sky130_fd_sc_hd__and2_1
XFILLER_50_261 VGND VGND VPWR VPWR sky130_fd_sc_hd__fill_1
XFILLER_109_503 VGND VGND VPWR VPWR sky130_fd_sc_hd__fill_1
X_07349_ _06638_ _06639_ VGND VGND VPWR VPWR _06640_ sky130_fd_sc_hd__nand2b_1
XFILLER_136_322 VGND VGND VPWR VPWR sky130_fd_sc_hd__decap_3
XFILLER_109_547 VPWR VGND VPWR VGND sky130_ef_sc_hd__decap_12
XTAP_TAPCELL_ROW_131_2123 VGND VPWR sky130_fd_sc_hd__tapvpwrvgnd_1
X_10360_ _03175_ _03176_ VGND VGND VPWR VPWR _03177_ sky130_fd_sc_hd__and2_4
XFILLER_12_76 VGND VGND VPWR VPWR sky130_fd_sc_hd__fill_2
XFILLER_136_399 VGND VGND VPWR VPWR sky130_fd_sc_hd__decap_3
XTAP_TAPCELL_ROW_131_2134 VGND VPWR sky130_fd_sc_hd__tapvpwrvgnd_1
XFILLER_128_65 VPWR VGND VPWR VGND sky130_ef_sc_hd__decap_12
X_09019_ _01743_ _01744_ VGND VGND VPWR VPWR _01745_ sky130_fd_sc_hd__nor2_1
X_10291_ net489 net115 VGND VGND VPWR VPWR _03101_ sky130_fd_sc_hd__and2_1
XFILLER_117_591 VGND VGND VPWR VPWR sky130_fd_sc_hd__fill_2
XFILLER_88_47 VPWR VGND VPWR VGND sky130_ef_sc_hd__decap_12
X_12030_ net269 net284 _04995_ VGND VGND VPWR VPWR _04996_ sky130_fd_sc_hd__a21o_1
XFILLER_2_357 VGND VGND VPWR VPWR sky130_fd_sc_hd__decap_6
XFILLER_120_701 VPWR VGND VPWR VGND sky130_ef_sc_hd__decap_12
XFILLER_105_797 VGND VGND VPWR VPWR sky130_fd_sc_hd__decap_8
Xfanout650 net117 VGND VGND VPWR VPWR net650 sky130_fd_sc_hd__buf_2
XFILLER_120_789 VGND VGND VPWR VPWR sky130_fd_sc_hd__fill_2
Xfanout683 net101 VGND VGND VPWR VPWR net683 sky130_fd_sc_hd__dlymetal6s2s_1
XFILLER_92_106 VGND VGND VPWR VPWR sky130_fd_sc_hd__fill_1
XFILLER_77_169 VGND VGND VPWR VPWR sky130_fd_sc_hd__decap_6
Xfanout694 net697 VGND VGND VPWR VPWR net694 sky130_fd_sc_hd__buf_2
Xfanout672 net109 VGND VGND VPWR VPWR net672 sky130_fd_sc_hd__buf_2
Xfanout661 net111 VGND VGND VPWR VPWR net661 sky130_fd_sc_hd__clkbuf_2
XTAP_TAPCELL_ROW_129_2096 VGND VPWR sky130_fd_sc_hd__tapvpwrvgnd_1
X_12932_ _05971_ _05979_ VGND VGND VPWR VPWR _05981_ sky130_fd_sc_hd__xnor2_1
XFILLER_61_526 VGND VGND VPWR VPWR sky130_fd_sc_hd__decap_8
X_12863_ _05726_ _05738_ _05737_ VGND VGND VPWR VPWR _05906_ sky130_fd_sc_hd__o21ai_1
XFILLER_33_206 VGND VGND VPWR VPWR sky130_fd_sc_hd__decap_8
X_11814_ net698 net366 VGND VGND VPWR VPWR _04760_ sky130_fd_sc_hd__nand2_1
X_12794_ _05826_ _05827_ _05828_ VGND VGND VPWR VPWR _05830_ sky130_fd_sc_hd__o21ai_1
X_11745_ net641 net302 net300 net665 VGND VGND VPWR VPWR _04684_ sky130_fd_sc_hd__a22oi_1
XTAP_TAPCELL_ROW_60_1129 VGND VPWR sky130_fd_sc_hd__tapvpwrvgnd_1
XFILLER_41_272 VGND VGND VPWR VPWR sky130_fd_sc_hd__fill_2
X_13415_ clknet_3_6__leaf_clk _00055_ _00125_ VGND VGND VPWR VPWR net214 sky130_fd_sc_hd__dfrtp_1
X_11676_ _04605_ _04608_ VGND VGND VPWR VPWR _04610_ sky130_fd_sc_hd__nand2_1
X_10627_ _03290_ _03293_ _03291_ VGND VGND VPWR VPWR _03468_ sky130_fd_sc_hd__o21bai_1
XFILLER_10_670 VPWR VGND VPWR VGND sky130_ef_sc_hd__decap_12
XFILLER_127_366 VGND VGND VPWR VPWR sky130_fd_sc_hd__fill_2
X_13346_ net398 VGND VGND VPWR VPWR _00120_ sky130_fd_sc_hd__inv_2
XTAP_TAPCELL_ROW_116_1918 VGND VPWR sky130_fd_sc_hd__tapvpwrvgnd_1
X_10558_ net458 net559 VGND VGND VPWR VPWR _03392_ sky130_fd_sc_hd__nand2_1
XFILLER_115_517 VGND VGND VPWR VPWR sky130_fd_sc_hd__fill_1
X_13277_ _06167_ _06279_ _06277_ VGND VGND VPWR VPWR _06357_ sky130_fd_sc_hd__a21oi_1
XTAP_TAPCELL_ROW_75_1350 VGND VPWR sky130_fd_sc_hd__tapvpwrvgnd_1
X_10489_ _03313_ _03315_ _03161_ _03164_ VGND VGND VPWR VPWR _03317_ sky130_fd_sc_hd__a211o_1
X_12228_ _05208_ _05209_ _05042_ VGND VGND VPWR VPWR _05212_ sky130_fd_sc_hd__a21bo_1
XFILLER_123_561 VGND VGND VPWR VPWR sky130_fd_sc_hd__decap_8
XFILLER_110_222 VPWR VGND VPWR VGND sky130_ef_sc_hd__decap_12
X_12159_ _05026_ _05053_ _05051_ VGND VGND VPWR VPWR _05136_ sky130_fd_sc_hd__o21a_1
XFILLER_84_629 VGND VGND VPWR VPWR sky130_fd_sc_hd__decap_4
XFILLER_1_390 VGND VGND VPWR VPWR sky130_fd_sc_hd__fill_2
X_06720_ _02338_ _02468_ VGND VGND VPWR VPWR _02479_ sky130_fd_sc_hd__nand2_1
XFILLER_83_117 VPWR VGND VPWR VGND sky130_ef_sc_hd__decap_12
XFILLER_64_353 VGND VGND VPWR VPWR sky130_fd_sc_hd__decap_8
XFILLER_25_729 VGND VGND VPWR VPWR sky130_fd_sc_hd__fill_2
XFILLER_37_589 VPWR VGND VPWR VGND sky130_ef_sc_hd__decap_12
X_09370_ _02097_ _02101_ VGND VGND VPWR VPWR _02102_ sky130_fd_sc_hd__xnor2_1
X_08321_ _00965_ _00981_ _00983_ VGND VGND VPWR VPWR _01055_ sky130_fd_sc_hd__a21oi_1
XTAP_TAPCELL_ROW_35_779 VGND VPWR sky130_fd_sc_hd__tapvpwrvgnd_1
X_08252_ _00985_ _00986_ VGND VGND VPWR VPWR _00987_ sky130_fd_sc_hd__xnor2_1
XFILLER_32_261 VGND VGND VPWR VPWR sky130_fd_sc_hd__decap_4
X_07203_ _06493_ _06492_ _05319_ _05352_ VGND VGND VPWR VPWR _06495_ sky130_fd_sc_hd__a211oi_4
XFILLER_20_445 VGND VGND VPWR VPWR sky130_fd_sc_hd__decap_6
X_08183_ _00917_ _00918_ VGND VGND VPWR VPWR _00919_ sky130_fd_sc_hd__nand2_1
XPHY_EDGE_ROW_65_Left_202 VGND VGND VPWR VPWR sky130_fd_sc_hd__decap_3
XFILLER_106_506 VPWR VGND VPWR VGND sky130_ef_sc_hd__decap_12
X_07134_ _06418_ _06425_ VGND VGND VPWR VPWR _06426_ sky130_fd_sc_hd__nand2_1
XFILLER_133_303 VGND VGND VPWR VPWR sky130_fd_sc_hd__fill_1
X_07065_ _05079_ _06216_ _06226_ VGND VGND VPWR VPWR _06237_ sky130_fd_sc_hd__nand3_4
Xoutput220 net220 VGND VGND VPWR VPWR out3[4] sky130_fd_sc_hd__buf_2
XFILLER_101_222 VGND VGND VPWR VPWR sky130_fd_sc_hd__fill_2
XFILLER_87_434 VGND VGND VPWR VPWR sky130_fd_sc_hd__fill_2
XFILLER_59_136 VGND VGND VPWR VPWR sky130_fd_sc_hd__decap_6
X_07967_ _00701_ _00702_ VGND VGND VPWR VPWR _00705_ sky130_fd_sc_hd__xor2_1
XFILLER_101_244 VPWR VGND VPWR VGND sky130_ef_sc_hd__decap_12
XPHY_EDGE_ROW_74_Left_211 VGND VGND VPWR VPWR sky130_fd_sc_hd__decap_3
XFILLER_59_169 VGND VGND VPWR VPWR sky130_fd_sc_hd__fill_2
XFILLER_59_158 VGND VGND VPWR VPWR sky130_fd_sc_hd__decap_4
X_09706_ _02324_ _02329_ _01949_ VGND VGND VPWR VPWR _02467_ sky130_fd_sc_hd__o21ai_1
XFILLER_87_489 VGND VGND VPWR VPWR sky130_fd_sc_hd__decap_6
X_06918_ _04101_ _04621_ VGND VGND VPWR VPWR _04632_ sky130_fd_sc_hd__or2_1
XFILLER_68_681 VGND VGND VPWR VPWR sky130_fd_sc_hd__decap_8
X_07898_ _00624_ _00635_ VGND VGND VPWR VPWR _00636_ sky130_fd_sc_hd__xnor2_1
X_06849_ _03795_ _03871_ VGND VGND VPWR VPWR _03882_ sky130_fd_sc_hd__xnor2_1
XFILLER_83_673 VGND VGND VPWR VPWR sky130_fd_sc_hd__decap_3
X_09637_ _02384_ _02391_ VGND VGND VPWR VPWR _02393_ sky130_fd_sc_hd__and2_1
XFILLER_15_217 VGND VGND VPWR VPWR sky130_fd_sc_hd__decap_6
XFILLER_28_589 VGND VGND VPWR VPWR sky130_fd_sc_hd__decap_4
X_09568_ _02305_ _02315_ VGND VGND VPWR VPWR _02318_ sky130_fd_sc_hd__xnor2_2
XFILLER_43_559 VGND VGND VPWR VPWR sky130_fd_sc_hd__fill_1
XFILLER_130_77 VGND VGND VPWR VPWR sky130_fd_sc_hd__decap_6
X_08519_ _01135_ _01247_ VGND VGND VPWR VPWR _01248_ sky130_fd_sc_hd__and2_1
X_09499_ _02090_ _02242_ VGND VGND VPWR VPWR _02243_ sky130_fd_sc_hd__nor2_1
XFILLER_70_389 VPWR VGND VPWR VGND sky130_ef_sc_hd__decap_12
X_11530_ net408 _03586_ _03589_ _04343_ VGND VGND VPWR VPWR _04454_ sky130_fd_sc_hd__a2bb2o_1
XFILLER_135_3 VPWR VGND VPWR VGND sky130_ef_sc_hd__decap_12
XPHY_EDGE_ROW_83_Left_220 VGND VGND VPWR VPWR sky130_fd_sc_hd__decap_3
XFILLER_7_405 VPWR VGND VPWR VGND sky130_ef_sc_hd__decap_12
XFILLER_23_53 VGND VGND VPWR VPWR sky130_fd_sc_hd__decap_3
X_11461_ net826 _04211_ _04212_ _04213_ VGND VGND VPWR VPWR _04379_ sky130_fd_sc_hd__a22o_1
XFILLER_136_141 VPWR VGND VPWR VGND sky130_ef_sc_hd__decap_12
X_10412_ net495 net503 net653 net651 VGND VGND VPWR VPWR _03232_ sky130_fd_sc_hd__nand4_1
X_11392_ net286 net343 _02240_ net308 VGND VGND VPWR VPWR _04303_ sky130_fd_sc_hd__o2bb2a_1
X_13200_ _06166_ _06273_ VGND VGND VPWR VPWR _06274_ sky130_fd_sc_hd__nor2_1
XFILLER_99_57 VGND VGND VPWR VPWR sky130_fd_sc_hd__fill_2
X_10343_ _03154_ _03156_ _02993_ _02995_ VGND VGND VPWR VPWR _03158_ sky130_fd_sc_hd__o211a_4
X_13131_ _06164_ _06197_ VGND VGND VPWR VPWR _06199_ sky130_fd_sc_hd__xnor2_1
XFILLER_2_121 VPWR VGND VPWR VGND sky130_ef_sc_hd__decap_12
X_10274_ _02940_ _03081_ VGND VGND VPWR VPWR _03082_ sky130_fd_sc_hd__xnor2_1
X_13062_ _06121_ _06122_ VGND VGND VPWR VPWR _06123_ sky130_fd_sc_hd__nor2_1
XFILLER_2_165 VPWR VGND VPWR VGND sky130_ef_sc_hd__decap_12
XTAP_TAPCELL_ROW_111_1848 VGND VPWR sky130_fd_sc_hd__tapvpwrvgnd_1
X_12013_ _04842_ _04845_ _04841_ VGND VGND VPWR VPWR _04978_ sky130_fd_sc_hd__a21o_1
XTAP_TAPCELL_ROW_57_1091 VGND VPWR sky130_fd_sc_hd__tapvpwrvgnd_1
XFILLER_120_586 VGND VGND VPWR VPWR sky130_fd_sc_hd__fill_2
Xfanout491 net22 VGND VGND VPWR VPWR net491 sky130_fd_sc_hd__clkbuf_4
Xfanout480 net481 VGND VGND VPWR VPWR net480 sky130_fd_sc_hd__clkbuf_4
XTAP_TAPCELL_ROW_70_1280 VGND VPWR sky130_fd_sc_hd__tapvpwrvgnd_1
XFILLER_74_651 VGND VGND VPWR VPWR sky130_fd_sc_hd__decap_8
XFILLER_80_109 VPWR VGND VPWR VGND sky130_ef_sc_hd__decap_12
XFILLER_74_684 VGND VGND VPWR VPWR sky130_fd_sc_hd__fill_1
XFILLER_61_301 VGND VGND VPWR VPWR sky130_fd_sc_hd__fill_1
XFILLER_0_57 VPWR VGND VPWR VGND sky130_ef_sc_hd__decap_12
X_12915_ _05960_ _05961_ VGND VGND VPWR VPWR _05962_ sky130_fd_sc_hd__nor2_1
X_12846_ _05884_ _05885_ VGND VGND VPWR VPWR _05887_ sky130_fd_sc_hd__xor2_1
XFILLER_34_537 VGND VGND VPWR VPWR sky130_fd_sc_hd__fill_1
XFILLER_64_93 VGND VGND VPWR VPWR sky130_fd_sc_hd__decap_3
XTAP_TAPCELL_ROW_122_1999 VGND VPWR sky130_fd_sc_hd__tapvpwrvgnd_1
X_12777_ _05810_ _05811_ VGND VGND VPWR VPWR _05813_ sky130_fd_sc_hd__xor2_1
XTAP_TAPCELL_ROW_32_738 VGND VPWR sky130_fd_sc_hd__tapvpwrvgnd_1
X_11728_ net529 net674 net672 net536 VGND VGND VPWR VPWR _04666_ sky130_fd_sc_hd__a22oi_1
XFILLER_9_88 VGND VGND VPWR VPWR sky130_fd_sc_hd__decap_3
XTAP_TAPCELL_ROW_32_749 VGND VPWR sky130_fd_sc_hd__tapvpwrvgnd_1
XFILLER_128_620 VPWR VGND VPWR VGND sky130_ef_sc_hd__decap_12
XPHY_EDGE_ROW_104_Right_104 VGND VGND VPWR VPWR sky130_fd_sc_hd__decap_3
XFILLER_80_81 VGND VGND VPWR VPWR sky130_fd_sc_hd__decap_3
X_11659_ net471 net598 VGND VGND VPWR VPWR _04592_ sky130_fd_sc_hd__nand2_1
XTAP_TAPCELL_ROW_12_462 VGND VPWR sky130_fd_sc_hd__tapvpwrvgnd_1
XFILLER_30_787 VPWR VGND VPWR VGND sky130_ef_sc_hd__decap_12
X_13329_ net392 VGND VGND VPWR VPWR _00103_ sky130_fd_sc_hd__inv_2
XFILLER_88_209 VGND VGND VPWR VPWR sky130_fd_sc_hd__decap_6
X_08870_ net670 net255 net254 net693 VGND VGND VPWR VPWR _01596_ sky130_fd_sc_hd__a22o_1
XFILLER_123_391 VGND VGND VPWR VPWR sky130_fd_sc_hd__fill_1
XFILLER_123_380 VGND VGND VPWR VPWR sky130_fd_sc_hd__decap_4
XFILLER_69_412 VGND VGND VPWR VPWR sky130_fd_sc_hd__decap_8
X_07821_ _00475_ _00559_ VGND VGND VPWR VPWR _00560_ sky130_fd_sc_hd__xnor2_1
XFILLER_29_309 VGND VGND VPWR VPWR sky130_fd_sc_hd__fill_2
XFILLER_84_415 VGND VGND VPWR VPWR sky130_fd_sc_hd__decap_4
XFILLER_38_810 VGND VGND VPWR VPWR sky130_fd_sc_hd__fill_1
X_07752_ _00488_ _00489_ VGND VGND VPWR VPWR _00491_ sky130_fd_sc_hd__xor2_1
XTAP_TAPCELL_ROW_88_1530 VGND VPWR sky130_fd_sc_hd__tapvpwrvgnd_1
X_07683_ _00421_ _00420_ _00285_ VGND VGND VPWR VPWR _00423_ sky130_fd_sc_hd__a21o_1
XFILLER_65_673 VGND VGND VPWR VPWR sky130_fd_sc_hd__decap_4
XFILLER_64_150 VGND VGND VPWR VPWR sky130_fd_sc_hd__decap_4
X_06703_ net145 VGND VGND VPWR VPWR _02295_ sky130_fd_sc_hd__inv_2
X_09422_ _02146_ _02158_ VGND VGND VPWR VPWR _02159_ sky130_fd_sc_hd__xor2_1
XFILLER_25_559 VGND VGND VPWR VPWR sky130_fd_sc_hd__fill_1
X_09353_ _01962_ _01964_ _02082_ VGND VGND VPWR VPWR _02083_ sky130_fd_sc_hd__a21oi_2
XFILLER_80_654 VGND VGND VPWR VPWR sky130_fd_sc_hd__decap_4
XFILLER_12_209 VGND VGND VPWR VPWR sky130_fd_sc_hd__decap_4
X_08304_ _01018_ _01019_ _01025_ VGND VGND VPWR VPWR _01038_ sky130_fd_sc_hd__o21ai_1
XFILLER_100_36 VGND VGND VPWR VPWR sky130_fd_sc_hd__decap_8
X_09284_ net555 net553 net406 VGND VGND VPWR VPWR _02008_ sky130_fd_sc_hd__o21ai_1
XFILLER_33_592 VGND VGND VPWR VPWR sky130_fd_sc_hd__decap_6
X_08235_ _02164_ net402 _06561_ VGND VGND VPWR VPWR _00970_ sky130_fd_sc_hd__or3_1
XFILLER_21_776 VGND VGND VPWR VPWR sky130_fd_sc_hd__decap_8
X_08166_ _00900_ _00901_ VGND VGND VPWR VPWR _00902_ sky130_fd_sc_hd__nor2_1
XTAP_TAPCELL_ROW_99_1681 VGND VPWR sky130_fd_sc_hd__tapvpwrvgnd_1
XFILLER_134_601 VPWR VGND VPWR VGND sky130_ef_sc_hd__decap_12
XFILLER_109_34 VGND VGND VPWR VPWR sky130_fd_sc_hd__decap_3
X_07117_ net497 net682 VGND VGND VPWR VPWR _06409_ sky130_fd_sc_hd__nand2_1
XFILLER_4_419 VGND VGND VPWR VPWR sky130_fd_sc_hd__fill_1
XFILLER_134_645 VPWR VGND VPWR VGND sky130_ef_sc_hd__decap_12
XFILLER_133_111 VGND VGND VPWR VPWR sky130_fd_sc_hd__fill_1
XFILLER_106_336 VGND VGND VPWR VPWR sky130_fd_sc_hd__fill_1
X_08097_ net381 _00618_ _00616_ VGND VGND VPWR VPWR _00833_ sky130_fd_sc_hd__a21o_1
X_07048_ _06008_ _05822_ _06030_ VGND VGND VPWR VPWR _06052_ sky130_fd_sc_hd__or3_4
XFILLER_102_531 VGND VGND VPWR VPWR sky130_fd_sc_hd__fill_1
XFILLER_125_55 VGND VGND VPWR VPWR sky130_fd_sc_hd__fill_1
XFILLER_88_776 VGND VGND VPWR VPWR sky130_fd_sc_hd__decap_4
XFILLER_88_765 VGND VGND VPWR VPWR sky130_fd_sc_hd__decap_4
XFILLER_87_242 VGND VGND VPWR VPWR sky130_fd_sc_hd__decap_8
XFILLER_0_669 VGND VGND VPWR VPWR sky130_fd_sc_hd__decap_3
XFILLER_102_586 VGND VGND VPWR VPWR sky130_fd_sc_hd__fill_2
XFILLER_85_48 VGND VGND VPWR VPWR sky130_fd_sc_hd__fill_1
X_08999_ _01722_ _01723_ VGND VGND VPWR VPWR _01725_ sky130_fd_sc_hd__xnor2_1
XTAP_TAPCELL_ROW_126_2055 VGND VPWR sky130_fd_sc_hd__tapvpwrvgnd_1
XFILLER_18_64 VGND VGND VPWR VPWR sky130_fd_sc_hd__decap_3
X_10961_ _03654_ _03656_ _03831_ _03832_ VGND VGND VPWR VPWR _03833_ sky130_fd_sc_hd__o211ai_2
XFILLER_83_481 VPWR VGND VPWR VGND sky130_ef_sc_hd__decap_12
XFILLER_18_97 VGND VGND VPWR VPWR sky130_fd_sc_hd__decap_8
X_12700_ _05584_ _05587_ VGND VGND VPWR VPWR _05728_ sky130_fd_sc_hd__nor2_1
X_12631_ _05650_ _05651_ _05476_ _05478_ VGND VGND VPWR VPWR _05653_ sky130_fd_sc_hd__a211o_1
XFILLER_31_518 VGND VGND VPWR VPWR sky130_fd_sc_hd__decap_4
X_10892_ net495 net649 _03574_ _03573_ VGND VGND VPWR VPWR _03757_ sky130_fd_sc_hd__a31o_1
XFILLER_70_175 VGND VGND VPWR VPWR sky130_fd_sc_hd__fill_1
XFILLER_34_63 VGND VGND VPWR VPWR sky130_fd_sc_hd__decap_4
XFILLER_70_197 VPWR VGND VPWR VGND sky130_ef_sc_hd__decap_12
XFILLER_34_85 VGND VGND VPWR VPWR sky130_fd_sc_hd__decap_8
X_12562_ _05544_ _05576_ VGND VGND VPWR VPWR _05577_ sky130_fd_sc_hd__and2b_1
X_11513_ _04321_ _04434_ VGND VGND VPWR VPWR _04435_ sky130_fd_sc_hd__and2b_1
XFILLER_8_725 VPWR VGND VPWR VGND sky130_ef_sc_hd__decap_12
X_12493_ net617 net293 VGND VGND VPWR VPWR _05501_ sky130_fd_sc_hd__nand2_1
XFILLER_8_769 VPWR VGND VPWR VGND sky130_ef_sc_hd__decap_12
X_11444_ _04359_ _04358_ VGND VGND VPWR VPWR _04360_ sky130_fd_sc_hd__nand2b_1
XTAP_TAPCELL_ROW_59_1120 VGND VPWR sky130_fd_sc_hd__tapvpwrvgnd_1
XFILLER_7_279 VGND VGND VPWR VPWR sky130_fd_sc_hd__fill_1
X_11375_ _03863_ _04155_ _04154_ VGND VGND VPWR VPWR _04285_ sky130_fd_sc_hd__a21oi_1
XFILLER_98_507 VGND VGND VPWR VPWR sky130_fd_sc_hd__decap_3
X_10326_ net332 net354 net352 net351 VGND VGND VPWR VPWR _03139_ sky130_fd_sc_hd__and4_1
XFILLER_3_441 VGND VGND VPWR VPWR sky130_fd_sc_hd__decap_6
X_13114_ net486 _06011_ _06012_ _06013_ VGND VGND VPWR VPWR _06180_ sky130_fd_sc_hd__a22oi_2
X_10257_ _03061_ _03062_ VGND VGND VPWR VPWR _03064_ sky130_fd_sc_hd__xnor2_1
X_13045_ _05226_ _06103_ VGND VGND VPWR VPWR _06104_ sky130_fd_sc_hd__xnor2_1
XFILLER_3_485 VPWR VGND VPWR VGND sky130_ef_sc_hd__decap_12
XFILLER_78_253 VPWR VGND VPWR VGND sky130_ef_sc_hd__decap_12
X_10188_ _02986_ _02980_ _02988_ VGND VGND VPWR VPWR _02989_ sky130_fd_sc_hd__and3_1
XFILLER_93_245 VPWR VGND VPWR VGND sky130_ef_sc_hd__decap_12
XFILLER_93_223 VGND VGND VPWR VPWR sky130_fd_sc_hd__fill_1
XFILLER_93_278 VGND VGND VPWR VPWR sky130_fd_sc_hd__fill_2
XFILLER_47_673 VPWR VGND VPWR VGND sky130_ef_sc_hd__decap_12
XTAP_TAPCELL_ROW_37_808 VGND VPWR sky130_fd_sc_hd__tapvpwrvgnd_1
XTAP_TAPCELL_ROW_37_819 VGND VPWR sky130_fd_sc_hd__tapvpwrvgnd_1
XFILLER_74_470 VGND VGND VPWR VPWR sky130_fd_sc_hd__fill_2
XFILLER_62_643 VGND VGND VPWR VPWR sky130_fd_sc_hd__fill_1
XTAP_TAPCELL_ROW_17_532 VGND VPWR sky130_fd_sc_hd__tapvpwrvgnd_1
XFILLER_98_3 VPWR VGND VPWR VGND sky130_ef_sc_hd__decap_12
XTAP_TAPCELL_ROW_83_1460 VGND VPWR sky130_fd_sc_hd__tapvpwrvgnd_1
XFILLER_15_581 VPWR VGND VPWR VGND sky130_ef_sc_hd__decap_12
X_12829_ _05745_ _05868_ VGND VGND VPWR VPWR _05869_ sky130_fd_sc_hd__xor2_1
X_08020_ _00750_ _00755_ VGND VGND VPWR VPWR _00757_ sky130_fd_sc_hd__xnor2_1
XFILLER_131_615 VGND VGND VPWR VPWR sky130_fd_sc_hd__fill_1
X_09971_ _02751_ _02754_ VGND VGND VPWR VPWR _02755_ sky130_fd_sc_hd__xnor2_1
XFILLER_115_188 VGND VGND VPWR VPWR sky130_fd_sc_hd__fill_2
X_08922_ _01645_ _01646_ VGND VGND VPWR VPWR _01648_ sky130_fd_sc_hd__xnor2_1
X_08853_ _01577_ _01576_ _01439_ net708 VGND VGND VPWR VPWR _01580_ sky130_fd_sc_hd__a211o_1
X_08784_ net510 net493 net634 _01221_ VGND VGND VPWR VPWR _01511_ sky130_fd_sc_hd__o211a_1
X_07804_ net607 net403 VGND VGND VPWR VPWR _00543_ sky130_fd_sc_hd__nand2_1
XFILLER_38_640 VGND VGND VPWR VPWR sky130_fd_sc_hd__decap_4
X_07735_ _00438_ _00473_ VGND VGND VPWR VPWR _00474_ sky130_fd_sc_hd__nand2b_1
XFILLER_84_278 VPWR VGND VPWR VGND sky130_ef_sc_hd__decap_12
XFILLER_55_29 VGND VGND VPWR VPWR sky130_fd_sc_hd__fill_2
XFILLER_44_109 VPWR VGND VPWR VGND sky130_ef_sc_hd__decap_12
XFILLER_37_150 VPWR VGND VPWR VGND sky130_ef_sc_hd__decap_12
XFILLER_38_662 VGND VGND VPWR VPWR sky130_fd_sc_hd__fill_1
XFILLER_25_301 VGND VGND VPWR VPWR sky130_fd_sc_hd__fill_2
XFILLER_25_323 VPWR VGND VPWR VGND sky130_ef_sc_hd__decap_12
X_09405_ net488 net628 _01974_ _02137_ VGND VGND VPWR VPWR _02140_ sky130_fd_sc_hd__nand4_2
X_07666_ _00393_ _00394_ _00404_ VGND VGND VPWR VPWR _00406_ sky130_fd_sc_hd__nand3_1
XFILLER_111_57 VPWR VGND VPWR VGND sky130_ef_sc_hd__decap_12
X_07597_ net681 net490 _00335_ _00336_ VGND VGND VPWR VPWR _00337_ sky130_fd_sc_hd__a22o_1
XFILLER_71_28 VGND VGND VPWR VPWR sky130_fd_sc_hd__decap_8
XFILLER_25_378 VPWR VGND VPWR VGND sky130_ef_sc_hd__decap_12
X_09336_ _01898_ _01900_ _02063_ _02064_ VGND VGND VPWR VPWR _02065_ sky130_fd_sc_hd__o211ai_2
X_09267_ _01984_ _01990_ VGND VGND VPWR VPWR _01991_ sky130_fd_sc_hd__xor2_1
XFILLER_21_573 VPWR VGND VPWR VGND sky130_ef_sc_hd__decap_12
X_08218_ _00546_ _00851_ VGND VGND VPWR VPWR _00953_ sky130_fd_sc_hd__nand2_1
XFILLER_119_461 VGND VGND VPWR VPWR sky130_fd_sc_hd__decap_6
X_09198_ _01758_ _01921_ VGND VGND VPWR VPWR _01922_ sky130_fd_sc_hd__xor2_1
XFILLER_107_634 VPWR VGND VPWR VGND sky130_ef_sc_hd__decap_12
XFILLER_106_122 VPWR VGND VPWR VGND sky130_ef_sc_hd__decap_12
XFILLER_106_111 VGND VGND VPWR VPWR sky130_fd_sc_hd__decap_4
X_08149_ _00861_ _00884_ VGND VGND VPWR VPWR _00885_ sky130_fd_sc_hd__xor2_2
XFILLER_134_475 VGND VGND VPWR VPWR sky130_fd_sc_hd__fill_1
X_11160_ _04049_ net247 VGND VGND VPWR VPWR _04050_ sky130_fd_sc_hd__nand2b_1
X_10111_ _02903_ _02902_ VGND VGND VPWR VPWR _02904_ sky130_fd_sc_hd__and2b_1
X_11091_ _03973_ _03974_ VGND VGND VPWR VPWR _03975_ sky130_fd_sc_hd__nor2_1
XFILLER_121_147 VGND VGND VPWR VPWR sky130_fd_sc_hd__decap_3
XFILLER_88_551 VPWR VGND VPWR VGND sky130_ef_sc_hd__decap_12
X_10042_ net453 net579 VGND VGND VPWR VPWR _02829_ sky130_fd_sc_hd__nand2_1
XTAP_TAPCELL_ROW_54_1050 VGND VPWR sky130_fd_sc_hd__tapvpwrvgnd_1
XFILLER_130_681 VPWR VGND VPWR VGND sky130_ef_sc_hd__decap_12
XFILLER_121_169 VPWR VGND VPWR VGND sky130_ef_sc_hd__decap_12
XFILLER_0_477 VGND VGND VPWR VPWR sky130_fd_sc_hd__fill_2
XFILLER_102_383 VGND VGND VPWR VPWR sky130_fd_sc_hd__fill_2
XFILLER_76_757 VPWR VGND VPWR VGND sky130_ef_sc_hd__decap_12
XFILLER_76_746 VGND VGND VPWR VPWR sky130_fd_sc_hd__decap_8
XFILLER_75_223 VGND VGND VPWR VPWR sky130_fd_sc_hd__fill_1
XFILLER_29_85 VGND VGND VPWR VPWR sky130_fd_sc_hd__fill_1
XFILLER_29_640 VPWR VGND VPWR VGND sky130_ef_sc_hd__decap_12
XFILLER_29_673 VGND VGND VPWR VPWR sky130_fd_sc_hd__decap_6
XFILLER_91_749 VGND VGND VPWR VPWR sky130_fd_sc_hd__fill_2
XFILLER_90_226 VGND VGND VPWR VPWR sky130_fd_sc_hd__fill_1
X_11993_ net715 _04953_ _04932_ VGND VGND VPWR VPWR _04956_ sky130_fd_sc_hd__o21a_4
XFILLER_90_248 VGND VGND VPWR VPWR sky130_fd_sc_hd__decap_4
XFILLER_44_643 VGND VGND VPWR VPWR sky130_fd_sc_hd__fill_1
XFILLER_43_142 VGND VGND VPWR VPWR sky130_fd_sc_hd__decap_8
XFILLER_43_131 VGND VGND VPWR VPWR sky130_fd_sc_hd__decap_4
XFILLER_43_120 VGND VGND VPWR VPWR sky130_fd_sc_hd__decap_6
XPHY_EDGE_ROW_11_Left_148 VGND VGND VPWR VPWR sky130_fd_sc_hd__decap_3
X_10944_ _03805_ _03812_ _03813_ VGND VGND VPWR VPWR _03814_ sky130_fd_sc_hd__nand3_1
XFILLER_71_473 VGND VGND VPWR VPWR sky130_fd_sc_hd__fill_2
XFILLER_45_95 VGND VGND VPWR VPWR sky130_fd_sc_hd__decap_8
XFILLER_44_698 VGND VGND VPWR VPWR sky130_fd_sc_hd__fill_2
XFILLER_16_389 VGND VGND VPWR VPWR sky130_fd_sc_hd__fill_2
X_10875_ _03698_ _03737_ VGND VGND VPWR VPWR _03738_ sky130_fd_sc_hd__nand2_1
XFILLER_31_337 VGND VGND VPWR VPWR sky130_fd_sc_hd__fill_2
X_12614_ _05453_ _05455_ _05632_ _05633_ VGND VGND VPWR VPWR _05634_ sky130_fd_sc_hd__o211ai_2
XFILLER_129_225 VPWR VGND VPWR VGND sky130_ef_sc_hd__decap_12
X_12545_ _05555_ _05556_ _05557_ VGND VGND VPWR VPWR _05558_ sky130_fd_sc_hd__and3_1
XTAP_TAPCELL_ROW_42_877 VGND VPWR sky130_fd_sc_hd__tapvpwrvgnd_1
XTAP_TAPCELL_ROW_42_888 VGND VPWR sky130_fd_sc_hd__tapvpwrvgnd_1
XFILLER_8_533 VGND VGND VPWR VPWR sky130_fd_sc_hd__decap_8
X_12476_ _05480_ _05481_ _05132_ VGND VGND VPWR VPWR _05483_ sky130_fd_sc_hd__o21a_1
X_11427_ net408 net559 _04192_ _04096_ VGND VGND VPWR VPWR _04342_ sky130_fd_sc_hd__a31o_1
XPHY_EDGE_ROW_20_Left_157 VGND VGND VPWR VPWR sky130_fd_sc_hd__decap_3
XANTENNA_5 _02087_ VGND VGND VPWR VPWR sky130_fd_sc_hd__diode_2
X_11358_ _04264_ _04266_ VGND VGND VPWR VPWR _04267_ sky130_fd_sc_hd__nand2b_1
XFILLER_112_125 VGND VGND VPWR VPWR sky130_fd_sc_hd__decap_4
X_10309_ _03117_ _03119_ _03116_ VGND VGND VPWR VPWR _03121_ sky130_fd_sc_hd__o21ai_1
XFILLER_113_659 VGND VGND VPWR VPWR sky130_fd_sc_hd__decap_4
XFILLER_79_540 VGND VGND VPWR VPWR sky130_fd_sc_hd__fill_1
XFILLER_3_293 VPWR VGND VPWR VGND sky130_ef_sc_hd__decap_12
X_11289_ net563 net561 net400 VGND VGND VPWR VPWR _04191_ sky130_fd_sc_hd__o21ai_1
XFILLER_121_670 VGND VGND VPWR VPWR sky130_fd_sc_hd__fill_2
XFILLER_100_309 VPWR VGND VPWR VGND sky130_ef_sc_hd__decap_12
X_13028_ _05663_ _05953_ _05952_ VGND VGND VPWR VPWR _06087_ sky130_fd_sc_hd__a21oi_1
XFILLER_13_3 VPWR VGND VPWR VGND sky130_ef_sc_hd__decap_12
Xrebuffer17 _04812_ VGND VGND VPWR VPWR net717 sky130_fd_sc_hd__buf_6
X_07520_ _06642_ _06640_ _00259_ _00260_ VGND VGND VPWR VPWR _00261_ sky130_fd_sc_hd__a211o_4
XFILLER_81_237 VPWR VGND VPWR VGND sky130_ef_sc_hd__decap_12
Xrebuffer39 net782 VGND VGND VPWR VPWR net739 sky130_fd_sc_hd__clkbuf_1
Xrebuffer28 _04782_ VGND VGND VPWR VPWR net728 sky130_fd_sc_hd__dlymetal6s2s_1
XFILLER_90_760 VGND VGND VPWR VPWR sky130_fd_sc_hd__decap_8
XFILLER_19_194 VPWR VGND VPWR VGND sky130_ef_sc_hd__decap_12
XFILLER_35_643 VGND VGND VPWR VPWR sky130_fd_sc_hd__fill_1
X_07451_ _06572_ _06574_ VGND VGND VPWR VPWR _00192_ sky130_fd_sc_hd__and2_1
XFILLER_22_304 VGND VGND VPWR VPWR sky130_fd_sc_hd__decap_4
XFILLER_22_315 VPWR VGND VPWR VGND sky130_ef_sc_hd__decap_12
X_07382_ net687 net668 net304 net73 VGND VGND VPWR VPWR _06672_ sky130_fd_sc_hd__and4b_1
XFILLER_62_495 VPWR VGND VPWR VGND sky130_ef_sc_hd__decap_12
XFILLER_34_197 VPWR VGND VPWR VGND sky130_ef_sc_hd__decap_12
X_09121_ net422 net552 _01844_ _01845_ VGND VGND VPWR VPWR _01846_ sky130_fd_sc_hd__a22o_1
Xrebuffer118 net333 VGND VGND VPWR VPWR net818 sky130_fd_sc_hd__buf_8
XFILLER_135_217 VGND VGND VPWR VPWR sky130_fd_sc_hd__decap_6
X_09052_ _01760_ _01776_ VGND VGND VPWR VPWR _01777_ sky130_fd_sc_hd__xnor2_1
XTAP_TAPCELL_ROW_96_1640 VGND VPWR sky130_fd_sc_hd__tapvpwrvgnd_1
X_08003_ _00644_ _00739_ VGND VGND VPWR VPWR _00740_ sky130_fd_sc_hd__xor2_1
Xmax_cap241 _01432_ VGND VGND VPWR VPWR net241 sky130_fd_sc_hd__clkbuf_2
Xmax_cap230 _03029_ VGND VGND VPWR VPWR net230 sky130_fd_sc_hd__buf_1
XFILLER_116_475 VGND VGND VPWR VPWR sky130_fd_sc_hd__fill_1
XFILLER_89_337 VGND VGND VPWR VPWR sky130_fd_sc_hd__decap_4
X_09954_ _02734_ _02735_ VGND VGND VPWR VPWR _02736_ sky130_fd_sc_hd__xnor2_1
X_08905_ _01629_ _01630_ VGND VGND VPWR VPWR _01631_ sky130_fd_sc_hd__nand2_1
XFILLER_106_68 VPWR VGND VPWR VGND sky130_ef_sc_hd__decap_12
X_09885_ _02660_ _02661_ VGND VGND VPWR VPWR _02662_ sky130_fd_sc_hd__xnor2_1
X_08836_ _01559_ _01560_ _01561_ VGND VGND VPWR VPWR _01563_ sky130_fd_sc_hd__a21o_1
XFILLER_85_576 VGND VGND VPWR VPWR sky130_fd_sc_hd__decap_4
XFILLER_73_727 VGND VGND VPWR VPWR sky130_fd_sc_hd__fill_1
XTAP_TAPCELL_ROW_123_2014 VGND VPWR sky130_fd_sc_hd__tapvpwrvgnd_1
X_08767_ _01367_ _01491_ _01493_ VGND VGND VPWR VPWR _01494_ sky130_fd_sc_hd__o21a_1
XFILLER_38_470 VGND VGND VPWR VPWR sky130_fd_sc_hd__decap_6
X_07718_ _00332_ _00341_ _00340_ VGND VGND VPWR VPWR _00457_ sky130_fd_sc_hd__a21oi_1
X_08698_ _01421_ _01422_ _01423_ VGND VGND VPWR VPWR _01426_ sky130_fd_sc_hd__a21oi_1
XFILLER_26_643 VGND VGND VPWR VPWR sky130_fd_sc_hd__fill_1
XFILLER_81_782 VGND VGND VPWR VPWR sky130_fd_sc_hd__fill_2
X_07649_ _00385_ _00384_ _00386_ VGND VGND VPWR VPWR _00389_ sky130_fd_sc_hd__a21o_1
XTAP_TAPCELL_ROW_0_274 VGND VPWR sky130_fd_sc_hd__tapvpwrvgnd_1
XTAP_TAPCELL_ROW_0_285 VGND VPWR sky130_fd_sc_hd__tapvpwrvgnd_1
XTAP_TAPCELL_ROW_0_296 VGND VPWR sky130_fd_sc_hd__tapvpwrvgnd_1
XFILLER_15_21 VPWR VGND VPWR VGND sky130_ef_sc_hd__decap_12
X_10660_ _03324_ _03503_ VGND VGND VPWR VPWR _03504_ sky130_fd_sc_hd__nor2_1
XFILLER_15_65 VGND VGND VPWR VPWR sky130_fd_sc_hd__decap_3
X_09319_ _02040_ _02046_ VGND VGND VPWR VPWR _02047_ sky130_fd_sc_hd__and2b_1
X_10591_ net409 net401 net580 net577 VGND VGND VPWR VPWR _03428_ sky130_fd_sc_hd__and4_1
XFILLER_127_729 VPWR VGND VPWR VGND sky130_ef_sc_hd__decap_12
XFILLER_5_503 VGND VGND VPWR VPWR sky130_fd_sc_hd__fill_1
XFILLER_31_31 VGND VGND VPWR VPWR sky130_fd_sc_hd__decap_4
X_12330_ _05321_ _05322_ VGND VGND VPWR VPWR _05323_ sky130_fd_sc_hd__and2b_1
XTAP_TAPCELL_ROW_134_2176 VGND VPWR sky130_fd_sc_hd__tapvpwrvgnd_1
XTAP_TAPCELL_ROW_134_2165 VGND VPWR sky130_fd_sc_hd__tapvpwrvgnd_1
XFILLER_31_86 VGND VGND VPWR VPWR sky130_fd_sc_hd__fill_1
X_12261_ net516 net363 _05086_ _05085_ VGND VGND VPWR VPWR _05248_ sky130_fd_sc_hd__a31o_1
X_11212_ _04105_ _04106_ VGND VGND VPWR VPWR _04107_ sky130_fd_sc_hd__xnor2_1
X_12192_ _05162_ _05170_ VGND VGND VPWR VPWR _05172_ sky130_fd_sc_hd__xnor2_1
XFILLER_1_753 VPWR VGND VPWR VGND sky130_ef_sc_hd__decap_12
X_11143_ _03868_ _03873_ _03870_ VGND VGND VPWR VPWR _04031_ sky130_fd_sc_hd__o21ba_1
Xinput120 w22[6] VGND VGND VPWR VPWR net120 sky130_fd_sc_hd__buf_1
X_11074_ net753 net344 _03802_ _03801_ VGND VGND VPWR VPWR _03956_ sky130_fd_sc_hd__a31o_1
Xinput131 w30[1] VGND VGND VPWR VPWR net131 sky130_fd_sc_hd__clkbuf_1
X_10025_ _02809_ _02810_ VGND VGND VPWR VPWR _02811_ sky130_fd_sc_hd__nand2_1
Xinput142 w31[4] VGND VGND VPWR VPWR net142 sky130_fd_sc_hd__buf_1
XFILLER_1_797 VPWR VGND VPWR VGND sky130_ef_sc_hd__decap_12
Xinput153 w32[7] VGND VGND VPWR VPWR net153 sky130_fd_sc_hd__buf_2
XTAP_TAPCELL_ROW_108_1809 VGND VPWR sky130_fd_sc_hd__tapvpwrvgnd_1
XFILLER_76_587 VGND VGND VPWR VPWR sky130_fd_sc_hd__fill_1
XFILLER_64_716 VPWR VGND VPWR VGND sky130_ef_sc_hd__decap_12
XFILLER_63_237 VGND VGND VPWR VPWR sky130_fd_sc_hd__decap_4
XTAP_TAPCELL_ROW_47_947 VGND VPWR sky130_fd_sc_hd__tapvpwrvgnd_1
XTAP_TAPCELL_ROW_67_1230 VGND VPWR sky130_fd_sc_hd__tapvpwrvgnd_1
XTAP_TAPCELL_ROW_47_958 VGND VPWR sky130_fd_sc_hd__tapvpwrvgnd_1
X_11976_ _04933_ _04936_ VGND VGND VPWR VPWR _04937_ sky130_fd_sc_hd__xnor2_1
XFILLER_16_153 VGND VGND VPWR VPWR sky130_fd_sc_hd__decap_8
XTAP_TAPCELL_ROW_27_671 VGND VPWR sky130_fd_sc_hd__tapvpwrvgnd_1
X_10927_ _03792_ _03793_ VGND VGND VPWR VPWR _03796_ sky130_fd_sc_hd__xnor2_1
XFILLER_72_60 VPWR VGND VPWR VGND sky130_ef_sc_hd__decap_12
XFILLER_16_197 VGND VGND VPWR VPWR sky130_fd_sc_hd__decap_8
XFILLER_31_167 VGND VGND VPWR VPWR sky130_fd_sc_hd__fill_1
X_10858_ _03572_ _03581_ _03580_ VGND VGND VPWR VPWR _03720_ sky130_fd_sc_hd__a21oi_1
XFILLER_12_370 VPWR VGND VPWR VGND sky130_ef_sc_hd__decap_12
X_10789_ net331 net348 net346 net356 VGND VGND VPWR VPWR _03645_ sky130_fd_sc_hd__a22o_1
XFILLER_8_363 VGND VGND VPWR VPWR sky130_fd_sc_hd__fill_1
X_12528_ _05497_ _05537_ VGND VGND VPWR VPWR _05540_ sky130_fd_sc_hd__xnor2_1
X_12459_ net233 _05461_ _05278_ _05280_ VGND VGND VPWR VPWR _05465_ sky130_fd_sc_hd__o211ai_2
XTAP_TAPCELL_ROW_78_1381 VGND VPWR sky130_fd_sc_hd__tapvpwrvgnd_1
XFILLER_125_261 VGND VGND VPWR VPWR sky130_fd_sc_hd__fill_1
XTAP_TAPCELL_ROW_78_1392 VGND VPWR sky130_fd_sc_hd__tapvpwrvgnd_1
Xfanout309 net311 VGND VGND VPWR VPWR net309 sky130_fd_sc_hd__buf_2
X_06951_ _04949_ _04982_ VGND VGND VPWR VPWR _04992_ sky130_fd_sc_hd__nand2b_1
XTAP_TAPCELL_ROW_91_1570 VGND VPWR sky130_fd_sc_hd__tapvpwrvgnd_1
XFILLER_100_139 VGND VGND VPWR VPWR sky130_fd_sc_hd__fill_1
X_09670_ _01824_ _02341_ net438 _01822_ VGND VGND VPWR VPWR _02428_ sky130_fd_sc_hd__o2bb2a_1
XFILLER_39_223 VGND VGND VPWR VPWR sky130_fd_sc_hd__fill_1
X_08621_ net622 net596 net264 net262 VGND VGND VPWR VPWR _01349_ sky130_fd_sc_hd__and4_1
X_06882_ _04210_ _04221_ _04199_ VGND VGND VPWR VPWR _04243_ sky130_fd_sc_hd__a21o_1
XFILLER_55_727 VGND VGND VPWR VPWR sky130_fd_sc_hd__fill_1
XFILLER_39_278 VGND VGND VPWR VPWR sky130_fd_sc_hd__fill_2
X_08552_ net724 _01274_ _01253_ VGND VGND VPWR VPWR _01281_ sky130_fd_sc_hd__o21ai_1
X_08483_ net530 net523 net632 net630 VGND VGND VPWR VPWR _01212_ sky130_fd_sc_hd__and4_1
X_07503_ _06621_ _06627_ _06626_ VGND VGND VPWR VPWR _00244_ sky130_fd_sc_hd__a21o_1
X_07434_ net497 net681 VGND VGND VPWR VPWR _00175_ sky130_fd_sc_hd__nand2_1
XFILLER_50_421 VGND VGND VPWR VPWR sky130_fd_sc_hd__decap_8
XFILLER_50_410 VGND VGND VPWR VPWR sky130_fd_sc_hd__decap_8
XFILLER_23_635 VGND VGND VPWR VPWR sky130_fd_sc_hd__decap_4
XFILLER_23_657 VPWR VGND VPWR VGND sky130_ef_sc_hd__decap_12
X_07365_ _06654_ _06655_ VGND VGND VPWR VPWR _06656_ sky130_fd_sc_hd__nor2_1
XFILLER_109_729 VGND VGND VPWR VPWR sky130_fd_sc_hd__decap_3
X_09104_ _01819_ _01828_ VGND VGND VPWR VPWR _01829_ sky130_fd_sc_hd__xor2_1
X_07296_ net614 net402 VGND VGND VPWR VPWR _06587_ sky130_fd_sc_hd__and2_2
X_09035_ _01758_ _01759_ VGND VGND VPWR VPWR _01760_ sky130_fd_sc_hd__or2_1
XFILLER_108_228 VPWR VGND VPWR VGND sky130_ef_sc_hd__decap_12
XFILLER_116_250 VGND VGND VPWR VPWR sky130_fd_sc_hd__fill_2
XFILLER_131_231 VGND VGND VPWR VPWR sky130_fd_sc_hd__fill_1
XFILLER_89_134 VGND VGND VPWR VPWR sky130_fd_sc_hd__decap_3
XFILLER_131_264 VGND VGND VPWR VPWR sky130_fd_sc_hd__fill_1
X_09937_ _02613_ _02618_ _02612_ VGND VGND VPWR VPWR _02719_ sky130_fd_sc_hd__a21oi_1
XFILLER_77_38 VGND VGND VPWR VPWR sky130_fd_sc_hd__fill_1
XFILLER_58_521 VGND VGND VPWR VPWR sky130_fd_sc_hd__decap_8
XFILLER_133_55 VGND VGND VPWR VPWR sky130_fd_sc_hd__fill_1
XFILLER_93_15 VGND VGND VPWR VPWR sky130_fd_sc_hd__decap_3
X_09868_ _02637_ _02643_ VGND VGND VPWR VPWR _02644_ sky130_fd_sc_hd__and2b_1
XTAP_TAPCELL_ROW_5_366 VGND VPWR sky130_fd_sc_hd__tapvpwrvgnd_1
XFILLER_100_684 VPWR VGND VPWR VGND sky130_ef_sc_hd__decap_12
X_09799_ _02543_ _02567_ VGND VGND VPWR VPWR _02569_ sky130_fd_sc_hd__xnor2_1
XFILLER_93_37 VGND VGND VPWR VPWR sky130_fd_sc_hd__decap_6
X_08819_ net517 net326 VGND VGND VPWR VPWR _01546_ sky130_fd_sc_hd__nand2_1
XFILLER_58_598 VPWR VGND VPWR VGND sky130_ef_sc_hd__decap_12
XFILLER_58_587 VGND VGND VPWR VPWR sky130_fd_sc_hd__fill_1
X_11830_ _04764_ _04776_ _04777_ VGND VGND VPWR VPWR _04778_ sky130_fd_sc_hd__nand3_1
XFILLER_45_248 VGND VGND VPWR VPWR sky130_fd_sc_hd__fill_1
XTAP_TAPCELL_ROW_44_906 VGND VPWR sky130_fd_sc_hd__tapvpwrvgnd_1
XFILLER_26_20 VGND VGND VPWR VPWR sky130_fd_sc_hd__decap_8
Xclkbuf_3_6__f_clk clknet_0_clk VGND VGND VPWR VPWR clknet_3_6__leaf_clk sky130_fd_sc_hd__clkbuf_16
X_11761_ _04700_ _04701_ VGND VGND VPWR VPWR _04702_ sky130_fd_sc_hd__nor2_1
XTAP_TAPCELL_ROW_44_917 VGND VPWR sky130_fd_sc_hd__tapvpwrvgnd_1
XTAP_TAPCELL_ROW_103_1739 VGND VPWR sky130_fd_sc_hd__tapvpwrvgnd_1
X_10712_ _03537_ _03559_ VGND VGND VPWR VPWR _03560_ sky130_fd_sc_hd__nand2b_1
XFILLER_14_657 VPWR VGND VPWR VGND sky130_ef_sc_hd__decap_12
XTAP_TAPCELL_ROW_24_630 VGND VPWR sky130_fd_sc_hd__tapvpwrvgnd_1
X_11692_ net462 net598 net588 net471 VGND VGND VPWR VPWR _04627_ sky130_fd_sc_hd__a22oi_1
XFILLER_13_134 VGND VGND VPWR VPWR sky130_fd_sc_hd__fill_1
XTAP_TAPCELL_ROW_136_2216 VGND VPWR sky130_fd_sc_hd__tapvpwrvgnd_1
XTAP_TAPCELL_ROW_136_2205 VGND VPWR sky130_fd_sc_hd__tapvpwrvgnd_1
XTAP_TAPCELL_ROW_62_1160 VGND VPWR sky130_fd_sc_hd__tapvpwrvgnd_1
X_10643_ _03482_ _03483_ VGND VGND VPWR VPWR _03485_ sky130_fd_sc_hd__xor2_2
X_13362_ clknet_3_3__leaf_clk _00049_ _00072_ VGND VGND VPWR VPWR net176 sky130_fd_sc_hd__dfrtp_1
XFILLER_42_63 VGND VGND VPWR VPWR sky130_fd_sc_hd__decap_4
XFILLER_42_85 VGND VGND VPWR VPWR sky130_fd_sc_hd__fill_2
X_10574_ _03404_ _03407_ _03408_ VGND VGND VPWR VPWR _03409_ sky130_fd_sc_hd__nand3_1
Xrebuffer8 _01441_ VGND VGND VPWR VPWR net708 sky130_fd_sc_hd__clkbuf_1
X_12313_ _05130_ _05127_ _05126_ VGND VGND VPWR VPWR _05305_ sky130_fd_sc_hd__a21o_1
X_13293_ net399 VGND VGND VPWR VPWR _00067_ sky130_fd_sc_hd__inv_2
XFILLER_123_721 VGND VGND VPWR VPWR sky130_fd_sc_hd__decap_6
X_12244_ _05227_ _05228_ VGND VGND VPWR VPWR _05229_ sky130_fd_sc_hd__nor2_1
XFILLER_122_231 VGND VGND VPWR VPWR sky130_fd_sc_hd__fill_1
XFILLER_107_294 VGND VGND VPWR VPWR sky130_fd_sc_hd__fill_2
X_12175_ _04988_ _04990_ _04987_ VGND VGND VPWR VPWR _05153_ sky130_fd_sc_hd__o21ba_1
X_11126_ _04011_ _04012_ VGND VGND VPWR VPWR _04013_ sky130_fd_sc_hd__or2_1
XFILLER_1_561 VPWR VGND VPWR VGND sky130_ef_sc_hd__decap_12
XFILLER_95_137 VGND VGND VPWR VPWR sky130_fd_sc_hd__decap_3
XFILLER_49_521 VGND VGND VPWR VPWR sky130_fd_sc_hd__fill_1
XFILLER_3_57 VPWR VGND VPWR VGND sky130_ef_sc_hd__decap_12
XFILLER_67_82 VPWR VGND VPWR VGND sky130_ef_sc_hd__decap_12
X_11057_ _03934_ _03935_ VGND VGND VPWR VPWR _03938_ sky130_fd_sc_hd__xnor2_1
XFILLER_76_362 VGND VGND VPWR VPWR sky130_fd_sc_hd__fill_2
XFILLER_64_513 VGND VGND VPWR VPWR sky130_fd_sc_hd__decap_4
X_10008_ net458 net579 _02789_ _02792_ VGND VGND VPWR VPWR _02793_ sky130_fd_sc_hd__and4_1
XFILLER_49_598 VGND VGND VPWR VPWR sky130_fd_sc_hd__fill_1
XFILLER_36_204 VGND VGND VPWR VPWR sky130_fd_sc_hd__decap_6
XFILLER_64_568 VGND VGND VPWR VPWR sky130_fd_sc_hd__fill_2
XPHY_EDGE_ROW_103_Left_240 VGND VGND VPWR VPWR sky130_fd_sc_hd__decap_3
XFILLER_45_782 VGND VGND VPWR VPWR sky130_fd_sc_hd__fill_2
XFILLER_45_771 VGND VGND VPWR VPWR sky130_fd_sc_hd__fill_2
XFILLER_17_462 VGND VGND VPWR VPWR sky130_fd_sc_hd__decap_3
XFILLER_60_730 VGND VGND VPWR VPWR sky130_fd_sc_hd__fill_2
X_11959_ net437 net598 net589 net446 VGND VGND VPWR VPWR _04919_ sky130_fd_sc_hd__a22oi_2
XFILLER_32_410 VGND VGND VPWR VPWR sky130_fd_sc_hd__decap_3
XFILLER_32_421 VGND VGND VPWR VPWR sky130_fd_sc_hd__decap_6
X_07150_ _06438_ _06440_ _06441_ VGND VGND VPWR VPWR _06442_ sky130_fd_sc_hd__or3_1
X_07081_ _05101_ _05123_ _05090_ VGND VGND VPWR VPWR _06373_ sky130_fd_sc_hd__o21ba_1
XFILLER_133_529 VPWR VGND VPWR VGND sky130_ef_sc_hd__decap_12
X_09722_ _02448_ _02483_ VGND VGND VPWR VPWR _02485_ sky130_fd_sc_hd__xnor2_1
XFILLER_99_498 VGND VGND VPWR VPWR sky130_fd_sc_hd__decap_6
X_07983_ net921 net309 net374 net373 VGND VGND VPWR VPWR _00720_ sky130_fd_sc_hd__and4b_1
X_06934_ _04741_ net232 _04697_ _04708_ VGND VGND VPWR VPWR _04807_ sky130_fd_sc_hd__o211ai_4
XFILLER_94_170 VGND VGND VPWR VPWR sky130_fd_sc_hd__decap_8
X_06865_ net469 net606 _04046_ VGND VGND VPWR VPWR _04057_ sky130_fd_sc_hd__and3_1
X_09653_ _02401_ _02407_ VGND VGND VPWR VPWR _02409_ sky130_fd_sc_hd__xnor2_1
XFILLER_67_373 VGND VGND VPWR VPWR sky130_fd_sc_hd__decap_8
XTAP_TAPCELL_ROW_2_325 VGND VPWR sky130_fd_sc_hd__tapvpwrvgnd_1
XFILLER_28_727 VGND VGND VPWR VPWR sky130_fd_sc_hd__decap_8
X_09584_ _02333_ _02334_ VGND VGND VPWR VPWR _02335_ sky130_fd_sc_hd__nor2_1
X_08604_ _01330_ _01332_ VGND VGND VPWR VPWR _01333_ sky130_fd_sc_hd__nor2_2
XFILLER_82_321 VPWR VGND VPWR VGND sky130_ef_sc_hd__decap_12
XFILLER_43_708 VPWR VGND VPWR VGND sky130_ef_sc_hd__decap_12
XPHY_EDGE_ROW_118_Right_118 VGND VGND VPWR VPWR sky130_fd_sc_hd__decap_3
X_06796_ _02533_ _02932_ _02954_ VGND VGND VPWR VPWR _03303_ sky130_fd_sc_hd__o21ai_1
XFILLER_82_365 VPWR VGND VPWR VGND sky130_ef_sc_hd__decap_12
X_08535_ net738 net341 net339 net824 VGND VGND VPWR VPWR _01264_ sky130_fd_sc_hd__a22oi_2
XFILLER_70_538 VPWR VGND VPWR VGND sky130_ef_sc_hd__decap_12
XFILLER_51_741 VPWR VGND VPWR VGND sky130_ef_sc_hd__decap_12
XFILLER_35_270 VGND VGND VPWR VPWR sky130_fd_sc_hd__fill_1
XFILLER_35_281 VGND VGND VPWR VPWR sky130_fd_sc_hd__decap_6
X_08466_ _01191_ _01192_ _01194_ VGND VGND VPWR VPWR _01195_ sky130_fd_sc_hd__and3_1
XFILLER_51_763 VGND VGND VPWR VPWR sky130_fd_sc_hd__fill_1
XFILLER_50_251 VGND VGND VPWR VPWR sky130_fd_sc_hd__fill_1
X_07417_ _00157_ _00156_ VGND VGND VPWR VPWR _00158_ sky130_fd_sc_hd__nand2b_1
X_08397_ _01123_ _01126_ VGND VGND VPWR VPWR _01127_ sky130_fd_sc_hd__xnor2_1
XFILLER_51_785 VGND VGND VPWR VPWR sky130_fd_sc_hd__decap_6
XFILLER_11_649 VGND VGND VPWR VPWR sky130_fd_sc_hd__fill_1
XFILLER_109_515 VGND VGND VPWR VPWR sky130_fd_sc_hd__decap_4
X_07348_ _06452_ _06480_ _06479_ VGND VGND VPWR VPWR _06639_ sky130_fd_sc_hd__a21bo_1
XFILLER_50_295 VGND VGND VPWR VPWR sky130_fd_sc_hd__decap_3
XFILLER_7_609 VGND VGND VPWR VPWR sky130_fd_sc_hd__decap_6
XFILLER_136_301 VGND VGND VPWR VPWR sky130_fd_sc_hd__decap_3
XFILLER_109_526 VPWR VGND VPWR VGND sky130_ef_sc_hd__decap_12
XFILLER_136_356 VGND VGND VPWR VPWR sky130_fd_sc_hd__decap_4
XTAP_TAPCELL_ROW_131_2124 VGND VPWR sky130_fd_sc_hd__tapvpwrvgnd_1
XFILLER_109_559 VGND VGND VPWR VPWR sky130_fd_sc_hd__fill_1
X_07279_ net452 net604 _06568_ _06569_ VGND VGND VPWR VPWR _06570_ sky130_fd_sc_hd__a22o_1
XFILLER_136_378 VGND VGND VPWR VPWR sky130_fd_sc_hd__decap_3
XTAP_TAPCELL_ROW_131_2135 VGND VPWR sky130_fd_sc_hd__tapvpwrvgnd_1
XFILLER_128_77 VGND VGND VPWR VPWR sky130_fd_sc_hd__decap_6
XFILLER_124_529 VGND VGND VPWR VPWR sky130_fd_sc_hd__decap_3
X_09018_ _01578_ _01581_ VGND VGND VPWR VPWR _01744_ sky130_fd_sc_hd__nor2_1
X_10290_ net489 net655 VGND VGND VPWR VPWR _03100_ sky130_fd_sc_hd__nand2_1
XFILLER_88_59 VGND VGND VPWR VPWR sky130_fd_sc_hd__fill_1
XFILLER_120_713 VPWR VGND VPWR VGND sky130_ef_sc_hd__decap_12
XFILLER_104_253 VGND VGND VPWR VPWR sky130_fd_sc_hd__decap_4
XFILLER_120_757 VPWR VGND VPWR VGND sky130_ef_sc_hd__decap_12
XFILLER_104_286 VGND VGND VPWR VPWR sky130_fd_sc_hd__decap_6
XFILLER_77_137 VGND VGND VPWR VPWR sky130_fd_sc_hd__decap_8
Xfanout640 net641 VGND VGND VPWR VPWR net640 sky130_fd_sc_hd__buf_2
Xfanout651 net117 VGND VGND VPWR VPWR net651 sky130_fd_sc_hd__clkbuf_2
Xfanout684 net100 VGND VGND VPWR VPWR net684 sky130_fd_sc_hd__buf_2
Xfanout673 net109 VGND VGND VPWR VPWR net673 sky130_fd_sc_hd__dlymetal6s2s_1
Xfanout662 net110 VGND VGND VPWR VPWR net662 sky130_fd_sc_hd__buf_2
XTAP_TAPCELL_ROW_129_2097 VGND VPWR sky130_fd_sc_hd__tapvpwrvgnd_1
Xfanout695 net696 VGND VGND VPWR VPWR net695 sky130_fd_sc_hd__clkbuf_4
XFILLER_58_362 VGND VGND VPWR VPWR sky130_fd_sc_hd__fill_2
X_12931_ _05971_ _05979_ VGND VGND VPWR VPWR _05980_ sky130_fd_sc_hd__nand2_1
XFILLER_18_204 VPWR VGND VPWR VGND sky130_ef_sc_hd__decap_12
XTAP_TAPCELL_ROW_29_700 VGND VPWR sky130_fd_sc_hd__tapvpwrvgnd_1
X_12862_ _05903_ _05904_ VGND VGND VPWR VPWR _05905_ sky130_fd_sc_hd__xnor2_1
XFILLER_34_708 VGND VGND VPWR VPWR sky130_fd_sc_hd__fill_1
X_11813_ _04756_ _04758_ VGND VGND VPWR VPWR _04759_ sky130_fd_sc_hd__or2_1
X_12793_ _05826_ _05827_ _05828_ VGND VGND VPWR VPWR _05829_ sky130_fd_sc_hd__or3_1
X_11744_ net665 net641 net302 net300 VGND VGND VPWR VPWR _04683_ sky130_fd_sc_hd__and4_1
XFILLER_14_454 VGND VGND VPWR VPWR sky130_fd_sc_hd__fill_1
XFILLER_14_465 VGND VGND VPWR VPWR sky130_fd_sc_hd__decap_3
X_11675_ _04605_ _04608_ VGND VGND VPWR VPWR _04609_ sky130_fd_sc_hd__or2_1
XFILLER_53_73 VGND VGND VPWR VPWR sky130_fd_sc_hd__fill_1
X_13414_ clknet_3_6__leaf_clk _00054_ _00124_ VGND VGND VPWR VPWR net213 sky130_fd_sc_hd__dfrtp_1
X_10626_ net121 _03465_ VGND VGND VPWR VPWR _03466_ sky130_fd_sc_hd__xnor2_1
XFILLER_127_345 VGND VGND VPWR VPWR sky130_fd_sc_hd__decap_6
XTAP_TAPCELL_ROW_116_1919 VGND VPWR sky130_fd_sc_hd__tapvpwrvgnd_1
X_13345_ net398 VGND VGND VPWR VPWR _00119_ sky130_fd_sc_hd__inv_2
X_10557_ _03231_ _03389_ VGND VGND VPWR VPWR _03391_ sky130_fd_sc_hd__xnor2_1
XFILLER_10_682 VPWR VGND VPWR VGND sky130_ef_sc_hd__decap_12
X_10488_ _03161_ _03164_ _03313_ _03315_ VGND VGND VPWR VPWR _03316_ sky130_fd_sc_hd__o211ai_2
X_13276_ _06343_ _06354_ VGND VGND VPWR VPWR _06355_ sky130_fd_sc_hd__xnor2_1
XTAP_TAPCELL_ROW_75_1351 VGND VPWR sky130_fd_sc_hd__tapvpwrvgnd_1
XTAP_TAPCELL_ROW_75_1340 VGND VPWR sky130_fd_sc_hd__tapvpwrvgnd_1
X_12227_ _05042_ _05208_ _05209_ VGND VGND VPWR VPWR _05211_ sky130_fd_sc_hd__nand3b_1
XFILLER_69_605 VGND VGND VPWR VPWR sky130_fd_sc_hd__fill_1
XFILLER_68_104 VPWR VGND VPWR VGND sky130_ef_sc_hd__decap_12
X_12158_ _05001_ _05020_ _05018_ VGND VGND VPWR VPWR _05135_ sky130_fd_sc_hd__o21bai_1
XFILLER_110_234 VPWR VGND VPWR VGND sky130_ef_sc_hd__decap_12
XFILLER_77_660 VPWR VGND VPWR VGND sky130_ef_sc_hd__decap_12
X_12089_ _05056_ _05060_ VGND VGND VPWR VPWR _05061_ sky130_fd_sc_hd__xnor2_1
X_11109_ _03993_ _03994_ VGND VGND VPWR VPWR _03995_ sky130_fd_sc_hd__and2b_1
XFILLER_110_267 VPWR VGND VPWR VGND sky130_ef_sc_hd__decap_12
XFILLER_83_129 VGND VGND VPWR VPWR sky130_fd_sc_hd__decap_6
XFILLER_83_107 VGND VGND VPWR VPWR sky130_fd_sc_hd__decap_4
XFILLER_76_170 VGND VGND VPWR VPWR sky130_fd_sc_hd__decap_3
XFILLER_64_365 VPWR VGND VPWR VGND sky130_ef_sc_hd__decap_12
XFILLER_52_516 VGND VGND VPWR VPWR sky130_fd_sc_hd__fill_2
XFILLER_91_195 VGND VGND VPWR VPWR sky130_fd_sc_hd__fill_2
XFILLER_17_281 VPWR VGND VPWR VGND sky130_ef_sc_hd__decap_12
XFILLER_18_793 VPWR VGND VPWR VGND sky130_ef_sc_hd__decap_12
X_08320_ _01052_ _01053_ VGND VGND VPWR VPWR _01054_ sky130_fd_sc_hd__xnor2_1
XFILLER_33_774 VGND VGND VPWR VPWR sky130_fd_sc_hd__decap_8
X_08251_ _00860_ _00885_ _00859_ VGND VGND VPWR VPWR _00986_ sky130_fd_sc_hd__a21oi_1
XFILLER_20_413 VGND VGND VPWR VPWR sky130_fd_sc_hd__fill_1
XFILLER_33_785 VGND VGND VPWR VPWR sky130_fd_sc_hd__fill_2
X_07202_ _05319_ _05352_ _06492_ _06493_ VGND VGND VPWR VPWR _06494_ sky130_fd_sc_hd__o211a_4
X_08182_ _00915_ _00916_ _00903_ VGND VGND VPWR VPWR _00918_ sky130_fd_sc_hd__o21ai_1
XFILLER_134_805 VGND VGND VPWR VPWR sky130_fd_sc_hd__decap_6
X_07133_ _06423_ _06424_ VGND VGND VPWR VPWR _06425_ sky130_fd_sc_hd__xor2_1
X_07064_ net228 _06205_ _04807_ _04829_ VGND VGND VPWR VPWR _06226_ sky130_fd_sc_hd__o211ai_4
XFILLER_106_518 VGND VGND VPWR VPWR sky130_fd_sc_hd__decap_4
Xoutput210 net210 VGND VGND VPWR VPWR out3[0] sky130_fd_sc_hd__buf_2
XPHY_EDGE_ROW_12_Right_12 VGND VGND VPWR VPWR sky130_fd_sc_hd__decap_3
XFILLER_133_337 VPWR VGND VPWR VGND sky130_ef_sc_hd__decap_12
Xoutput221 net221 VGND VGND VPWR VPWR out3[5] sky130_fd_sc_hd__buf_2
XFILLER_99_262 VPWR VGND VPWR VGND sky130_ef_sc_hd__decap_12
X_07966_ _00701_ _00702_ VGND VGND VPWR VPWR _00704_ sky130_fd_sc_hd__nor2_1
XFILLER_75_608 VGND VGND VPWR VPWR sky130_fd_sc_hd__decap_8
XFILLER_56_800 VGND VGND VPWR VPWR sky130_fd_sc_hd__fill_2
X_09705_ _02330_ _02335_ _02333_ VGND VGND VPWR VPWR _02466_ sky130_fd_sc_hd__a21oi_1
X_06917_ _02856_ _04090_ VGND VGND VPWR VPWR _04621_ sky130_fd_sc_hd__nor2_1
X_07897_ _00625_ _00633_ VGND VGND VPWR VPWR _00635_ sky130_fd_sc_hd__xnor2_1
X_09636_ _02385_ _02389_ VGND VGND VPWR VPWR _02391_ sky130_fd_sc_hd__xor2_1
XFILLER_55_321 VGND VGND VPWR VPWR sky130_fd_sc_hd__fill_1
XFILLER_28_557 VGND VGND VPWR VPWR sky130_fd_sc_hd__decap_3
X_06848_ _03839_ _03860_ VGND VGND VPWR VPWR _03871_ sky130_fd_sc_hd__xor2_1
XFILLER_82_162 VGND VGND VPWR VPWR sky130_fd_sc_hd__decap_8
XFILLER_55_376 VPWR VGND VPWR VGND sky130_ef_sc_hd__decap_12
XFILLER_15_207 VGND VGND VPWR VPWR sky130_fd_sc_hd__decap_3
XPHY_EDGE_ROW_21_Right_21 VGND VGND VPWR VPWR sky130_fd_sc_hd__decap_3
X_06779_ _02664_ _03096_ VGND VGND VPWR VPWR _03118_ sky130_fd_sc_hd__or2_1
X_09567_ _02305_ _02315_ VGND VGND VPWR VPWR _02317_ sky130_fd_sc_hd__nand2b_1
XFILLER_82_195 VGND VGND VPWR VPWR sky130_fd_sc_hd__fill_1
XFILLER_43_527 VGND VGND VPWR VPWR sky130_fd_sc_hd__fill_2
XFILLER_15_229 VGND VGND VPWR VPWR sky130_fd_sc_hd__decap_6
X_09498_ net258 net256 net544 VGND VGND VPWR VPWR _02242_ sky130_fd_sc_hd__o21ai_1
X_08518_ _01240_ _01246_ VGND VGND VPWR VPWR _01247_ sky130_fd_sc_hd__nor2_1
X_08449_ net270 net692 net259 net256 VGND VGND VPWR VPWR _01178_ sky130_fd_sc_hd__and4_1
XFILLER_11_413 VGND VGND VPWR VPWR sky130_fd_sc_hd__decap_8
XFILLER_128_109 VPWR VGND VPWR VGND sky130_ef_sc_hd__decap_12
XFILLER_11_446 VGND VGND VPWR VPWR sky130_fd_sc_hd__fill_2
XFILLER_128_3 VPWR VGND VPWR VGND sky130_ef_sc_hd__decap_12
XFILLER_109_312 VPWR VGND VPWR VGND sky130_ef_sc_hd__decap_12
XFILLER_7_417 VGND VGND VPWR VPWR sky130_fd_sc_hd__decap_4
X_11460_ _04208_ _04214_ _04120_ VGND VGND VPWR VPWR _04378_ sky130_fd_sc_hd__o21ai_1
XFILLER_125_805 VGND VGND VPWR VPWR sky130_fd_sc_hd__fill_2
XFILLER_109_334 VGND VGND VPWR VPWR sky130_fd_sc_hd__fill_2
X_10411_ net495 net651 VGND VGND VPWR VPWR _03231_ sky130_fd_sc_hd__nand2_1
X_11391_ _03946_ _04069_ VGND VGND VPWR VPWR _04302_ sky130_fd_sc_hd__or2_2
XPHY_EDGE_ROW_30_Right_30 VGND VGND VPWR VPWR sky130_fd_sc_hd__decap_3
XFILLER_136_153 VPWR VGND VPWR VGND sky130_ef_sc_hd__decap_12
X_10342_ _02993_ _02995_ _03154_ _03156_ VGND VGND VPWR VPWR _03157_ sky130_fd_sc_hd__a211oi_4
X_13130_ _06197_ _06164_ VGND VGND VPWR VPWR _06198_ sky130_fd_sc_hd__and2b_1
XFILLER_136_197 VGND VGND VPWR VPWR sky130_fd_sc_hd__fill_2
X_13061_ _05978_ _05980_ _06120_ VGND VGND VPWR VPWR _06122_ sky130_fd_sc_hd__and3_1
X_12012_ _04975_ _04976_ VGND VGND VPWR VPWR _04977_ sky130_fd_sc_hd__and2_4
X_10273_ _03067_ _03080_ VGND VGND VPWR VPWR _03081_ sky130_fd_sc_hd__xnor2_1
XFILLER_2_133 VGND VGND VPWR VPWR sky130_fd_sc_hd__decap_6
XFILLER_120_521 VGND VGND VPWR VPWR sky130_fd_sc_hd__decap_8
XTAP_TAPCELL_ROW_111_1849 VGND VPWR sky130_fd_sc_hd__tapvpwrvgnd_1
XTAP_TAPCELL_ROW_57_1092 VGND VPWR sky130_fd_sc_hd__tapvpwrvgnd_1
XFILLER_2_177 VPWR VGND VPWR VGND sky130_ef_sc_hd__decap_12
XFILLER_93_405 VGND VGND VPWR VPWR sky130_fd_sc_hd__decap_8
XFILLER_120_576 VGND VGND VPWR VPWR sky130_fd_sc_hd__decap_3
Xfanout481 net24 VGND VGND VPWR VPWR net481 sky130_fd_sc_hd__clkbuf_4
XFILLER_93_416 VGND VGND VPWR VPWR sky130_fd_sc_hd__decap_8
Xfanout470 net25 VGND VGND VPWR VPWR net470 sky130_fd_sc_hd__buf_2
XTAP_TAPCELL_ROW_70_1281 VGND VPWR sky130_fd_sc_hd__tapvpwrvgnd_1
XTAP_TAPCELL_ROW_70_1270 VGND VPWR sky130_fd_sc_hd__tapvpwrvgnd_1
XFILLER_65_118 VPWR VGND VPWR VGND sky130_ef_sc_hd__decap_12
Xfanout492 net494 VGND VGND VPWR VPWR net492 sky130_fd_sc_hd__buf_2
XFILLER_48_62 VGND VGND VPWR VPWR sky130_fd_sc_hd__fill_1
XFILLER_46_321 VGND VGND VPWR VPWR sky130_fd_sc_hd__decap_8
XFILLER_0_69 VPWR VGND VPWR VGND sky130_ef_sc_hd__decap_12
X_12914_ _05677_ _05841_ _05840_ VGND VGND VPWR VPWR _05961_ sky130_fd_sc_hd__a21oi_1
XFILLER_73_184 VGND VGND VPWR VPWR sky130_fd_sc_hd__decap_8
XFILLER_73_173 VGND VGND VPWR VPWR sky130_fd_sc_hd__fill_1
XFILLER_61_335 VGND VGND VPWR VPWR sky130_fd_sc_hd__fill_1
XFILLER_46_387 VPWR VGND VPWR VGND sky130_ef_sc_hd__decap_12
X_12845_ _05884_ _05885_ VGND VGND VPWR VPWR _05886_ sky130_fd_sc_hd__nand2_1
X_12776_ _05652_ _05654_ VGND VGND VPWR VPWR _05811_ sky130_fd_sc_hd__and2_1
XFILLER_14_240 VGND VGND VPWR VPWR sky130_fd_sc_hd__fill_2
X_11727_ _04663_ _04664_ VGND VGND VPWR VPWR _00005_ sky130_fd_sc_hd__and2_1
XTAP_TAPCELL_ROW_32_739 VGND VPWR sky130_fd_sc_hd__tapvpwrvgnd_1
XFILLER_128_632 VPWR VGND VPWR VGND sky130_ef_sc_hd__decap_12
X_11658_ _04575_ _04588_ VGND VGND VPWR VPWR _04591_ sky130_fd_sc_hd__xnor2_1
XTAP_TAPCELL_ROW_12_463 VGND VPWR sky130_fd_sc_hd__tapvpwrvgnd_1
XFILLER_30_799 VGND VGND VPWR VPWR sky130_fd_sc_hd__decap_8
X_11589_ _04515_ _04517_ VGND VGND VPWR VPWR _04519_ sky130_fd_sc_hd__xor2_1
X_10609_ _03425_ _03447_ VGND VGND VPWR VPWR _03448_ sky130_fd_sc_hd__xor2_1
X_13328_ net392 VGND VGND VPWR VPWR _00102_ sky130_fd_sc_hd__inv_2
XFILLER_10_490 VGND VGND VPWR VPWR sky130_fd_sc_hd__decap_3
XFILLER_115_337 VPWR VGND VPWR VGND sky130_ef_sc_hd__decap_12
XFILLER_97_700 VGND VGND VPWR VPWR sky130_fd_sc_hd__decap_3
X_13259_ _06333_ _06336_ VGND VGND VPWR VPWR _06337_ sky130_fd_sc_hd__xnor2_1
XFILLER_111_565 VGND VGND VPWR VPWR sky130_fd_sc_hd__fill_1
X_07820_ _00556_ _00557_ VGND VGND VPWR VPWR _00559_ sky130_fd_sc_hd__xnor2_1
X_07751_ _00488_ _00489_ VGND VGND VPWR VPWR _00490_ sky130_fd_sc_hd__nor2_1
XTAP_TAPCELL_ROW_88_1531 VGND VPWR sky130_fd_sc_hd__tapvpwrvgnd_1
XTAP_TAPCELL_ROW_88_1520 VGND VPWR sky130_fd_sc_hd__tapvpwrvgnd_1
XFILLER_49_181 VGND VGND VPWR VPWR sky130_fd_sc_hd__decap_8
X_06702_ net360 VGND VGND VPWR VPWR _02284_ sky130_fd_sc_hd__inv_2
XFILLER_37_332 VGND VGND VPWR VPWR sky130_fd_sc_hd__decap_4
X_07682_ _00285_ _00420_ _00421_ VGND VGND VPWR VPWR _00422_ sky130_fd_sc_hd__nand3_1
XFILLER_53_803 VGND VGND VPWR VPWR sky130_fd_sc_hd__fill_1
XFILLER_25_505 VGND VGND VPWR VPWR sky130_fd_sc_hd__fill_1
X_09421_ _02155_ _02156_ VGND VGND VPWR VPWR _02158_ sky130_fd_sc_hd__xnor2_1
XFILLER_80_611 VGND VGND VPWR VPWR sky130_fd_sc_hd__decap_4
XFILLER_64_195 VGND VGND VPWR VPWR sky130_fd_sc_hd__fill_1
X_09352_ _01761_ _01941_ _01938_ VGND VGND VPWR VPWR _02082_ sky130_fd_sc_hd__a21oi_1
X_08303_ _00929_ _01029_ _01028_ VGND VGND VPWR VPWR _01037_ sky130_fd_sc_hd__a21bo_1
XFILLER_80_699 VGND VGND VPWR VPWR sky130_fd_sc_hd__fill_1
X_09283_ net406 net555 net553 VGND VGND VPWR VPWR _02007_ sky130_fd_sc_hd__and3_1
X_08234_ _02164_ net402 _06561_ VGND VGND VPWR VPWR _00969_ sky130_fd_sc_hd__o21ai_1
X_08165_ _00898_ _00899_ VGND VGND VPWR VPWR _00901_ sky130_fd_sc_hd__and2_1
XFILLER_134_613 VPWR VGND VPWR VGND sky130_ef_sc_hd__decap_12
X_07116_ net521 net102 VGND VGND VPWR VPWR _06408_ sky130_fd_sc_hd__nand2_1
XTAP_TAPCELL_ROW_99_1682 VGND VPWR sky130_fd_sc_hd__tapvpwrvgnd_1
XFILLER_134_657 VPWR VGND VPWR VGND sky130_ef_sc_hd__decap_12
XFILLER_118_197 VGND VGND VPWR VPWR sky130_fd_sc_hd__decap_8
XFILLER_109_68 VGND VGND VPWR VPWR sky130_fd_sc_hd__decap_6
XFILLER_109_57 VGND VGND VPWR VPWR sky130_fd_sc_hd__decap_8
X_08096_ _06587_ _00721_ _00720_ VGND VGND VPWR VPWR _00832_ sky130_fd_sc_hd__a21oi_1
XFILLER_133_167 VGND VGND VPWR VPWR sky130_fd_sc_hd__fill_1
X_07047_ _05822_ _06008_ _06030_ VGND VGND VPWR VPWR _06041_ sky130_fd_sc_hd__nor3_2
XFILLER_87_221 VGND VGND VPWR VPWR sky130_fd_sc_hd__decap_3
XFILLER_88_755 VGND VGND VPWR VPWR sky130_fd_sc_hd__fill_1
XFILLER_85_16 VPWR VGND VPWR VGND sky130_ef_sc_hd__decap_12
X_08998_ _01723_ net731 VGND VGND VPWR VPWR _01724_ sky130_fd_sc_hd__nand2b_1
XFILLER_75_427 VGND VGND VPWR VPWR sky130_fd_sc_hd__decap_8
XFILLER_75_405 VGND VGND VPWR VPWR sky130_fd_sc_hd__fill_2
XTAP_TAPCELL_ROW_126_2056 VGND VPWR sky130_fd_sc_hd__tapvpwrvgnd_1
X_07949_ _00658_ _00686_ VGND VGND VPWR VPWR _00687_ sky130_fd_sc_hd__and2b_1
XFILLER_75_449 VGND VGND VPWR VPWR sky130_fd_sc_hd__decap_6
XFILLER_56_663 VPWR VGND VPWR VGND sky130_ef_sc_hd__decap_12
XFILLER_44_803 VGND VGND VPWR VPWR sky130_fd_sc_hd__decap_4
XFILLER_16_505 VPWR VGND VPWR VGND sky130_ef_sc_hd__decap_12
X_10960_ _03818_ _03819_ _03830_ VGND VGND VPWR VPWR _03832_ sky130_fd_sc_hd__nand3_1
X_09619_ _02241_ _02276_ _02278_ VGND VGND VPWR VPWR _02373_ sky130_fd_sc_hd__a21oi_1
XFILLER_83_493 VGND VGND VPWR VPWR sky130_fd_sc_hd__decap_4
XFILLER_71_611 VGND VGND VPWR VPWR sky130_fd_sc_hd__decap_4
XFILLER_43_302 VGND VGND VPWR VPWR sky130_fd_sc_hd__decap_4
XFILLER_16_549 VGND VGND VPWR VPWR sky130_fd_sc_hd__fill_1
X_10891_ _02087_ _03753_ net649 _03750_ VGND VGND VPWR VPWR _03756_ sky130_fd_sc_hd__or4bb_1
X_12630_ _05476_ _05478_ _05650_ _05651_ VGND VGND VPWR VPWR _05652_ sky130_fd_sc_hd__o211ai_2
XFILLER_12_755 VGND VGND VPWR VPWR sky130_fd_sc_hd__fill_1
X_12561_ _05562_ _05575_ VGND VGND VPWR VPWR _05576_ sky130_fd_sc_hd__xnor2_1
XFILLER_11_265 VGND VGND VPWR VPWR sky130_fd_sc_hd__fill_2
X_11512_ _04302_ _04306_ _04309_ VGND VGND VPWR VPWR _04434_ sky130_fd_sc_hd__a21bo_1
XFILLER_8_737 VPWR VGND VPWR VGND sky130_ef_sc_hd__decap_12
X_12492_ _05498_ _05499_ VGND VGND VPWR VPWR _05500_ sky130_fd_sc_hd__and2b_1
XFILLER_109_120 VPWR VGND VPWR VGND sky130_ef_sc_hd__decap_12
XFILLER_7_225 VPWR VGND VPWR VGND sky130_ef_sc_hd__decap_12
X_11443_ _04205_ _04233_ _04204_ VGND VGND VPWR VPWR _04359_ sky130_fd_sc_hd__a21oi_1
XFILLER_125_624 VPWR VGND VPWR VGND sky130_ef_sc_hd__decap_12
XFILLER_109_153 VPWR VGND VPWR VGND sky130_ef_sc_hd__decap_12
XTAP_TAPCELL_ROW_59_1121 VGND VPWR sky130_fd_sc_hd__tapvpwrvgnd_1
X_13113_ _06009_ _06014_ _05918_ VGND VGND VPWR VPWR _06179_ sky130_fd_sc_hd__o21ai_1
X_11374_ _04021_ _04282_ VGND VGND VPWR VPWR _04284_ sky130_fd_sc_hd__xnor2_1
X_10325_ net376 net52 VGND VGND VPWR VPWR _03138_ sky130_fd_sc_hd__nand2_1
X_10256_ net266 net274 VGND VGND VPWR VPWR _03062_ sky130_fd_sc_hd__nand2_1
X_13044_ _06101_ _06102_ VGND VGND VPWR VPWR _06103_ sky130_fd_sc_hd__nor2_1
XFILLER_3_497 VGND VGND VPWR VPWR sky130_fd_sc_hd__decap_6
XFILLER_59_72 VPWR VGND VPWR VGND sky130_ef_sc_hd__decap_12
XFILLER_39_608 VGND VGND VPWR VPWR sky130_fd_sc_hd__decap_3
XFILLER_120_362 VGND VGND VPWR VPWR sky130_fd_sc_hd__fill_2
XFILLER_93_202 VGND VGND VPWR VPWR sky130_fd_sc_hd__decap_8
XFILLER_78_265 VPWR VGND VPWR VGND sky130_ef_sc_hd__decap_12
X_10187_ net901 _02979_ _02978_ VGND VGND VPWR VPWR _02988_ sky130_fd_sc_hd__o21ai_1
XFILLER_19_332 VGND VGND VPWR VPWR sky130_fd_sc_hd__decap_4
XFILLER_93_257 VGND VGND VPWR VPWR sky130_fd_sc_hd__decap_3
XFILLER_47_652 VGND VGND VPWR VPWR sky130_fd_sc_hd__decap_4
XFILLER_19_343 VGND VGND VPWR VPWR sky130_fd_sc_hd__decap_8
XFILLER_19_354 VGND VGND VPWR VPWR sky130_fd_sc_hd__decap_3
XTAP_TAPCELL_ROW_37_809 VGND VPWR sky130_fd_sc_hd__tapvpwrvgnd_1
XFILLER_47_685 VGND VGND VPWR VPWR sky130_fd_sc_hd__decap_8
XTAP_TAPCELL_ROW_17_533 VGND VPWR sky130_fd_sc_hd__tapvpwrvgnd_1
XTAP_TAPCELL_ROW_83_1461 VGND VPWR sky130_fd_sc_hd__tapvpwrvgnd_1
XTAP_TAPCELL_ROW_83_1450 VGND VPWR sky130_fd_sc_hd__tapvpwrvgnd_1
X_12828_ _05864_ _05865_ VGND VGND VPWR VPWR _05868_ sky130_fd_sc_hd__xor2_1
XFILLER_15_593 VGND VGND VPWR VPWR sky130_fd_sc_hd__decap_3
X_12759_ _05771_ _05792_ VGND VGND VPWR VPWR _05793_ sky130_fd_sc_hd__xnor2_1
XFILLER_30_530 VGND VGND VPWR VPWR sky130_fd_sc_hd__fill_2
XFILLER_115_123 VPWR VGND VPWR VGND sky130_ef_sc_hd__decap_12
X_09970_ _02752_ _02753_ VGND VGND VPWR VPWR _02754_ sky130_fd_sc_hd__xnor2_1
X_08921_ net464 net538 _01646_ VGND VGND VPWR VPWR _01647_ sky130_fd_sc_hd__and3_1
X_08852_ _01439_ _01441_ _01576_ _01577_ VGND VGND VPWR VPWR _01579_ sky130_fd_sc_hd__o211ai_1
XFILLER_111_362 VPWR VGND VPWR VGND sky130_ef_sc_hd__decap_12
X_07803_ net607 net411 _00368_ _00206_ VGND VGND VPWR VPWR _00542_ sky130_fd_sc_hd__a31o_1
XFILLER_57_405 VPWR VGND VPWR VGND sky130_ef_sc_hd__decap_12
X_08783_ _01508_ _01509_ VGND VGND VPWR VPWR _01510_ sky130_fd_sc_hd__or2_1
X_07734_ _00439_ _00471_ VGND VGND VPWR VPWR _00473_ sky130_fd_sc_hd__xnor2_1
XFILLER_72_419 VGND VGND VPWR VPWR sky130_fd_sc_hd__fill_1
X_07665_ _00394_ _00393_ _00404_ VGND VGND VPWR VPWR _00405_ sky130_fd_sc_hd__a21o_1
XFILLER_37_162 VGND VGND VPWR VPWR sky130_fd_sc_hd__decap_6
X_09404_ net488 net628 _01974_ _02137_ VGND VGND VPWR VPWR _02139_ sky130_fd_sc_hd__a22o_1
XFILLER_25_335 VGND VGND VPWR VPWR sky130_fd_sc_hd__fill_1
XFILLER_41_806 VGND VGND VPWR VPWR sky130_fd_sc_hd__fill_1
XFILLER_111_69 VGND VGND VPWR VPWR sky130_fd_sc_hd__fill_2
X_07596_ net682 net484 net476 net684 VGND VGND VPWR VPWR _00336_ sky130_fd_sc_hd__a22o_1
XFILLER_80_463 VGND VGND VPWR VPWR sky130_fd_sc_hd__decap_3
X_09335_ _02061_ _02062_ _01965_ VGND VGND VPWR VPWR _02064_ sky130_fd_sc_hd__a21o_1
X_09266_ _01985_ _01988_ VGND VGND VPWR VPWR _01990_ sky130_fd_sc_hd__xor2_1
XFILLER_21_541 VGND VGND VPWR VPWR sky130_fd_sc_hd__decap_8
X_08217_ _00950_ _00951_ VGND VGND VPWR VPWR _00952_ sky130_fd_sc_hd__xnor2_1
XFILLER_21_585 VGND VGND VPWR VPWR sky130_fd_sc_hd__fill_1
X_09197_ _01918_ _01919_ VGND VGND VPWR VPWR _01921_ sky130_fd_sc_hd__xor2_1
XFILLER_5_729 VPWR VGND VPWR VGND sky130_ef_sc_hd__decap_12
XFILLER_134_421 VPWR VGND VPWR VGND sky130_ef_sc_hd__decap_12
XFILLER_134_410 VGND VGND VPWR VPWR sky130_fd_sc_hd__decap_8
XFILLER_107_646 VGND VGND VPWR VPWR sky130_fd_sc_hd__fill_2
X_08148_ _00862_ _00882_ VGND VGND VPWR VPWR _00884_ sky130_fd_sc_hd__xnor2_1
XFILLER_20_22 VGND VGND VPWR VPWR sky130_fd_sc_hd__decap_6
X_08079_ _00710_ _00815_ VGND VGND VPWR VPWR _00816_ sky130_fd_sc_hd__xnor2_1
XFILLER_106_134 VGND VGND VPWR VPWR sky130_fd_sc_hd__decap_6
X_10110_ _02891_ _02893_ _02892_ VGND VGND VPWR VPWR _02903_ sky130_fd_sc_hd__o21ba_1
XFILLER_0_412 VGND VGND VPWR VPWR sky130_fd_sc_hd__decap_4
X_11090_ net409 net563 net561 net416 VGND VGND VPWR VPWR _03974_ sky130_fd_sc_hd__a22oi_1
X_10041_ _02792_ _02826_ VGND VGND VPWR VPWR _02828_ sky130_fd_sc_hd__xnor2_1
XTAP_TAPCELL_ROW_54_1051 VGND VPWR sky130_fd_sc_hd__tapvpwrvgnd_1
XFILLER_0_434 VGND VGND VPWR VPWR sky130_fd_sc_hd__decap_3
XFILLER_102_362 VGND VGND VPWR VPWR sky130_fd_sc_hd__fill_2
XFILLER_88_563 VPWR VGND VPWR VGND sky130_ef_sc_hd__decap_12
XFILLER_0_489 VGND VGND VPWR VPWR sky130_fd_sc_hd__decap_4
XFILLER_130_693 VGND VGND VPWR VPWR sky130_fd_sc_hd__decap_6
XFILLER_76_769 VPWR VGND VPWR VGND sky130_ef_sc_hd__decap_12
XFILLER_63_419 VGND VGND VPWR VPWR sky130_fd_sc_hd__decap_6
X_11992_ _04932_ _04951_ _04953_ VGND VGND VPWR VPWR _04955_ sky130_fd_sc_hd__or3_4
XFILLER_29_652 VPWR VGND VPWR VGND sky130_ef_sc_hd__decap_12
XFILLER_44_600 VGND VGND VPWR VPWR sky130_fd_sc_hd__fill_1
X_10943_ _03809_ _03810_ _03807_ VGND VGND VPWR VPWR _03813_ sky130_fd_sc_hd__o21ai_1
XFILLER_28_173 VPWR VGND VPWR VGND sky130_ef_sc_hd__decap_12
XFILLER_29_696 VGND VGND VPWR VPWR sky130_fd_sc_hd__decap_6
XFILLER_71_430 VGND VGND VPWR VPWR sky130_fd_sc_hd__fill_2
XFILLER_43_110 VGND VGND VPWR VPWR sky130_fd_sc_hd__fill_2
XFILLER_28_195 VGND VGND VPWR VPWR sky130_fd_sc_hd__fill_1
XFILLER_71_485 VGND VGND VPWR VPWR sky130_fd_sc_hd__decap_3
X_10874_ _03717_ _03736_ VGND VGND VPWR VPWR _03737_ sky130_fd_sc_hd__xnor2_1
XFILLER_12_530 VGND VGND VPWR VPWR sky130_fd_sc_hd__fill_2
X_12613_ _05619_ _05620_ _05631_ VGND VGND VPWR VPWR _05633_ sky130_fd_sc_hd__nand3_1
XFILLER_31_349 VGND VGND VPWR VPWR sky130_fd_sc_hd__decap_8
XFILLER_12_552 VGND VGND VPWR VPWR sky130_fd_sc_hd__fill_2
X_12544_ net499 net662 _05373_ _05372_ VGND VGND VPWR VPWR _05557_ sky130_fd_sc_hd__a31o_1
XTAP_TAPCELL_ROW_42_878 VGND VPWR sky130_fd_sc_hd__tapvpwrvgnd_1
XTAP_TAPCELL_ROW_42_889 VGND VPWR sky130_fd_sc_hd__tapvpwrvgnd_1
XFILLER_129_237 VGND VGND VPWR VPWR sky130_fd_sc_hd__decap_4
X_12475_ _05132_ _05480_ _05481_ VGND VGND VPWR VPWR _05482_ sky130_fd_sc_hd__nor3_1
XFILLER_8_589 VGND VGND VPWR VPWR sky130_fd_sc_hd__fill_1
X_11426_ net417 _03586_ _03589_ _04218_ VGND VGND VPWR VPWR _04340_ sky130_fd_sc_hd__a2bb2o_1
XANTENNA_6 _02087_ VGND VGND VPWR VPWR sky130_fd_sc_hd__diode_2
XFILLER_113_605 VGND VGND VPWR VPWR sky130_fd_sc_hd__fill_2
XFILLER_99_806 VGND VGND VPWR VPWR sky130_fd_sc_hd__fill_2
X_11357_ _04047_ _04054_ _04053_ VGND VGND VPWR VPWR _04266_ sky130_fd_sc_hd__a21bo_1
X_10308_ _03116_ _03117_ _03119_ VGND VGND VPWR VPWR _03120_ sky130_fd_sc_hd__or3_1
XFILLER_3_261 VPWR VGND VPWR VGND sky130_ef_sc_hd__decap_12
XFILLER_112_148 VGND VGND VPWR VPWR sky130_fd_sc_hd__fill_1
XFILLER_106_690 VGND VGND VPWR VPWR sky130_fd_sc_hd__decap_8
X_11288_ _04075_ _04084_ _04083_ VGND VGND VPWR VPWR _04190_ sky130_fd_sc_hd__a21oi_1
X_13027_ _05818_ _06083_ VGND VGND VPWR VPWR _06086_ sky130_fd_sc_hd__xnor2_1
X_10239_ _03034_ _03035_ _03038_ net730 VGND VGND VPWR VPWR _03045_ sky130_fd_sc_hd__a211oi_2
XFILLER_120_181 VGND VGND VPWR VPWR sky130_fd_sc_hd__fill_1
XFILLER_94_533 VPWR VGND VPWR VGND sky130_ef_sc_hd__decap_12
XFILLER_66_224 VGND VGND VPWR VPWR sky130_fd_sc_hd__fill_1
XFILLER_39_449 VGND VGND VPWR VPWR sky130_fd_sc_hd__decap_4
XFILLER_82_717 VPWR VGND VPWR VGND sky130_ef_sc_hd__decap_12
Xrebuffer18 net717 VGND VGND VPWR VPWR net718 sky130_fd_sc_hd__dlymetal6s2s_1
Xrebuffer29 _04804_ VGND VGND VPWR VPWR net729 sky130_fd_sc_hd__dlygate4sd1_1
XFILLER_35_600 VGND VGND VPWR VPWR sky130_fd_sc_hd__fill_1
XFILLER_81_249 VPWR VGND VPWR VGND sky130_ef_sc_hd__decap_12
X_07450_ _00181_ _00190_ VGND VGND VPWR VPWR _00191_ sky130_fd_sc_hd__xor2_1
X_07381_ _06669_ _06670_ VGND VGND VPWR VPWR _06671_ sky130_fd_sc_hd__or2_1
XFILLER_22_327 VPWR VGND VPWR VGND sky130_ef_sc_hd__decap_12
X_09120_ net406 net555 net553 net414 VGND VGND VPWR VPWR _01845_ sky130_fd_sc_hd__a22o_1
X_09051_ _01773_ _01774_ VGND VGND VPWR VPWR _01776_ sky130_fd_sc_hd__xor2_1
Xrebuffer119 net818 VGND VGND VPWR VPWR net819 sky130_fd_sc_hd__dlygate4sd1_1
X_08002_ _00736_ _00738_ VGND VGND VPWR VPWR _00739_ sky130_fd_sc_hd__nand2_1
XPHY_EDGE_ROW_6_Right_6 VGND VGND VPWR VPWR sky130_fd_sc_hd__decap_3
XFILLER_116_421 VGND VGND VPWR VPWR sky130_fd_sc_hd__decap_8
XTAP_TAPCELL_ROW_96_1641 VGND VPWR sky130_fd_sc_hd__tapvpwrvgnd_1
Xmax_cap242 _06095_ VGND VGND VPWR VPWR net242 sky130_fd_sc_hd__buf_6
Xmax_cap231 _01311_ VGND VGND VPWR VPWR net231 sky130_fd_sc_hd__buf_1
XFILLER_131_446 VGND VGND VPWR VPWR sky130_fd_sc_hd__fill_2
X_09953_ _02579_ _02685_ _02683_ VGND VGND VPWR VPWR _02735_ sky130_fd_sc_hd__a21oi_1
X_08904_ _01353_ _01354_ _01480_ _01479_ _01469_ VGND VGND VPWR VPWR _01630_ sky130_fd_sc_hd__a32o_1
XFILLER_97_371 VGND VGND VPWR VPWR sky130_fd_sc_hd__decap_8
X_09884_ net415 _01822_ _01825_ _02554_ VGND VGND VPWR VPWR _02661_ sky130_fd_sc_hd__o22a_1
XFILLER_58_714 VGND VGND VPWR VPWR sky130_fd_sc_hd__decap_6
X_08835_ _01559_ _01560_ _01561_ VGND VGND VPWR VPWR _01562_ sky130_fd_sc_hd__nand3_1
XFILLER_66_29 VPWR VGND VPWR VGND sky130_ef_sc_hd__decap_12
XFILLER_58_736 VGND VGND VPWR VPWR sky130_fd_sc_hd__decap_8
X_08766_ net18 net627 net625 net536 VGND VGND VPWR VPWR _01493_ sky130_fd_sc_hd__a22o_1
XTAP_TAPCELL_ROW_123_2015 VGND VPWR sky130_fd_sc_hd__tapvpwrvgnd_1
X_07717_ _00307_ _00312_ _00311_ VGND VGND VPWR VPWR _00456_ sky130_fd_sc_hd__a21o_1
XFILLER_81_750 VPWR VGND VPWR VGND sky130_ef_sc_hd__decap_12
X_08697_ net732 VGND VGND VPWR VPWR _01425_ sky130_fd_sc_hd__inv_2
X_07648_ net714 _00383_ VGND VGND VPWR VPWR _00388_ sky130_fd_sc_hd__nand2_1
XTAP_TAPCELL_ROW_0_275 VGND VPWR sky130_fd_sc_hd__tapvpwrvgnd_1
XTAP_TAPCELL_ROW_0_286 VGND VPWR sky130_fd_sc_hd__tapvpwrvgnd_1
XTAP_TAPCELL_ROW_0_297 VGND VPWR sky130_fd_sc_hd__tapvpwrvgnd_1
XFILLER_25_143 VPWR VGND VPWR VGND sky130_ef_sc_hd__decap_12
XFILLER_26_699 VGND VGND VPWR VPWR sky130_fd_sc_hd__fill_1
XFILLER_41_625 VGND VGND VPWR VPWR sky130_fd_sc_hd__decap_3
X_07579_ _00316_ _00317_ VGND VGND VPWR VPWR _00319_ sky130_fd_sc_hd__nor2_1
XTAP_TAPCELL_ROW_105_1770 VGND VPWR sky130_fd_sc_hd__tapvpwrvgnd_1
XFILLER_15_55 VGND VGND VPWR VPWR sky130_fd_sc_hd__fill_1
X_09318_ _01677_ _02043_ VGND VGND VPWR VPWR _02046_ sky130_fd_sc_hd__xnor2_1
XFILLER_40_146 VGND VGND VPWR VPWR sky130_fd_sc_hd__decap_4
X_10590_ net400 net580 VGND VGND VPWR VPWR _03427_ sky130_fd_sc_hd__nand2_2
X_09249_ net479 net631 net629 net488 VGND VGND VPWR VPWR _01973_ sky130_fd_sc_hd__a22o_1
XFILLER_21_393 VGND VGND VPWR VPWR sky130_fd_sc_hd__fill_2
XTAP_TAPCELL_ROW_134_2166 VGND VPWR sky130_fd_sc_hd__tapvpwrvgnd_1
XFILLER_126_229 VGND VGND VPWR VPWR sky130_fd_sc_hd__decap_3
XFILLER_110_3 VPWR VGND VPWR VGND sky130_ef_sc_hd__decap_12
X_12260_ _05246_ _05224_ VGND VGND VPWR VPWR _05247_ sky130_fd_sc_hd__xor2_1
XFILLER_31_54 VGND VGND VPWR VPWR sky130_fd_sc_hd__fill_2
XFILLER_31_65 VGND VGND VPWR VPWR sky130_fd_sc_hd__decap_3
XFILLER_135_741 VPWR VGND VPWR VGND sky130_ef_sc_hd__decap_12
XTAP_TAPCELL_ROW_134_2177 VGND VPWR sky130_fd_sc_hd__tapvpwrvgnd_1
X_12191_ _05162_ _05170_ VGND VGND VPWR VPWR _05171_ sky130_fd_sc_hd__nand2_1
XFILLER_5_559 VGND VGND VPWR VPWR sky130_fd_sc_hd__fill_1
X_11211_ _03969_ _03991_ _03968_ VGND VGND VPWR VPWR _04106_ sky130_fd_sc_hd__a21oi_1
XFILLER_135_785 VPWR VGND VPWR VGND sky130_ef_sc_hd__decap_12
XFILLER_134_251 VGND VGND VPWR VPWR sky130_fd_sc_hd__fill_1
XFILLER_107_476 VPWR VGND VPWR VGND sky130_ef_sc_hd__decap_12
X_11142_ net565 net274 _04028_ VGND VGND VPWR VPWR _04030_ sky130_fd_sc_hd__and3_1
XFILLER_1_721 VGND VGND VPWR VPWR sky130_fd_sc_hd__decap_6
XFILLER_95_319 VPWR VGND VPWR VGND sky130_ef_sc_hd__decap_12
XFILLER_76_500 VGND VGND VPWR VPWR sky130_fd_sc_hd__decap_8
XFILLER_49_725 VGND VGND VPWR VPWR sky130_fd_sc_hd__decap_3
XFILLER_0_253 VGND VGND VPWR VPWR sky130_fd_sc_hd__fill_2
XFILLER_1_765 VPWR VGND VPWR VGND sky130_ef_sc_hd__decap_12
X_11073_ _03822_ _03823_ _03825_ VGND VGND VPWR VPWR _03955_ sky130_fd_sc_hd__o21bai_2
Xinput110 w21[4] VGND VGND VPWR VPWR net110 sky130_fd_sc_hd__clkbuf_2
Xinput132 w30[2] VGND VGND VPWR VPWR net132 sky130_fd_sc_hd__dlymetal6s2s_1
Xinput154 w33[0] VGND VGND VPWR VPWR net154 sky130_fd_sc_hd__buf_1
XFILLER_76_533 VGND VGND VPWR VPWR sky130_fd_sc_hd__decap_6
X_10024_ _02784_ _02808_ VGND VGND VPWR VPWR _02810_ sky130_fd_sc_hd__nand2b_1
Xinput143 w31[5] VGND VGND VPWR VPWR net143 sky130_fd_sc_hd__buf_1
Xinput121 w22[7] VGND VGND VPWR VPWR net121 sky130_fd_sc_hd__clkbuf_2
XFILLER_91_503 VGND VGND VPWR VPWR sky130_fd_sc_hd__fill_1
XTAP_TAPCELL_ROW_47_948 VGND VPWR sky130_fd_sc_hd__tapvpwrvgnd_1
XFILLER_17_622 VGND VGND VPWR VPWR sky130_fd_sc_hd__decap_4
XTAP_TAPCELL_ROW_67_1231 VGND VPWR sky130_fd_sc_hd__tapvpwrvgnd_1
XTAP_TAPCELL_ROW_47_959 VGND VPWR sky130_fd_sc_hd__tapvpwrvgnd_1
X_11975_ _04934_ _04935_ VGND VGND VPWR VPWR _04936_ sky130_fd_sc_hd__nor2_1
X_10926_ _03792_ _03793_ VGND VGND VPWR VPWR _03794_ sky130_fd_sc_hd__nand2_1
XTAP_TAPCELL_ROW_80_1420 VGND VPWR sky130_fd_sc_hd__tapvpwrvgnd_1
XTAP_TAPCELL_ROW_27_672 VGND VPWR sky130_fd_sc_hd__tapvpwrvgnd_1
XFILLER_31_113 VPWR VGND VPWR VGND sky130_ef_sc_hd__decap_12
X_10857_ _03549_ _03551_ _03548_ VGND VGND VPWR VPWR _03719_ sky130_fd_sc_hd__a21o_1
XFILLER_72_72 VGND VGND VPWR VPWR sky130_fd_sc_hd__decap_6
XPHY_EDGE_ROW_59_Right_59 VGND VGND VPWR VPWR sky130_fd_sc_hd__decap_3
XFILLER_12_382 VPWR VGND VPWR VGND sky130_ef_sc_hd__decap_12
X_10788_ net356 net331 net348 net346 VGND VGND VPWR VPWR _03644_ sky130_fd_sc_hd__and4_1
XFILLER_40_691 VGND VGND VPWR VPWR sky130_fd_sc_hd__decap_8
X_12527_ _05497_ _05537_ VGND VGND VPWR VPWR _05539_ sky130_fd_sc_hd__nand2_1
X_12458_ _05463_ VGND VGND VPWR VPWR _05464_ sky130_fd_sc_hd__inv_2
XFILLER_125_240 VGND VGND VPWR VPWR sky130_fd_sc_hd__fill_1
X_11409_ _04179_ _04181_ _04321_ VGND VGND VPWR VPWR _04322_ sky130_fd_sc_hd__a21oi_1
XTAP_TAPCELL_ROW_78_1393 VGND VPWR sky130_fd_sc_hd__tapvpwrvgnd_1
XTAP_TAPCELL_ROW_78_1382 VGND VPWR sky130_fd_sc_hd__tapvpwrvgnd_1
X_12389_ net478 net676 VGND VGND VPWR VPWR _05388_ sky130_fd_sc_hd__and2_2
XFILLER_113_435 VGND VGND VPWR VPWR sky130_fd_sc_hd__fill_1
XFILLER_4_581 VGND VGND VPWR VPWR sky130_fd_sc_hd__decap_6
X_06950_ _04916_ _04960_ _04971_ VGND VGND VPWR VPWR _04982_ sky130_fd_sc_hd__nor3b_2
XTAP_TAPCELL_ROW_91_1571 VGND VPWR sky130_fd_sc_hd__tapvpwrvgnd_1
X_06881_ _04199_ _04210_ _04221_ VGND VGND VPWR VPWR _04232_ sky130_fd_sc_hd__nand3_1
XPHY_EDGE_ROW_68_Right_68 VGND VGND VPWR VPWR sky130_fd_sc_hd__decap_3
X_08620_ _01346_ _01347_ VGND VGND VPWR VPWR _01348_ sky130_fd_sc_hd__nand2_1
XFILLER_55_739 VPWR VGND VPWR VGND sky130_ef_sc_hd__decap_12
XFILLER_82_547 VGND VGND VPWR VPWR sky130_fd_sc_hd__decap_6
X_08551_ net439 net558 _01277_ _01278_ VGND VGND VPWR VPWR _01280_ sky130_fd_sc_hd__a22o_1
X_08482_ net535 net628 VGND VGND VPWR VPWR _01211_ sky130_fd_sc_hd__nand2_1
X_07502_ _00235_ _00236_ _00241_ VGND VGND VPWR VPWR _00243_ sky130_fd_sc_hd__nand3_2
X_07433_ _00172_ _00173_ VGND VGND VPWR VPWR _00174_ sky130_fd_sc_hd__and2b_1
XFILLER_23_625 VGND VGND VPWR VPWR sky130_fd_sc_hd__decap_4
XPHY_EDGE_ROW_77_Right_77 VGND VGND VPWR VPWR sky130_fd_sc_hd__decap_3
XFILLER_11_809 VGND VGND VPWR VPWR sky130_fd_sc_hd__fill_2
XFILLER_23_669 VGND VGND VPWR VPWR sky130_fd_sc_hd__decap_3
X_07364_ _06491_ _06494_ VGND VGND VPWR VPWR _06655_ sky130_fd_sc_hd__nor2_1
X_09103_ _01820_ _01826_ VGND VGND VPWR VPWR _01828_ sky130_fd_sc_hd__xor2_1
XFILLER_50_477 VGND VGND VPWR VPWR sky130_fd_sc_hd__decap_3
XFILLER_31_680 VGND VGND VPWR VPWR sky130_fd_sc_hd__decap_4
XFILLER_136_505 VPWR VGND VPWR VGND sky130_ef_sc_hd__decap_12
X_07295_ _06445_ _06447_ VGND VGND VPWR VPWR _06586_ sky130_fd_sc_hd__nand2_1
X_09034_ _01756_ _01757_ VGND VGND VPWR VPWR _01759_ sky130_fd_sc_hd__and2_1
XFILLER_117_785 VPWR VGND VPWR VGND sky130_ef_sc_hd__decap_12
XFILLER_104_402 VGND VGND VPWR VPWR sky130_fd_sc_hd__decap_8
XFILLER_89_113 VPWR VGND VPWR VGND sky130_ef_sc_hd__decap_12
XFILLER_132_755 VGND VGND VPWR VPWR sky130_fd_sc_hd__fill_1
XFILLER_117_57 VPWR VGND VPWR VGND sky130_ef_sc_hd__decap_12
X_09936_ _02712_ _02717_ VGND VGND VPWR VPWR _02718_ sky130_fd_sc_hd__xor2_1
XFILLER_89_179 VPWR VGND VPWR VGND sky130_ef_sc_hd__decap_12
XPHY_EDGE_ROW_86_Right_86 VGND VGND VPWR VPWR sky130_fd_sc_hd__decap_3
XTAP_TAPCELL_ROW_51_1010 VGND VPWR sky130_fd_sc_hd__tapvpwrvgnd_1
XFILLER_100_630 VPWR VGND VPWR VGND sky130_ef_sc_hd__decap_12
X_09867_ _02638_ _02641_ VGND VGND VPWR VPWR _02643_ sky130_fd_sc_hd__xor2_1
XTAP_TAPCELL_ROW_5_367 VGND VPWR sky130_fd_sc_hd__tapvpwrvgnd_1
XFILLER_100_696 VGND VGND VPWR VPWR sky130_fd_sc_hd__decap_4
X_09798_ _02567_ _02543_ VGND VGND VPWR VPWR _02568_ sky130_fd_sc_hd__and2b_1
XFILLER_73_503 VGND VGND VPWR VPWR sky130_fd_sc_hd__fill_1
X_08818_ _01540_ _01543_ VGND VGND VPWR VPWR _01545_ sky130_fd_sc_hd__xnor2_1
XFILLER_46_739 VGND VGND VPWR VPWR sky130_fd_sc_hd__fill_1
X_08749_ net644 net260 _01350_ _01349_ VGND VGND VPWR VPWR _01476_ sky130_fd_sc_hd__a31o_1
XFILLER_45_238 VGND VGND VPWR VPWR sky130_fd_sc_hd__decap_3
XFILLER_39_791 VGND VGND VPWR VPWR sky130_fd_sc_hd__fill_1
X_11760_ _04688_ _04696_ VGND VGND VPWR VPWR _04701_ sky130_fd_sc_hd__xnor2_1
XTAP_TAPCELL_ROW_44_907 VGND VPWR sky130_fd_sc_hd__tapvpwrvgnd_1
XFILLER_26_65 VGND VGND VPWR VPWR sky130_fd_sc_hd__fill_2
XPHY_EDGE_ROW_95_Right_95 VGND VGND VPWR VPWR sky130_fd_sc_hd__decap_3
X_10711_ _03556_ _03557_ VGND VGND VPWR VPWR _03559_ sky130_fd_sc_hd__xnor2_1
XFILLER_13_113 VGND VGND VPWR VPWR sky130_fd_sc_hd__decap_6
XFILLER_26_76 VGND VGND VPWR VPWR sky130_fd_sc_hd__decap_8
X_11691_ _04586_ _04625_ VGND VGND VPWR VPWR _04626_ sky130_fd_sc_hd__xnor2_1
XFILLER_14_669 VPWR VGND VPWR VGND sky130_ef_sc_hd__decap_12
XTAP_TAPCELL_ROW_24_631 VGND VPWR sky130_fd_sc_hd__tapvpwrvgnd_1
XTAP_TAPCELL_ROW_136_2217 VGND VPWR sky130_fd_sc_hd__tapvpwrvgnd_1
XTAP_TAPCELL_ROW_136_2206 VGND VPWR sky130_fd_sc_hd__tapvpwrvgnd_1
XTAP_TAPCELL_ROW_62_1161 VGND VPWR sky130_fd_sc_hd__tapvpwrvgnd_1
X_10642_ _03482_ _03483_ VGND VGND VPWR VPWR _03484_ sky130_fd_sc_hd__nand2b_1
XFILLER_9_139 VPWR VGND VPWR VGND sky130_ef_sc_hd__decap_12
XFILLER_41_488 VPWR VGND VPWR VGND sky130_ef_sc_hd__decap_12
X_13361_ clknet_3_3__leaf_clk _00048_ _00071_ VGND VGND VPWR VPWR net175 sky130_fd_sc_hd__dfrtp_1
XFILLER_127_505 VGND VGND VPWR VPWR sky130_fd_sc_hd__decap_8
X_10573_ net450 net562 _03405_ _03406_ VGND VGND VPWR VPWR _03408_ sky130_fd_sc_hd__nand4_1
X_13292_ net399 VGND VGND VPWR VPWR _00066_ sky130_fd_sc_hd__inv_2
XFILLER_127_538 VGND VGND VPWR VPWR sky130_fd_sc_hd__decap_8
Xrebuffer9 _01441_ VGND VGND VPWR VPWR net709 sky130_fd_sc_hd__dlygate4sd1_1
X_12312_ _05124_ _05302_ VGND VGND VPWR VPWR _05304_ sky130_fd_sc_hd__xor2_2
XTAP_TAPCELL_ROW_118_1950 VGND VPWR sky130_fd_sc_hd__tapvpwrvgnd_1
X_12243_ net405 net601 net599 net413 VGND VGND VPWR VPWR _05228_ sky130_fd_sc_hd__a22oi_1
XFILLER_107_273 VGND VGND VPWR VPWR sky130_fd_sc_hd__fill_1
XFILLER_122_221 VGND VGND VPWR VPWR sky130_fd_sc_hd__fill_1
X_12174_ _05004_ _05151_ VGND VGND VPWR VPWR _05152_ sky130_fd_sc_hd__xnor2_1
X_11125_ _03508_ _03852_ _03851_ VGND VGND VPWR VPWR _04012_ sky130_fd_sc_hd__a21boi_2
XFILLER_67_50 VGND VGND VPWR VPWR sky130_fd_sc_hd__decap_6
XFILLER_1_573 VPWR VGND VPWR VGND sky130_ef_sc_hd__decap_12
XFILLER_3_69 VPWR VGND VPWR VGND sky130_ef_sc_hd__decap_12
X_11056_ _03934_ _03935_ VGND VGND VPWR VPWR _03936_ sky130_fd_sc_hd__or2_1
XFILLER_103_490 VPWR VGND VPWR VGND sky130_ef_sc_hd__decap_12
X_10007_ _02790_ VGND VGND VPWR VPWR _02792_ sky130_fd_sc_hd__inv_2
XFILLER_49_566 VPWR VGND VPWR VGND sky130_ef_sc_hd__decap_12
XFILLER_67_94 VGND VGND VPWR VPWR sky130_fd_sc_hd__decap_8
XFILLER_45_750 VGND VGND VPWR VPWR sky130_fd_sc_hd__decap_8
X_11958_ net437 net446 net598 net589 VGND VGND VPWR VPWR _04918_ sky130_fd_sc_hd__and4_1
X_11889_ _04841_ _04842_ VGND VGND VPWR VPWR _04843_ sky130_fd_sc_hd__nand2b_4
X_10909_ _03761_ _03775_ VGND VGND VPWR VPWR _03776_ sky130_fd_sc_hd__xnor2_1
XFILLER_32_499 VGND VGND VPWR VPWR sky130_fd_sc_hd__decap_3
XFILLER_9_651 VGND VGND VPWR VPWR sky130_fd_sc_hd__decap_3
X_07080_ _06370_ _06371_ VGND VGND VPWR VPWR _06372_ sky130_fd_sc_hd__xnor2_1
XFILLER_73_3 VGND VGND VPWR VPWR sky130_fd_sc_hd__fill_2
XFILLER_9_673 VGND VGND VPWR VPWR sky130_fd_sc_hd__decap_8
XTAP_TAPCELL_ROW_93_1600 VGND VPWR sky130_fd_sc_hd__tapvpwrvgnd_1
XFILLER_8_194 VGND VGND VPWR VPWR sky130_fd_sc_hd__fill_2
XFILLER_114_755 VGND VGND VPWR VPWR sky130_fd_sc_hd__fill_1
XFILLER_113_221 VGND VGND VPWR VPWR sky130_fd_sc_hd__decap_3
XFILLER_87_617 VGND VGND VPWR VPWR sky130_fd_sc_hd__decap_4
X_07982_ net309 net374 _02142_ net332 VGND VGND VPWR VPWR _00719_ sky130_fd_sc_hd__o2bb2a_1
X_09721_ _02448_ _02483_ VGND VGND VPWR VPWR _02484_ sky130_fd_sc_hd__nand2_1
XFILLER_113_287 VGND VGND VPWR VPWR sky130_fd_sc_hd__decap_4
X_06933_ _04741_ _04763_ _04774_ VGND VGND VPWR VPWR _04796_ sky130_fd_sc_hd__or3_4
XFILLER_86_149 VGND VGND VPWR VPWR sky130_fd_sc_hd__fill_1
XFILLER_103_15 VGND VGND VPWR VPWR sky130_fd_sc_hd__decap_8
X_06864_ _03981_ _04024_ VGND VGND VPWR VPWR _04046_ sky130_fd_sc_hd__xnor2_1
X_09652_ _02401_ _02407_ VGND VGND VPWR VPWR _02408_ sky130_fd_sc_hd__nand2b_1
XTAP_TAPCELL_ROW_2_326 VGND VPWR sky130_fd_sc_hd__tapvpwrvgnd_1
X_09583_ _01974_ _02140_ _02332_ VGND VGND VPWR VPWR _02334_ sky130_fd_sc_hd__and3_1
X_06795_ _02932_ _03270_ _03281_ VGND VGND VPWR VPWR _03292_ sky130_fd_sc_hd__a21o_1
X_08603_ _01328_ _01324_ _01329_ VGND VGND VPWR VPWR _01332_ sky130_fd_sc_hd__a21oi_2
XFILLER_82_333 VPWR VGND VPWR VGND sky130_ef_sc_hd__decap_12
XFILLER_82_377 VGND VGND VPWR VPWR sky130_fd_sc_hd__decap_4
X_08534_ net518 net60 VGND VGND VPWR VPWR _01263_ sky130_fd_sc_hd__nand2_1
X_08465_ _01188_ _01193_ VGND VGND VPWR VPWR _01194_ sky130_fd_sc_hd__nor2_1
XFILLER_51_753 VGND VGND VPWR VPWR sky130_fd_sc_hd__decap_4
X_07416_ _06390_ _06540_ _06538_ VGND VGND VPWR VPWR _00157_ sky130_fd_sc_hd__o21a_1
X_08396_ _01124_ _01125_ VGND VGND VPWR VPWR _01126_ sky130_fd_sc_hd__and2b_1
XFILLER_109_505 VGND VGND VPWR VPWR sky130_fd_sc_hd__decap_4
X_07347_ _06607_ _06636_ VGND VGND VPWR VPWR _06638_ sky130_fd_sc_hd__xnor2_1
XFILLER_109_538 VGND VGND VPWR VPWR sky130_fd_sc_hd__decap_4
X_09017_ _01741_ _01742_ VGND VGND VPWR VPWR _01743_ sky130_fd_sc_hd__nand2_1
X_07278_ net436 net608 net606 net445 VGND VGND VPWR VPWR _06569_ sky130_fd_sc_hd__a22o_1
XTAP_TAPCELL_ROW_131_2125 VGND VPWR sky130_fd_sc_hd__tapvpwrvgnd_1
XFILLER_105_744 VPWR VGND VPWR VGND sky130_ef_sc_hd__decap_12
XFILLER_105_733 VGND VGND VPWR VPWR sky130_fd_sc_hd__fill_1
XFILLER_120_725 VGND VGND VPWR VPWR sky130_fd_sc_hd__decap_8
XTAP_TAPCELL_ROW_113_1880 VGND VPWR sky130_fd_sc_hd__tapvpwrvgnd_1
Xfanout630 net125 VGND VGND VPWR VPWR net630 sky130_fd_sc_hd__clkbuf_2
Xfanout641 net646 VGND VGND VPWR VPWR net641 sky130_fd_sc_hd__clkbuf_2
XFILLER_120_769 VPWR VGND VPWR VGND sky130_ef_sc_hd__decap_12
X_09919_ _02596_ _02598_ _02698_ VGND VGND VPWR VPWR _02700_ sky130_fd_sc_hd__and3_1
Xfanout685 net100 VGND VGND VPWR VPWR net685 sky130_fd_sc_hd__clkbuf_2
Xfanout663 net671 VGND VGND VPWR VPWR net663 sky130_fd_sc_hd__clkbuf_4
Xfanout652 net116 VGND VGND VPWR VPWR net652 sky130_fd_sc_hd__clkbuf_4
Xfanout674 net108 VGND VGND VPWR VPWR net674 sky130_fd_sc_hd__buf_2
XTAP_TAPCELL_ROW_129_2098 VGND VPWR sky130_fd_sc_hd__tapvpwrvgnd_1
XFILLER_85_160 VGND VGND VPWR VPWR sky130_fd_sc_hd__fill_1
XFILLER_73_311 VGND VGND VPWR VPWR sky130_fd_sc_hd__decap_3
Xfanout696 net697 VGND VGND VPWR VPWR net696 sky130_fd_sc_hd__clkbuf_2
X_12930_ _05972_ _05977_ VGND VGND VPWR VPWR _05979_ sky130_fd_sc_hd__xor2_1
XFILLER_18_216 VPWR VGND VPWR VGND sky130_ef_sc_hd__decap_12
XTAP_TAPCELL_ROW_29_701 VGND VPWR sky130_fd_sc_hd__tapvpwrvgnd_1
X_12861_ _05771_ _05792_ _05770_ VGND VGND VPWR VPWR _05904_ sky130_fd_sc_hd__a21oi_1
XFILLER_37_53 VGND VGND VPWR VPWR sky130_fd_sc_hd__decap_3
X_11812_ _04751_ _04755_ VGND VGND VPWR VPWR _04758_ sky130_fd_sc_hd__nor2_1
X_12792_ _05667_ _05672_ _05670_ VGND VGND VPWR VPWR _05828_ sky130_fd_sc_hd__o21ba_1
XFILLER_27_783 VGND VGND VPWR VPWR sky130_fd_sc_hd__fill_1
X_11743_ net690 net76 VGND VGND VPWR VPWR _04682_ sky130_fd_sc_hd__nand2_1
XFILLER_53_30 VGND VGND VPWR VPWR sky130_fd_sc_hd__fill_1
X_11674_ _04606_ _04607_ VGND VGND VPWR VPWR _04608_ sky130_fd_sc_hd__or2_1
XFILLER_14_477 VGND VGND VPWR VPWR sky130_fd_sc_hd__fill_1
XFILLER_14_499 VGND VGND VPWR VPWR sky130_fd_sc_hd__fill_1
X_13413_ clknet_3_6__leaf_clk _00053_ _00123_ VGND VGND VPWR VPWR net212 sky130_fd_sc_hd__dfrtp_1
X_10625_ net89 net342 VGND VGND VPWR VPWR _03465_ sky130_fd_sc_hd__xor2_1
XFILLER_127_335 VGND VGND VPWR VPWR sky130_fd_sc_hd__fill_1
X_13344_ net398 VGND VGND VPWR VPWR _00118_ sky130_fd_sc_hd__inv_2
X_10556_ _03387_ _03388_ VGND VGND VPWR VPWR _03389_ sky130_fd_sc_hd__and2b_1
XFILLER_10_694 VGND VGND VPWR VPWR sky130_fd_sc_hd__decap_6
XFILLER_6_643 VGND VGND VPWR VPWR sky130_fd_sc_hd__fill_1
X_10487_ _03312_ _03311_ _03254_ VGND VGND VPWR VPWR _03315_ sky130_fd_sc_hd__a21o_1
X_13275_ _06344_ _06353_ VGND VGND VPWR VPWR _06354_ sky130_fd_sc_hd__xnor2_1
XTAP_TAPCELL_ROW_75_1341 VGND VPWR sky130_fd_sc_hd__tapvpwrvgnd_1
X_12226_ _05206_ _05207_ _05203_ VGND VGND VPWR VPWR _05209_ sky130_fd_sc_hd__a21o_1
XFILLER_69_617 VPWR VGND VPWR VGND sky130_ef_sc_hd__decap_12
X_12157_ _04999_ _05131_ VGND VGND VPWR VPWR _05134_ sky130_fd_sc_hd__xnor2_1
XFILLER_68_116 VGND VGND VPWR VPWR sky130_fd_sc_hd__fill_2
XFILLER_1_370 VPWR VGND VPWR VGND sky130_ef_sc_hd__decap_12
X_11108_ _03800_ _03834_ _03833_ VGND VGND VPWR VPWR _03994_ sky130_fd_sc_hd__a21bo_1
XFILLER_110_246 VGND VGND VPWR VPWR sky130_fd_sc_hd__decap_6
X_12088_ _05057_ _05059_ VGND VGND VPWR VPWR _05060_ sky130_fd_sc_hd__and2b_1
XFILLER_110_279 VPWR VGND VPWR VGND sky130_ef_sc_hd__decap_12
X_11039_ net482 net649 VGND VGND VPWR VPWR _03918_ sky130_fd_sc_hd__nand2_1
XFILLER_37_503 VGND VGND VPWR VPWR sky130_fd_sc_hd__fill_1
XFILLER_37_525 VGND VGND VPWR VPWR sky130_fd_sc_hd__fill_1
XFILLER_37_558 VGND VGND VPWR VPWR sky130_fd_sc_hd__fill_2
XFILLER_94_92 VPWR VGND VPWR VGND sky130_ef_sc_hd__decap_12
XFILLER_64_377 VPWR VGND VPWR VGND sky130_ef_sc_hd__decap_12
XFILLER_52_506 VGND VGND VPWR VPWR sky130_fd_sc_hd__fill_1
XFILLER_25_709 VPWR VGND VPWR VGND sky130_ef_sc_hd__decap_12
XTAP_TAPCELL_ROW_86_1492 VGND VPWR sky130_fd_sc_hd__tapvpwrvgnd_1
XFILLER_52_539 VGND VGND VPWR VPWR sky130_fd_sc_hd__fill_1
XFILLER_17_293 VGND VGND VPWR VPWR sky130_fd_sc_hd__decap_4
XFILLER_33_742 VGND VGND VPWR VPWR sky130_fd_sc_hd__fill_2
X_08250_ _00963_ _00984_ VGND VGND VPWR VPWR _00985_ sky130_fd_sc_hd__xnor2_1
X_08181_ _00903_ _00915_ _00916_ VGND VGND VPWR VPWR _00917_ sky130_fd_sc_hd__or3_1
X_07201_ _06490_ _06489_ net916 _06194_ VGND VGND VPWR VPWR _06493_ sky130_fd_sc_hd__a211o_4
XFILLER_118_302 VGND VGND VPWR VPWR sky130_fd_sc_hd__decap_3
X_07132_ _03270_ _03817_ _05516_ VGND VGND VPWR VPWR _06424_ sky130_fd_sc_hd__o21ba_1
XFILLER_20_469 VGND VGND VPWR VPWR sky130_fd_sc_hd__decap_6
X_07063_ _04807_ _04829_ _06205_ net228 VGND VGND VPWR VPWR _06216_ sky130_fd_sc_hd__a211o_4
Xoutput200 net200 VGND VGND VPWR VPWR out2[15] sky130_fd_sc_hd__buf_2
XFILLER_133_349 VPWR VGND VPWR VGND sky130_ef_sc_hd__decap_12
XFILLER_133_327 VGND VGND VPWR VPWR sky130_fd_sc_hd__decap_8
Xoutput211 net211 VGND VGND VPWR VPWR out3[10] sky130_fd_sc_hd__buf_2
XFILLER_114_530 VGND VGND VPWR VPWR sky130_fd_sc_hd__fill_2
Xoutput222 net222 VGND VGND VPWR VPWR out3[6] sky130_fd_sc_hd__buf_2
XFILLER_114_541 VGND VGND VPWR VPWR sky130_fd_sc_hd__fill_1
XFILLER_102_714 VGND VGND VPWR VPWR sky130_fd_sc_hd__fill_2
XFILLER_99_274 VGND VGND VPWR VPWR sky130_fd_sc_hd__decap_6
X_07965_ _00701_ _00702_ VGND VGND VPWR VPWR _00703_ sky130_fd_sc_hd__nand2_1
X_09704_ _01950_ _02264_ _02266_ VGND VGND VPWR VPWR _02465_ sky130_fd_sc_hd__o21ai_1
XFILLER_101_279 VGND VGND VPWR VPWR sky130_fd_sc_hd__fill_1
X_06916_ _02813_ _04505_ net918 VGND VGND VPWR VPWR _04611_ sky130_fd_sc_hd__nand3_2
XFILLER_95_491 VGND VGND VPWR VPWR sky130_fd_sc_hd__fill_1
XFILLER_74_29 VGND VGND VPWR VPWR sky130_fd_sc_hd__fill_1
X_07896_ _00625_ _00633_ VGND VGND VPWR VPWR _00634_ sky130_fd_sc_hd__and2b_1
X_09635_ _02385_ _02389_ VGND VGND VPWR VPWR _02390_ sky130_fd_sc_hd__nor2_1
X_06847_ _03281_ _03850_ VGND VGND VPWR VPWR _03860_ sky130_fd_sc_hd__nand2b_1
XFILLER_82_141 VGND VGND VPWR VPWR sky130_fd_sc_hd__decap_3
X_06778_ _02664_ _03096_ VGND VGND VPWR VPWR _03107_ sky130_fd_sc_hd__nand2_1
X_09566_ _02306_ _02314_ VGND VGND VPWR VPWR _02315_ sky130_fd_sc_hd__xor2_2
XFILLER_55_388 VGND VGND VPWR VPWR sky130_fd_sc_hd__decap_4
X_09497_ _02128_ _02161_ _02160_ VGND VGND VPWR VPWR _02241_ sky130_fd_sc_hd__a21o_1
X_08517_ net474 net552 _01238_ _01239_ VGND VGND VPWR VPWR _01246_ sky130_fd_sc_hd__o2bb2a_1
XFILLER_23_230 VPWR VGND VPWR VGND sky130_ef_sc_hd__decap_12
X_08448_ net270 net258 VGND VGND VPWR VPWR _01177_ sky130_fd_sc_hd__nand2_1
XTAP_TAPCELL_ROW_34_770 VGND VPWR sky130_fd_sc_hd__tapvpwrvgnd_1
XPHY_EDGE_ROW_122_Left_259 VGND VGND VPWR VPWR sky130_fd_sc_hd__decap_3
X_08379_ _01088_ _01109_ VGND VGND VPWR VPWR _01110_ sky130_fd_sc_hd__nor2_1
X_10410_ net520 net118 VGND VGND VPWR VPWR _03230_ sky130_fd_sc_hd__nand2_1
XFILLER_23_88 VGND VGND VPWR VPWR sky130_fd_sc_hd__decap_6
XFILLER_109_324 VGND VGND VPWR VPWR sky130_fd_sc_hd__decap_6
X_11390_ _03426_ _04176_ _04175_ VGND VGND VPWR VPWR _04301_ sky130_fd_sc_hd__a21oi_1
XFILLER_136_165 VGND VGND VPWR VPWR sky130_fd_sc_hd__decap_3
X_10341_ net705 _03153_ _03132_ VGND VGND VPWR VPWR _03156_ sky130_fd_sc_hd__o21a_1
X_10272_ _03078_ _03079_ VGND VGND VPWR VPWR _03080_ sky130_fd_sc_hd__xnor2_1
X_13060_ _05978_ _05980_ _06120_ VGND VGND VPWR VPWR _06121_ sky130_fd_sc_hd__a21oi_1
X_12011_ _04972_ _04973_ _04855_ VGND VGND VPWR VPWR _04976_ sky130_fd_sc_hd__o21ai_2
XFILLER_3_3 VPWR VGND VPWR VGND sky130_ef_sc_hd__decap_12
XFILLER_105_574 VGND VGND VPWR VPWR sky130_fd_sc_hd__decap_8
XTAP_TAPCELL_ROW_57_1093 VGND VPWR sky130_fd_sc_hd__tapvpwrvgnd_1
XFILLER_2_189 VGND VGND VPWR VPWR sky130_fd_sc_hd__decap_6
XPHY_EDGE_ROW_131_Left_268 VGND VGND VPWR VPWR sky130_fd_sc_hd__decap_3
XFILLER_120_533 VPWR VGND VPWR VGND sky130_ef_sc_hd__decap_12
XFILLER_48_41 VGND VGND VPWR VPWR sky130_fd_sc_hd__decap_6
XFILLER_120_599 VPWR VGND VPWR VGND sky130_ef_sc_hd__decap_12
Xfanout493 net494 VGND VGND VPWR VPWR net493 sky130_fd_sc_hd__buf_2
Xfanout460 net461 VGND VGND VPWR VPWR net460 sky130_fd_sc_hd__buf_2
XTAP_TAPCELL_ROW_70_1271 VGND VPWR sky130_fd_sc_hd__tapvpwrvgnd_1
XFILLER_59_683 VGND VGND VPWR VPWR sky130_fd_sc_hd__decap_4
Xfanout482 net825 VGND VGND VPWR VPWR net482 sky130_fd_sc_hd__buf_2
Xfanout471 net472 VGND VGND VPWR VPWR net471 sky130_fd_sc_hd__buf_2
XFILLER_0_15 VPWR VGND VPWR VGND sky130_ef_sc_hd__decap_12
X_12913_ _05823_ _05859_ _05861_ VGND VGND VPWR VPWR _05960_ sky130_fd_sc_hd__a21oi_1
XFILLER_73_141 VPWR VGND VPWR VGND sky130_ef_sc_hd__decap_12
XFILLER_0_37 VPWR VGND VPWR VGND sky130_ef_sc_hd__decap_12
XFILLER_19_569 VGND VGND VPWR VPWR sky130_fd_sc_hd__decap_8
XFILLER_46_399 VPWR VGND VPWR VGND sky130_ef_sc_hd__decap_12
X_12844_ _05755_ _05766_ _05754_ VGND VGND VPWR VPWR _05885_ sky130_fd_sc_hd__o21ai_1
XFILLER_61_347 VGND VGND VPWR VPWR sky130_fd_sc_hd__fill_2
X_12775_ _05661_ _05809_ VGND VGND VPWR VPWR _05810_ sky130_fd_sc_hd__xnor2_1
X_11726_ _04661_ _04662_ _04613_ VGND VGND VPWR VPWR _04664_ sky130_fd_sc_hd__o21bai_1
XFILLER_42_561 VGND VGND VPWR VPWR sky130_fd_sc_hd__decap_4
X_11657_ _04575_ _04588_ VGND VGND VPWR VPWR _04590_ sky130_fd_sc_hd__nand2_1
XTAP_TAPCELL_ROW_12_464 VGND VPWR sky130_fd_sc_hd__tapvpwrvgnd_1
X_11588_ _04515_ _04517_ VGND VGND VPWR VPWR _04518_ sky130_fd_sc_hd__nand2b_1
X_10608_ _03283_ _03444_ VGND VGND VPWR VPWR _03447_ sky130_fd_sc_hd__xor2_1
XFILLER_128_699 VGND VGND VPWR VPWR sky130_fd_sc_hd__fill_1
X_13327_ net392 VGND VGND VPWR VPWR _00101_ sky130_fd_sc_hd__inv_2
X_10539_ _03364_ _03370_ VGND VGND VPWR VPWR _03371_ sky130_fd_sc_hd__xor2_1
XFILLER_6_451 VGND VGND VPWR VPWR sky130_fd_sc_hd__decap_4
XFILLER_115_349 VGND VGND VPWR VPWR sky130_fd_sc_hd__decap_4
XFILLER_131_809 VGND VGND VPWR VPWR sky130_fd_sc_hd__fill_2
X_13258_ _06332_ _06335_ VGND VGND VPWR VPWR _06336_ sky130_fd_sc_hd__xnor2_1
XFILLER_97_734 VPWR VGND VPWR VGND sky130_ef_sc_hd__decap_12
X_13189_ _06249_ _06261_ VGND VGND VPWR VPWR _06262_ sky130_fd_sc_hd__xnor2_1
X_12209_ net462 net581 VGND VGND VPWR VPWR _05191_ sky130_fd_sc_hd__nand2_1
XFILLER_123_393 VPWR VGND VPWR VGND sky130_ef_sc_hd__decap_12
X_07750_ _00335_ _00338_ VGND VGND VPWR VPWR _00489_ sky130_fd_sc_hd__and2_1
XTAP_TAPCELL_ROW_88_1532 VGND VPWR sky130_fd_sc_hd__tapvpwrvgnd_1
XTAP_TAPCELL_ROW_88_1521 VGND VPWR sky130_fd_sc_hd__tapvpwrvgnd_1
XFILLER_84_439 VPWR VGND VPWR VGND sky130_ef_sc_hd__decap_12
X_06701_ net81 VGND VGND VPWR VPWR _02273_ sky130_fd_sc_hd__inv_2
X_07681_ _00419_ _00418_ _00262_ _00264_ VGND VGND VPWR VPWR _00421_ sky130_fd_sc_hd__a211o_1
XFILLER_64_141 VGND VGND VPWR VPWR sky130_fd_sc_hd__decap_4
XFILLER_37_355 VGND VGND VPWR VPWR sky130_fd_sc_hd__fill_1
X_09420_ _02155_ _02156_ VGND VGND VPWR VPWR _02157_ sky130_fd_sc_hd__or2_1
XFILLER_92_483 VGND VGND VPWR VPWR sky130_fd_sc_hd__decap_6
XFILLER_80_634 VGND VGND VPWR VPWR sky130_fd_sc_hd__fill_1
XFILLER_65_697 VGND VGND VPWR VPWR sky130_fd_sc_hd__decap_3
XFILLER_37_377 VPWR VGND VPWR VGND sky130_ef_sc_hd__decap_12
X_09351_ _01758_ _01921_ _01920_ VGND VGND VPWR VPWR _02081_ sky130_fd_sc_hd__a21o_1
X_08302_ _01033_ _01035_ _01032_ VGND VGND VPWR VPWR _01036_ sky130_fd_sc_hd__o21a_1
XFILLER_100_27 VGND VGND VPWR VPWR sky130_fd_sc_hd__fill_1
X_09282_ _02004_ _02005_ VGND VGND VPWR VPWR _02006_ sky130_fd_sc_hd__or2_1
X_08233_ _00733_ _00737_ VGND VGND VPWR VPWR _00968_ sky130_fd_sc_hd__nor2_1
XFILLER_60_380 VGND VGND VPWR VPWR sky130_fd_sc_hd__decap_3
X_08164_ _00898_ _00899_ VGND VGND VPWR VPWR _00900_ sky130_fd_sc_hd__nor2_1
XFILLER_119_688 VGND VGND VPWR VPWR sky130_fd_sc_hd__fill_1
X_07115_ _06405_ _06406_ VGND VGND VPWR VPWR _06407_ sky130_fd_sc_hd__nor2_1
XTAP_TAPCELL_ROW_99_1683 VGND VPWR sky130_fd_sc_hd__tapvpwrvgnd_1
X_08095_ _00231_ _00383_ _00712_ _00830_ VGND VGND VPWR VPWR _00831_ sky130_fd_sc_hd__o31a_2
XFILLER_134_625 VPWR VGND VPWR VGND sky130_ef_sc_hd__decap_12
XFILLER_133_113 VPWR VGND VPWR VGND sky130_ef_sc_hd__decap_12
XFILLER_118_176 VGND VGND VPWR VPWR sky130_fd_sc_hd__decap_4
XFILLER_106_349 VPWR VGND VPWR VGND sky130_ef_sc_hd__decap_12
X_07046_ _05975_ _05986_ _05997_ VGND VGND VPWR VPWR _06030_ sky130_fd_sc_hd__a21oi_1
XFILLER_134_669 VPWR VGND VPWR VGND sky130_ef_sc_hd__decap_12
XFILLER_121_319 VGND VGND VPWR VPWR sky130_fd_sc_hd__fill_1
XFILLER_125_57 VPWR VGND VPWR VGND sky130_ef_sc_hd__decap_12
XFILLER_102_533 VPWR VGND VPWR VGND sky130_ef_sc_hd__decap_12
XFILLER_85_28 VPWR VGND VPWR VGND sky130_ef_sc_hd__decap_12
X_08997_ _01545_ _01563_ _01562_ VGND VGND VPWR VPWR _01723_ sky130_fd_sc_hd__a21boi_1
XTAP_TAPCELL_ROW_126_2057 VGND VPWR sky130_fd_sc_hd__tapvpwrvgnd_1
X_07948_ _00659_ _00684_ VGND VGND VPWR VPWR _00686_ sky130_fd_sc_hd__xnor2_1
XFILLER_68_491 VGND VGND VPWR VPWR sky130_fd_sc_hd__decap_8
XFILLER_56_620 VGND VGND VPWR VPWR sky130_fd_sc_hd__decap_6
X_07879_ net385 net383 net287 VGND VGND VPWR VPWR _00617_ sky130_fd_sc_hd__o21ai_1
XFILLER_56_675 VPWR VGND VPWR VGND sky130_ef_sc_hd__decap_12
XTAP_TAPCELL_ROW_39_840 VGND VPWR sky130_fd_sc_hd__tapvpwrvgnd_1
X_09618_ _02370_ _02372_ VGND VGND VPWR VPWR _00053_ sky130_fd_sc_hd__xnor2_1
XFILLER_55_185 VGND VGND VPWR VPWR sky130_fd_sc_hd__decap_4
XFILLER_43_325 VGND VGND VPWR VPWR sky130_fd_sc_hd__decap_8
XFILLER_16_517 VGND VGND VPWR VPWR sky130_fd_sc_hd__decap_3
XFILLER_28_377 VGND VGND VPWR VPWR sky130_fd_sc_hd__decap_3
X_10890_ net489 net649 _03750_ _03754_ VGND VGND VPWR VPWR _03755_ sky130_fd_sc_hd__a22o_1
X_09549_ _02291_ _02297_ VGND VGND VPWR VPWR _02298_ sky130_fd_sc_hd__and2_1
XFILLER_71_689 VPWR VGND VPWR VGND sky130_ef_sc_hd__decap_12
XFILLER_12_701 VPWR VGND VPWR VGND sky130_ef_sc_hd__decap_12
XFILLER_34_43 VGND VGND VPWR VPWR sky130_fd_sc_hd__decap_4
XFILLER_51_391 VGND VGND VPWR VPWR sky130_fd_sc_hd__fill_1
X_12560_ _05570_ _05572_ VGND VGND VPWR VPWR _05575_ sky130_fd_sc_hd__xnor2_1
XTAP_TAPCELL_ROW_121_1990 VGND VPWR sky130_fd_sc_hd__tapvpwrvgnd_1
XFILLER_11_233 VPWR VGND VPWR VGND sky130_ef_sc_hd__decap_12
X_11511_ _03985_ _04320_ VGND VGND VPWR VPWR _04433_ sky130_fd_sc_hd__or2_1
X_12491_ net567 net296 net294 net592 VGND VGND VPWR VPWR _05499_ sky130_fd_sc_hd__a22o_1
XFILLER_109_132 VGND VGND VPWR VPWR sky130_fd_sc_hd__decap_4
X_11442_ _04331_ _04357_ VGND VGND VPWR VPWR _04358_ sky130_fd_sc_hd__xor2_1
XFILLER_8_749 VGND VGND VPWR VPWR sky130_fd_sc_hd__decap_6
XFILLER_7_237 VPWR VGND VPWR VGND sky130_ef_sc_hd__decap_12
XFILLER_125_614 VGND VGND VPWR VPWR sky130_fd_sc_hd__fill_2
XFILLER_109_165 VGND VGND VPWR VPWR sky130_fd_sc_hd__decap_3
XTAP_TAPCELL_ROW_59_1122 VGND VPWR sky130_fd_sc_hd__tapvpwrvgnd_1
X_11373_ _04021_ _04282_ VGND VGND VPWR VPWR _04283_ sky130_fd_sc_hd__nand2_1
XFILLER_125_636 VPWR VGND VPWR VGND sky130_ef_sc_hd__decap_12
XFILLER_124_113 VPWR VGND VPWR VGND sky130_ef_sc_hd__decap_12
X_10324_ _03133_ _03136_ VGND VGND VPWR VPWR _03137_ sky130_fd_sc_hd__xnor2_1
X_13112_ _05688_ _06060_ _06058_ VGND VGND VPWR VPWR _06178_ sky130_fd_sc_hd__o21ai_1
XFILLER_113_809 VGND VGND VPWR VPWR sky130_fd_sc_hd__fill_2
XTAP_TAPCELL_ROW_72_1300 VGND VPWR sky130_fd_sc_hd__tapvpwrvgnd_1
XFILLER_78_211 VPWR VGND VPWR VGND sky130_ef_sc_hd__decap_12
X_10255_ _02885_ _03060_ _03059_ VGND VGND VPWR VPWR _03061_ sky130_fd_sc_hd__a21oi_1
X_13043_ _02109_ net290 net361 net360 VGND VGND VPWR VPWR _06102_ sky130_fd_sc_hd__and4_1
XFILLER_79_745 VGND VGND VPWR VPWR sky130_fd_sc_hd__fill_2
X_10186_ net697 net52 _02824_ _02822_ VGND VGND VPWR VPWR _02986_ sky130_fd_sc_hd__a31o_1
XFILLER_59_84 VPWR VGND VPWR VGND sky130_ef_sc_hd__decap_12
XFILLER_78_277 VPWR VGND VPWR VGND sky130_ef_sc_hd__decap_12
XFILLER_93_225 VPWR VGND VPWR VGND sky130_ef_sc_hd__decap_12
XFILLER_19_300 VPWR VGND VPWR VGND sky130_ef_sc_hd__decap_12
Xfanout290 net292 VGND VGND VPWR VPWR net290 sky130_fd_sc_hd__buf_2
XFILLER_75_72 VPWR VGND VPWR VGND sky130_ef_sc_hd__decap_12
XFILLER_74_483 VGND VGND VPWR VPWR sky130_fd_sc_hd__decap_8
XFILLER_62_645 VGND VGND VPWR VPWR sky130_fd_sc_hd__decap_8
X_12827_ net362 _05864_ VGND VGND VPWR VPWR _05867_ sky130_fd_sc_hd__and2_1
XTAP_TAPCELL_ROW_17_534 VGND VPWR sky130_fd_sc_hd__tapvpwrvgnd_1
XTAP_TAPCELL_ROW_83_1462 VGND VPWR sky130_fd_sc_hd__tapvpwrvgnd_1
XTAP_TAPCELL_ROW_83_1451 VGND VPWR sky130_fd_sc_hd__tapvpwrvgnd_1
XFILLER_61_166 VGND VGND VPWR VPWR sky130_fd_sc_hd__fill_2
X_12758_ _05772_ _05791_ VGND VGND VPWR VPWR _05792_ sky130_fd_sc_hd__xor2_1
X_11709_ _04634_ _04645_ VGND VGND VPWR VPWR _04646_ sky130_fd_sc_hd__xor2_1
X_12689_ net674 net672 net478 VGND VGND VPWR VPWR _05716_ sky130_fd_sc_hd__o21ai_2
XFILLER_30_586 VGND VGND VPWR VPWR sky130_fd_sc_hd__fill_2
XFILLER_115_113 VGND VGND VPWR VPWR sky130_fd_sc_hd__decap_6
XFILLER_115_135 VGND VGND VPWR VPWR sky130_fd_sc_hd__decap_6
XFILLER_131_617 VPWR VGND VPWR VGND sky130_ef_sc_hd__decap_12
X_08920_ net474 net161 VGND VGND VPWR VPWR _01646_ sky130_fd_sc_hd__and2b_1
XFILLER_123_190 VPWR VGND VPWR VGND sky130_ef_sc_hd__decap_12
X_08851_ _01439_ net709 _01576_ _01577_ VGND VGND VPWR VPWR _01578_ sky130_fd_sc_hd__o211a_1
XFILLER_85_726 VGND VGND VPWR VPWR sky130_fd_sc_hd__fill_2
X_07802_ _00540_ VGND VGND VPWR VPWR _00541_ sky130_fd_sc_hd__inv_2
XFILLER_57_417 VPWR VGND VPWR VGND sky130_ef_sc_hd__decap_12
XFILLER_111_374 VPWR VGND VPWR VGND sky130_ef_sc_hd__decap_12
X_08782_ _01391_ _01506_ _01507_ VGND VGND VPWR VPWR _01509_ sky130_fd_sc_hd__and3_1
X_07733_ _00439_ _00471_ VGND VGND VPWR VPWR _00472_ sky130_fd_sc_hd__nand2b_1
XFILLER_84_247 VGND VGND VPWR VPWR sky130_fd_sc_hd__decap_4
X_07664_ _00395_ _00403_ VGND VGND VPWR VPWR _00404_ sky130_fd_sc_hd__xor2_1
XFILLER_111_15 VPWR VGND VPWR VGND sky130_ef_sc_hd__decap_12
X_09403_ _01974_ _02137_ VGND VGND VPWR VPWR _02138_ sky130_fd_sc_hd__nand2_1
XFILLER_53_645 VGND VGND VPWR VPWR sky130_fd_sc_hd__decap_4
X_07595_ _00334_ VGND VGND VPWR VPWR _00335_ sky130_fd_sc_hd__inv_2
X_09334_ _01965_ _02061_ _02062_ VGND VGND VPWR VPWR _02063_ sky130_fd_sc_hd__nand3_1
X_09265_ _01985_ _01988_ VGND VGND VPWR VPWR _01989_ sky130_fd_sc_hd__and2_1
X_09196_ _01918_ _01919_ VGND VGND VPWR VPWR _01920_ sky130_fd_sc_hd__nor2_1
X_08216_ _00831_ _00841_ _00830_ VGND VGND VPWR VPWR _00951_ sky130_fd_sc_hd__a21boi_1
XFILLER_134_433 VPWR VGND VPWR VGND sky130_ef_sc_hd__decap_12
XFILLER_119_474 VPWR VGND VPWR VGND sky130_ef_sc_hd__decap_12
X_08147_ _00882_ _00862_ VGND VGND VPWR VPWR _00883_ sky130_fd_sc_hd__and2b_1
X_08078_ _00812_ _00813_ VGND VGND VPWR VPWR _00815_ sky130_fd_sc_hd__xnor2_1
XFILLER_106_157 VGND VGND VPWR VPWR sky130_fd_sc_hd__decap_8
XFILLER_105_6 VPWR VGND VPWR VGND sky130_ef_sc_hd__decap_12
XFILLER_134_477 VPWR VGND VPWR VGND sky130_ef_sc_hd__decap_12
XFILLER_122_639 VGND VGND VPWR VPWR sky130_fd_sc_hd__fill_1
XFILLER_121_116 VPWR VGND VPWR VGND sky130_ef_sc_hd__decap_12
X_07029_ net514 net427 net386 net384 VGND VGND VPWR VPWR _05844_ sky130_fd_sc_hd__and4_1
XFILLER_96_38 VPWR VGND VPWR VGND sky130_ef_sc_hd__decap_12
X_10040_ _02790_ _02826_ VGND VGND VPWR VPWR _02827_ sky130_fd_sc_hd__and2_1
XTAP_TAPCELL_ROW_54_1052 VGND VPWR sky130_fd_sc_hd__tapvpwrvgnd_1
XFILLER_88_575 VPWR VGND VPWR VGND sky130_ef_sc_hd__decap_12
XFILLER_76_726 VGND VGND VPWR VPWR sky130_fd_sc_hd__fill_1
XFILLER_48_406 VPWR VGND VPWR VGND sky130_ef_sc_hd__decap_12
XFILLER_0_457 VGND VGND VPWR VPWR sky130_fd_sc_hd__fill_1
XFILLER_0_468 VGND VGND VPWR VPWR sky130_fd_sc_hd__decap_4
X_11991_ _04932_ net715 _04953_ VGND VGND VPWR VPWR _04954_ sky130_fd_sc_hd__nor3_2
XFILLER_28_141 VPWR VGND VPWR VGND sky130_ef_sc_hd__decap_12
XFILLER_29_664 VGND VGND VPWR VPWR sky130_fd_sc_hd__decap_8
XFILLER_56_483 VGND VGND VPWR VPWR sky130_fd_sc_hd__fill_1
X_10942_ _03807_ _03809_ _03810_ VGND VGND VPWR VPWR _03812_ sky130_fd_sc_hd__or3_4
XFILLER_56_494 VGND VGND VPWR VPWR sky130_fd_sc_hd__fill_1
XFILLER_28_185 VGND VGND VPWR VPWR sky130_fd_sc_hd__decap_3
XFILLER_32_807 VGND VGND VPWR VPWR sky130_fd_sc_hd__fill_1
XFILLER_16_369 VPWR VGND VPWR VGND sky130_ef_sc_hd__decap_12
X_10873_ _03732_ _03733_ VGND VGND VPWR VPWR _03736_ sky130_fd_sc_hd__xor2_1
X_12612_ _05619_ _05620_ _05631_ VGND VGND VPWR VPWR _05632_ sky130_fd_sc_hd__a21o_1
X_12543_ _02087_ _05553_ net662 _05551_ VGND VGND VPWR VPWR _05556_ sky130_fd_sc_hd__or4bb_1
XTAP_TAPCELL_ROW_42_879 VGND VPWR sky130_fd_sc_hd__tapvpwrvgnd_1
XFILLER_12_597 VGND VGND VPWR VPWR sky130_fd_sc_hd__fill_2
X_12474_ _05478_ _05479_ _05294_ _05296_ VGND VGND VPWR VPWR _05481_ sky130_fd_sc_hd__o211a_1
XANTENNA_7 _02098_ VGND VGND VPWR VPWR sky130_fd_sc_hd__diode_2
X_11425_ _04208_ _04338_ VGND VGND VPWR VPWR _04339_ sky130_fd_sc_hd__xor2_1
X_11356_ _04255_ _04262_ VGND VGND VPWR VPWR _04264_ sky130_fd_sc_hd__xor2_1
XFILLER_98_306 VGND VGND VPWR VPWR sky130_fd_sc_hd__fill_2
X_10307_ net434 net578 net576 net443 VGND VGND VPWR VPWR _03119_ sky130_fd_sc_hd__a22oi_2
XFILLER_3_273 VGND VGND VPWR VPWR sky130_fd_sc_hd__decap_6
X_11287_ _04093_ _04099_ _03985_ VGND VGND VPWR VPWR _04189_ sky130_fd_sc_hd__a21oi_1
X_13026_ _05818_ _06083_ VGND VGND VPWR VPWR _06084_ sky130_fd_sc_hd__nand2_1
XFILLER_94_501 VPWR VGND VPWR VGND sky130_ef_sc_hd__decap_12
XFILLER_79_575 VPWR VGND VPWR VGND sky130_ef_sc_hd__decap_12
X_10238_ _03038_ net730 _03034_ _03035_ VGND VGND VPWR VPWR _03044_ sky130_fd_sc_hd__o211a_1
XFILLER_39_406 VPWR VGND VPWR VGND sky130_ef_sc_hd__decap_12
XFILLER_94_545 VGND VGND VPWR VPWR sky130_fd_sc_hd__decap_8
XFILLER_67_737 VPWR VGND VPWR VGND sky130_ef_sc_hd__decap_12
X_10169_ net694 net512 net348 net346 VGND VGND VPWR VPWR _02968_ sky130_fd_sc_hd__and4_1
XFILLER_66_258 VGND VGND VPWR VPWR sky130_fd_sc_hd__fill_1
XFILLER_82_729 VGND VGND VPWR VPWR sky130_fd_sc_hd__decap_8
Xrebuffer19 net720 VGND VGND VPWR VPWR net719 sky130_fd_sc_hd__buf_1
XFILLER_35_612 VGND VGND VPWR VPWR sky130_fd_sc_hd__decap_4
XFILLER_62_464 VPWR VGND VPWR VGND sky130_ef_sc_hd__decap_12
XFILLER_35_678 VGND VGND VPWR VPWR sky130_fd_sc_hd__fill_1
X_07380_ _06667_ _06668_ VGND VGND VPWR VPWR _06670_ sky130_fd_sc_hd__and2_1
XFILLER_22_339 VPWR VGND VPWR VGND sky130_ef_sc_hd__decap_12
X_09050_ _01773_ _01774_ VGND VGND VPWR VPWR _01775_ sky130_fd_sc_hd__nand2b_1
X_08001_ net410 _00737_ VGND VGND VPWR VPWR _00738_ sky130_fd_sc_hd__nand2_1
XFILLER_129_783 VGND VGND VPWR VPWR sky130_fd_sc_hd__fill_1
XTAP_TAPCELL_ROW_96_1642 VGND VPWR sky130_fd_sc_hd__tapvpwrvgnd_1
XFILLER_116_433 VPWR VGND VPWR VGND sky130_ef_sc_hd__decap_12
Xmax_cap232 _04785_ VGND VGND VPWR VPWR net232 sky130_fd_sc_hd__buf_1
Xmax_cap243 _04559_ VGND VGND VPWR VPWR net243 sky130_fd_sc_hd__clkbuf_2
XFILLER_116_477 VGND VGND VPWR VPWR sky130_fd_sc_hd__decap_4
X_09952_ _02677_ _02704_ _02703_ VGND VGND VPWR VPWR _02734_ sky130_fd_sc_hd__a21oi_1
X_08903_ _01477_ _01628_ VGND VGND VPWR VPWR _01629_ sky130_fd_sc_hd__xor2_1
XFILLER_106_59 VGND VGND VPWR VPWR sky130_fd_sc_hd__fill_2
X_09883_ _02654_ _02657_ VGND VGND VPWR VPWR _02660_ sky130_fd_sc_hd__xnor2_1
X_08834_ _01412_ _01420_ _01419_ VGND VGND VPWR VPWR _01561_ sky130_fd_sc_hd__a21bo_1
XFILLER_66_19 VGND VGND VPWR VPWR sky130_fd_sc_hd__decap_8
XFILLER_57_214 VGND VGND VPWR VPWR sky130_fd_sc_hd__fill_1
XFILLER_111_193 VGND VGND VPWR VPWR sky130_fd_sc_hd__decap_4
X_08765_ _01367_ _01491_ VGND VGND VPWR VPWR _01492_ sky130_fd_sc_hd__nor2_1
XTAP_TAPCELL_ROW_123_2016 VGND VPWR sky130_fd_sc_hd__tapvpwrvgnd_1
X_07716_ _00296_ _00454_ VGND VGND VPWR VPWR _00455_ sky130_fd_sc_hd__xnor2_1
XFILLER_73_729 VPWR VGND VPWR VGND sky130_ef_sc_hd__decap_12
XFILLER_66_770 VPWR VGND VPWR VGND sky130_ef_sc_hd__decap_12
XFILLER_26_601 VPWR VGND VPWR VGND sky130_ef_sc_hd__decap_12
XFILLER_82_29 VGND VGND VPWR VPWR sky130_fd_sc_hd__decap_8
X_08696_ _01422_ _01421_ _01423_ VGND VGND VPWR VPWR _01424_ sky130_fd_sc_hd__and3_1
XFILLER_26_645 VPWR VGND VPWR VGND sky130_ef_sc_hd__decap_12
XFILLER_81_762 VPWR VGND VPWR VGND sky130_ef_sc_hd__decap_12
X_07647_ net391 net389 net387 net287 VGND VGND VPWR VPWR _00387_ sky130_fd_sc_hd__and4_1
XTAP_TAPCELL_ROW_0_276 VGND VPWR sky130_fd_sc_hd__tapvpwrvgnd_1
XTAP_TAPCELL_ROW_0_287 VGND VPWR sky130_fd_sc_hd__tapvpwrvgnd_1
XFILLER_25_155 VGND VGND VPWR VPWR sky130_fd_sc_hd__decap_3
XFILLER_25_166 VGND VGND VPWR VPWR sky130_fd_sc_hd__fill_2
XFILLER_41_615 VGND VGND VPWR VPWR sky130_fd_sc_hd__fill_1
X_07578_ _00316_ _00317_ VGND VGND VPWR VPWR _00318_ sky130_fd_sc_hd__nand2_1
XTAP_TAPCELL_ROW_105_1771 VGND VPWR sky130_fd_sc_hd__tapvpwrvgnd_1
XTAP_TAPCELL_ROW_105_1760 VGND VPWR sky130_fd_sc_hd__tapvpwrvgnd_1
XFILLER_53_486 VGND VGND VPWR VPWR sky130_fd_sc_hd__fill_1
XTAP_TAPCELL_ROW_0_298 VGND VPWR sky130_fd_sc_hd__tapvpwrvgnd_1
XFILLER_40_125 VGND VGND VPWR VPWR sky130_fd_sc_hd__decap_6
X_09317_ _01676_ _02043_ VGND VGND VPWR VPWR _02045_ sky130_fd_sc_hd__nand2_1
XFILLER_127_709 VPWR VGND VPWR VGND sky130_ef_sc_hd__decap_12
X_09248_ _01970_ _01971_ VGND VGND VPWR VPWR _01972_ sky130_fd_sc_hd__xnor2_1
XFILLER_5_505 VPWR VGND VPWR VGND sky130_ef_sc_hd__decap_12
XTAP_TAPCELL_ROW_134_2167 VGND VPWR sky130_fd_sc_hd__tapvpwrvgnd_1
X_09179_ _01903_ VGND VGND VPWR VPWR _01904_ sky130_fd_sc_hd__inv_2
XFILLER_135_753 VPWR VGND VPWR VGND sky130_ef_sc_hd__decap_12
X_12190_ _05163_ _05169_ VGND VGND VPWR VPWR _05170_ sky130_fd_sc_hd__xor2_1
X_11210_ _04089_ _04104_ VGND VGND VPWR VPWR _04105_ sky130_fd_sc_hd__xnor2_1
XFILLER_135_797 VPWR VGND VPWR VGND sky130_ef_sc_hd__decap_12
XFILLER_107_488 VGND VGND VPWR VPWR sky130_fd_sc_hd__fill_1
XFILLER_103_3 VPWR VGND VPWR VGND sky130_ef_sc_hd__decap_12
X_11141_ net565 net274 _04028_ VGND VGND VPWR VPWR _04029_ sky130_fd_sc_hd__a21oi_1
XFILLER_0_221 VGND VGND VPWR VPWR sky130_fd_sc_hd__decap_3
Xinput100 w20[2] VGND VGND VPWR VPWR net100 sky130_fd_sc_hd__buf_1
XFILLER_1_777 VGND VGND VPWR VPWR sky130_fd_sc_hd__decap_6
X_11072_ _03951_ _03952_ VGND VGND VPWR VPWR _03954_ sky130_fd_sc_hd__xnor2_2
Xinput111 w21[5] VGND VGND VPWR VPWR net111 sky130_fd_sc_hd__buf_1
XFILLER_103_683 VGND VGND VPWR VPWR sky130_fd_sc_hd__fill_1
Xinput122 w23[0] VGND VGND VPWR VPWR net122 sky130_fd_sc_hd__clkbuf_2
XFILLER_88_383 VGND VGND VPWR VPWR sky130_fd_sc_hd__fill_1
Xinput133 w30[3] VGND VGND VPWR VPWR net133 sky130_fd_sc_hd__buf_1
X_10023_ _02780_ _02782_ _02783_ _02808_ VGND VGND VPWR VPWR _02809_ sky130_fd_sc_hd__or4_1
XFILLER_0_265 VPWR VGND VPWR VGND sky130_ef_sc_hd__decap_12
Xinput144 w31[6] VGND VGND VPWR VPWR net144 sky130_fd_sc_hd__buf_1
Xinput155 w33[1] VGND VGND VPWR VPWR net155 sky130_fd_sc_hd__buf_1
XFILLER_76_589 VPWR VGND VPWR VGND sky130_ef_sc_hd__decap_12
XFILLER_56_63 VGND VGND VPWR VPWR sky130_fd_sc_hd__fill_1
XTAP_TAPCELL_ROW_67_1232 VGND VPWR sky130_fd_sc_hd__tapvpwrvgnd_1
XTAP_TAPCELL_ROW_47_949 VGND VPWR sky130_fd_sc_hd__tapvpwrvgnd_1
X_11974_ net428 net367 net365 net515 VGND VGND VPWR VPWR _04935_ sky130_fd_sc_hd__a22oi_1
XFILLER_16_100 VGND VGND VPWR VPWR sky130_fd_sc_hd__fill_1
XFILLER_44_475 VGND VGND VPWR VPWR sky130_fd_sc_hd__fill_1
X_10925_ _03611_ _03614_ VGND VGND VPWR VPWR _03793_ sky130_fd_sc_hd__nand2_1
XTAP_TAPCELL_ROW_80_1421 VGND VPWR sky130_fd_sc_hd__tapvpwrvgnd_1
XTAP_TAPCELL_ROW_80_1410 VGND VPWR sky130_fd_sc_hd__tapvpwrvgnd_1
XTAP_TAPCELL_ROW_27_673 VGND VPWR sky130_fd_sc_hd__tapvpwrvgnd_1
XFILLER_31_125 VPWR VGND VPWR VGND sky130_ef_sc_hd__decap_12
X_10856_ _03519_ _03715_ VGND VGND VPWR VPWR _03717_ sky130_fd_sc_hd__xor2_1
XFILLER_32_659 VPWR VGND VPWR VGND sky130_ef_sc_hd__decap_12
XFILLER_12_361 VGND VGND VPWR VPWR sky130_fd_sc_hd__decap_3
XFILLER_8_321 VPWR VGND VPWR VGND sky130_ef_sc_hd__decap_12
X_10787_ _03638_ _03639_ _03640_ VGND VGND VPWR VPWR _03643_ sky130_fd_sc_hd__a21o_1
XFILLER_31_169 VPWR VGND VPWR VGND sky130_ef_sc_hd__decap_12
XFILLER_12_394 VGND VGND VPWR VPWR sky130_fd_sc_hd__decap_8
X_12526_ _05517_ _05536_ VGND VGND VPWR VPWR _05537_ sky130_fd_sc_hd__xnor2_1
XFILLER_8_365 VPWR VGND VPWR VGND sky130_ef_sc_hd__decap_12
X_12457_ _05278_ _05280_ net233 _05461_ VGND VGND VPWR VPWR _05463_ sky130_fd_sc_hd__a211o_1
X_11408_ _04318_ _04320_ VGND VGND VPWR VPWR _04321_ sky130_fd_sc_hd__or2_1
XFILLER_113_403 VPWR VGND VPWR VGND sky130_ef_sc_hd__decap_12
XFILLER_99_626 VGND VGND VPWR VPWR sky130_fd_sc_hd__decap_8
XFILLER_99_615 VGND VGND VPWR VPWR sky130_fd_sc_hd__fill_1
XTAP_TAPCELL_ROW_78_1383 VGND VPWR sky130_fd_sc_hd__tapvpwrvgnd_1
X_12388_ _05195_ _05384_ VGND VGND VPWR VPWR _05387_ sky130_fd_sc_hd__xnor2_1
XFILLER_113_447 VGND VGND VPWR VPWR sky130_fd_sc_hd__fill_1
X_11339_ _03869_ _04030_ _04245_ VGND VGND VPWR VPWR _04246_ sky130_fd_sc_hd__o21bai_2
XTAP_TAPCELL_ROW_91_1572 VGND VPWR sky130_fd_sc_hd__tapvpwrvgnd_1
XFILLER_86_309 VGND VGND VPWR VPWR sky130_fd_sc_hd__decap_8
XFILLER_100_119 VPWR VGND VPWR VGND sky130_ef_sc_hd__decap_12
X_06880_ net804 net357 net771 net388 VGND VGND VPWR VPWR _04221_ sky130_fd_sc_hd__a22o_1
X_13009_ _06056_ _06064_ VGND VGND VPWR VPWR _06066_ sky130_fd_sc_hd__xor2_1
XFILLER_39_203 VGND VGND VPWR VPWR sky130_fd_sc_hd__decap_8
XFILLER_39_225 VGND VGND VPWR VPWR sky130_fd_sc_hd__decap_4
XFILLER_94_342 VGND VGND VPWR VPWR sky130_fd_sc_hd__fill_1
XFILLER_39_236 VGND VGND VPWR VPWR sky130_fd_sc_hd__decap_4
XFILLER_39_247 VGND VGND VPWR VPWR sky130_fd_sc_hd__decap_8
X_08550_ net438 net558 _01277_ _01278_ VGND VGND VPWR VPWR _01279_ sky130_fd_sc_hd__nand4_2
X_08481_ _01206_ _01209_ VGND VGND VPWR VPWR _01210_ sky130_fd_sc_hd__xor2_1
X_07501_ _00235_ _00236_ _00241_ VGND VGND VPWR VPWR _00242_ sky130_fd_sc_hd__a21o_1
X_07432_ net682 net490 net483 net684 VGND VGND VPWR VPWR _00173_ sky130_fd_sc_hd__a22o_1
X_07363_ _06652_ _06653_ VGND VGND VPWR VPWR _06654_ sky130_fd_sc_hd__nand2_1
X_09102_ _01820_ _01826_ VGND VGND VPWR VPWR _01827_ sky130_fd_sc_hd__and2_1
X_07294_ _06551_ _06584_ VGND VGND VPWR VPWR _06585_ sky130_fd_sc_hd__xnor2_2
XFILLER_136_517 VPWR VGND VPWR VGND sky130_ef_sc_hd__decap_12
X_09033_ _01756_ _01757_ VGND VGND VPWR VPWR _01758_ sky130_fd_sc_hd__nor2_1
XTAP_TAPCELL_ROW_100_1690 VGND VPWR sky130_fd_sc_hd__tapvpwrvgnd_1
XFILLER_132_701 VPWR VGND VPWR VGND sky130_ef_sc_hd__decap_12
XFILLER_117_797 VPWR VGND VPWR VGND sky130_ef_sc_hd__decap_12
XFILLER_117_69 VGND VGND VPWR VPWR sky130_fd_sc_hd__decap_8
XFILLER_104_425 VGND VGND VPWR VPWR sky130_fd_sc_hd__fill_1
XFILLER_89_125 VGND VGND VPWR VPWR sky130_fd_sc_hd__decap_6
X_09935_ _02715_ _02716_ VGND VGND VPWR VPWR _02717_ sky130_fd_sc_hd__and2_1
XFILLER_131_277 VGND VGND VPWR VPWR sky130_fd_sc_hd__decap_3
X_09866_ _02531_ _02639_ VGND VGND VPWR VPWR _02641_ sky130_fd_sc_hd__xor2_1
XTAP_TAPCELL_ROW_51_1011 VGND VPWR sky130_fd_sc_hd__tapvpwrvgnd_1
XFILLER_133_57 VPWR VGND VPWR VGND sky130_ef_sc_hd__decap_12
XFILLER_112_491 VGND VGND VPWR VPWR sky130_fd_sc_hd__decap_3
XFILLER_100_642 VGND VGND VPWR VPWR sky130_fd_sc_hd__fill_2
X_08817_ _01540_ _01541_ _01542_ VGND VGND VPWR VPWR _01544_ sky130_fd_sc_hd__or3_1
XTAP_TAPCELL_ROW_5_368 VGND VPWR sky130_fd_sc_hd__tapvpwrvgnd_1
X_09797_ _02551_ _02565_ VGND VGND VPWR VPWR _02567_ sky130_fd_sc_hd__xnor2_1
X_08748_ _01473_ _01474_ VGND VGND VPWR VPWR _01475_ sky130_fd_sc_hd__xnor2_1
XFILLER_73_537 VPWR VGND VPWR VGND sky130_ef_sc_hd__decap_12
XFILLER_38_291 VGND VGND VPWR VPWR sky130_fd_sc_hd__decap_8
X_08679_ _01405_ _01406_ VGND VGND VPWR VPWR _01407_ sky130_fd_sc_hd__or2_1
XFILLER_53_250 VGND VGND VPWR VPWR sky130_fd_sc_hd__decap_3
XTAP_TAPCELL_ROW_44_908 VGND VPWR sky130_fd_sc_hd__tapvpwrvgnd_1
X_10710_ _03557_ _03556_ VGND VGND VPWR VPWR _03558_ sky130_fd_sc_hd__nand2b_1
XFILLER_26_99 VPWR VGND VPWR VGND sky130_ef_sc_hd__decap_12
XFILLER_26_475 VGND VGND VPWR VPWR sky130_fd_sc_hd__fill_1
X_11690_ _04622_ _04623_ VGND VGND VPWR VPWR _04625_ sky130_fd_sc_hd__xnor2_1
XFILLER_9_107 VGND VGND VPWR VPWR sky130_fd_sc_hd__fill_1
XTAP_TAPCELL_ROW_24_632 VGND VPWR sky130_fd_sc_hd__tapvpwrvgnd_1
XTAP_TAPCELL_ROW_136_2218 VGND VPWR sky130_fd_sc_hd__tapvpwrvgnd_1
XTAP_TAPCELL_ROW_136_2207 VGND VPWR sky130_fd_sc_hd__tapvpwrvgnd_1
XTAP_TAPCELL_ROW_62_1162 VGND VPWR sky130_fd_sc_hd__tapvpwrvgnd_1
X_10641_ _03277_ _03308_ _03307_ VGND VGND VPWR VPWR _03483_ sky130_fd_sc_hd__a21bo_1
XFILLER_41_478 VGND VGND VPWR VPWR sky130_fd_sc_hd__decap_4
X_13360_ clknet_3_3__leaf_clk _00047_ _00070_ VGND VGND VPWR VPWR net174 sky130_fd_sc_hd__dfrtp_1
X_10572_ net450 net562 _03405_ _03406_ VGND VGND VPWR VPWR _03407_ sky130_fd_sc_hd__a22o_1
X_13291_ net394 VGND VGND VPWR VPWR _00065_ sky130_fd_sc_hd__inv_2
XTAP_TAPCELL_ROW_118_1940 VGND VPWR sky130_fd_sc_hd__tapvpwrvgnd_1
X_12311_ _05124_ _05302_ VGND VGND VPWR VPWR _05303_ sky130_fd_sc_hd__nor2_1
XTAP_TAPCELL_ROW_118_1951 VGND VPWR sky130_fd_sc_hd__tapvpwrvgnd_1
XFILLER_5_335 VGND VGND VPWR VPWR sky130_fd_sc_hd__fill_1
X_12242_ net413 net405 net601 net599 VGND VGND VPWR VPWR _05227_ sky130_fd_sc_hd__and4_1
XFILLER_135_561 VPWR VGND VPWR VGND sky130_ef_sc_hd__decap_12
XFILLER_107_252 VGND VGND VPWR VPWR sky130_fd_sc_hd__fill_1
X_12173_ _05148_ _05149_ VGND VGND VPWR VPWR _05151_ sky130_fd_sc_hd__xnor2_1
XFILLER_68_309 VPWR VGND VPWR VGND sky130_ef_sc_hd__decap_12
X_11124_ _03861_ _04010_ VGND VGND VPWR VPWR _04011_ sky130_fd_sc_hd__xnor2_2
XFILLER_1_541 VPWR VGND VPWR VGND sky130_ef_sc_hd__decap_12
XFILLER_3_15 VPWR VGND VPWR VGND sky130_ef_sc_hd__decap_12
XFILLER_110_439 VGND VGND VPWR VPWR sky130_fd_sc_hd__fill_1
XFILLER_95_106 VGND VGND VPWR VPWR sky130_fd_sc_hd__decap_6
XFILLER_89_670 VGND VGND VPWR VPWR sky130_fd_sc_hd__fill_2
XFILLER_1_585 VPWR VGND VPWR VGND sky130_ef_sc_hd__decap_12
X_11055_ _03763_ _03769_ _03768_ VGND VGND VPWR VPWR _03935_ sky130_fd_sc_hd__a21oi_1
XFILLER_88_191 VGND VGND VPWR VPWR sky130_fd_sc_hd__decap_4
X_10006_ net697 net513 net353 net350 VGND VGND VPWR VPWR _02790_ sky130_fd_sc_hd__and4_1
XFILLER_49_545 VGND VGND VPWR VPWR sky130_fd_sc_hd__decap_6
XFILLER_49_578 VPWR VGND VPWR VGND sky130_ef_sc_hd__decap_12
XFILLER_37_729 VGND VGND VPWR VPWR sky130_fd_sc_hd__decap_6
XFILLER_91_345 VGND VGND VPWR VPWR sky130_fd_sc_hd__fill_1
XFILLER_91_334 VGND VGND VPWR VPWR sky130_fd_sc_hd__fill_2
XFILLER_91_323 VGND VGND VPWR VPWR sky130_fd_sc_hd__fill_2
XFILLER_17_420 VGND VGND VPWR VPWR sky130_fd_sc_hd__decap_4
X_11957_ net454 net587 VGND VGND VPWR VPWR _04917_ sky130_fd_sc_hd__nand2_1
XFILLER_91_389 VGND VGND VPWR VPWR sky130_fd_sc_hd__decap_3
XFILLER_60_710 VPWR VGND VPWR VGND sky130_ef_sc_hd__decap_12
XFILLER_45_795 VGND VGND VPWR VPWR sky130_fd_sc_hd__decap_6
XFILLER_17_486 VGND VGND VPWR VPWR sky130_fd_sc_hd__fill_1
X_10908_ _03770_ _03771_ VGND VGND VPWR VPWR _03775_ sky130_fd_sc_hd__xnor2_1
X_11888_ _04828_ _04831_ _04834_ _04839_ VGND VGND VPWR VPWR _04842_ sky130_fd_sc_hd__o211ai_2
XFILLER_44_294 VGND VGND VPWR VPWR sky130_fd_sc_hd__fill_1
XFILLER_13_670 VGND VGND VPWR VPWR sky130_fd_sc_hd__fill_2
XPHY_EDGE_ROW_17_Left_154 VGND VGND VPWR VPWR sky130_fd_sc_hd__decap_3
X_10839_ net590 net566 net277 net275 VGND VGND VPWR VPWR _03699_ sky130_fd_sc_hd__and4_1
XPHY_EDGE_ROW_132_Right_132 VGND VGND VPWR VPWR sky130_fd_sc_hd__decap_3
XFILLER_9_696 VPWR VGND VPWR VGND sky130_ef_sc_hd__decap_12
XFILLER_8_162 VGND VGND VPWR VPWR sky130_fd_sc_hd__decap_6
X_12509_ _05371_ _05380_ _05379_ VGND VGND VPWR VPWR _05519_ sky130_fd_sc_hd__a21oi_1
XTAP_TAPCELL_ROW_93_1601 VGND VPWR sky130_fd_sc_hd__tapvpwrvgnd_1
XFILLER_126_550 VGND VGND VPWR VPWR sky130_fd_sc_hd__fill_1
XFILLER_114_712 VGND VGND VPWR VPWR sky130_fd_sc_hd__decap_4
XFILLER_114_701 VGND VGND VPWR VPWR sky130_fd_sc_hd__fill_2
X_07981_ _00617_ _00619_ _00616_ VGND VGND VPWR VPWR _00718_ sky130_fd_sc_hd__o21ba_1
XPHY_EDGE_ROW_26_Left_163 VGND VGND VPWR VPWR sky130_fd_sc_hd__decap_3
X_09720_ _02449_ _02481_ VGND VGND VPWR VPWR _02483_ sky130_fd_sc_hd__xnor2_1
X_06932_ _04741_ _04763_ _04774_ VGND VGND VPWR VPWR _04785_ sky130_fd_sc_hd__nor3_1
XFILLER_86_117 VGND VGND VPWR VPWR sky130_fd_sc_hd__fill_1
XFILLER_86_139 VGND VGND VPWR VPWR sky130_fd_sc_hd__fill_1
XFILLER_67_320 VPWR VGND VPWR VGND sky130_ef_sc_hd__decap_12
XFILLER_95_673 VPWR VGND VPWR VGND sky130_ef_sc_hd__decap_12
X_06863_ _04024_ _03981_ VGND VGND VPWR VPWR _04035_ sky130_fd_sc_hd__and2b_1
X_09651_ _02308_ _02406_ VGND VGND VPWR VPWR _02407_ sky130_fd_sc_hd__xnor2_1
XTAP_TAPCELL_ROW_2_316 VGND VPWR sky130_fd_sc_hd__tapvpwrvgnd_1
XTAP_TAPCELL_ROW_2_327 VGND VPWR sky130_fd_sc_hd__tapvpwrvgnd_1
XFILLER_27_217 VGND VGND VPWR VPWR sky130_fd_sc_hd__decap_6
X_09582_ _01974_ _02140_ _02332_ VGND VGND VPWR VPWR _02333_ sky130_fd_sc_hd__a21oi_4
X_06794_ net251 net506 _02921_ VGND VGND VPWR VPWR _03281_ sky130_fd_sc_hd__and3_1
XFILLER_94_194 VGND VGND VPWR VPWR sky130_fd_sc_hd__fill_2
X_08602_ _01327_ _01330_ VGND VGND VPWR VPWR _01331_ sky130_fd_sc_hd__xnor2_2
XFILLER_82_345 VGND VGND VPWR VPWR sky130_fd_sc_hd__decap_4
XFILLER_55_537 VGND VGND VPWR VPWR sky130_fd_sc_hd__fill_2
X_08533_ net430 net735 net341 net339 VGND VGND VPWR VPWR _01262_ sky130_fd_sc_hd__and4_1
XFILLER_36_740 VGND VGND VPWR VPWR sky130_fd_sc_hd__fill_1
XFILLER_23_412 VPWR VGND VPWR VGND sky130_ef_sc_hd__decap_12
X_08464_ net692 net261 _01186_ _01187_ VGND VGND VPWR VPWR _01193_ sky130_fd_sc_hd__a22oi_1
XPHY_EDGE_ROW_35_Left_172 VGND VGND VPWR VPWR sky130_fd_sc_hd__decap_3
X_07415_ _00140_ _00155_ VGND VGND VPWR VPWR _00156_ sky130_fd_sc_hd__xor2_1
X_08395_ net824 net341 net339 net518 VGND VGND VPWR VPWR _01125_ sky130_fd_sc_hd__a22o_1
XFILLER_50_275 VPWR VGND VPWR VGND sky130_ef_sc_hd__decap_12
XFILLER_50_253 VGND VGND VPWR VPWR sky130_fd_sc_hd__decap_8
XFILLER_23_478 VGND VGND VPWR VPWR sky130_fd_sc_hd__fill_1
X_07346_ _06607_ _06636_ VGND VGND VPWR VPWR _06637_ sky130_fd_sc_hd__nand2_1
XFILLER_136_314 VGND VGND VPWR VPWR sky130_fd_sc_hd__decap_4
X_09016_ _01592_ _01740_ VGND VGND VPWR VPWR _01742_ sky130_fd_sc_hd__or2_1
X_07277_ net436 net445 net608 net606 VGND VGND VPWR VPWR _06568_ sky130_fd_sc_hd__nand4_1
XTAP_TAPCELL_ROW_131_2126 VGND VPWR sky130_fd_sc_hd__tapvpwrvgnd_1
XFILLER_124_509 VPWR VGND VPWR VGND sky130_ef_sc_hd__decap_12
XFILLER_117_561 VGND VGND VPWR VPWR sky130_fd_sc_hd__decap_8
XFILLER_132_531 VGND VGND VPWR VPWR sky130_fd_sc_hd__fill_1
XFILLER_117_583 VGND VGND VPWR VPWR sky130_fd_sc_hd__decap_4
XPHY_EDGE_ROW_44_Left_181 VGND VGND VPWR VPWR sky130_fd_sc_hd__decap_3
XTAP_TAPCELL_ROW_113_1870 VGND VPWR sky130_fd_sc_hd__tapvpwrvgnd_1
XFILLER_105_756 VGND VGND VPWR VPWR sky130_fd_sc_hd__fill_2
XFILLER_104_233 VGND VGND VPWR VPWR sky130_fd_sc_hd__fill_2
Xfanout642 net643 VGND VGND VPWR VPWR net642 sky130_fd_sc_hd__buf_2
Xfanout620 net623 VGND VGND VPWR VPWR net620 sky130_fd_sc_hd__clkbuf_2
XTAP_TAPCELL_ROW_113_1881 VGND VPWR sky130_fd_sc_hd__tapvpwrvgnd_1
X_09918_ _02596_ _02598_ _02698_ VGND VGND VPWR VPWR _02699_ sky130_fd_sc_hd__a21oi_1
Xfanout631 net124 VGND VGND VPWR VPWR net631 sky130_fd_sc_hd__buf_2
XFILLER_104_299 VGND VGND VPWR VPWR sky130_fd_sc_hd__decap_8
Xfanout664 net671 VGND VGND VPWR VPWR net664 sky130_fd_sc_hd__dlymetal6s2s_1
XFILLER_58_331 VPWR VGND VPWR VGND sky130_ef_sc_hd__decap_12
Xfanout653 net116 VGND VGND VPWR VPWR net653 sky130_fd_sc_hd__clkbuf_2
Xfanout675 net108 VGND VGND VPWR VPWR net675 sky130_fd_sc_hd__clkbuf_2
XTAP_TAPCELL_ROW_129_2099 VGND VPWR sky130_fd_sc_hd__tapvpwrvgnd_1
X_09849_ _02375_ _02623_ VGND VGND VPWR VPWR _02624_ sky130_fd_sc_hd__xnor2_1
Xfanout686 net689 VGND VGND VPWR VPWR net686 sky130_fd_sc_hd__buf_2
Xfanout697 net1 VGND VGND VPWR VPWR net697 sky130_fd_sc_hd__clkbuf_2
XTAP_TAPCELL_ROW_29_702 VGND VPWR sky130_fd_sc_hd__tapvpwrvgnd_1
XFILLER_46_559 VGND VGND VPWR VPWR sky130_fd_sc_hd__fill_1
XFILLER_18_228 VGND VGND VPWR VPWR sky130_fd_sc_hd__decap_4
XFILLER_18_239 VPWR VGND VPWR VGND sky130_ef_sc_hd__decap_12
X_12860_ _05887_ _05902_ VGND VGND VPWR VPWR _05903_ sky130_fd_sc_hd__xnor2_1
X_11811_ _04756_ VGND VGND VPWR VPWR _04757_ sky130_fd_sc_hd__inv_2
XFILLER_73_389 VGND VGND VPWR VPWR sky130_fd_sc_hd__decap_3
XPHY_EDGE_ROW_53_Left_190 VGND VGND VPWR VPWR sky130_fd_sc_hd__decap_3
X_12791_ net567 net293 _05825_ VGND VGND VPWR VPWR _05827_ sky130_fd_sc_hd__and3_1
X_11742_ _04649_ _04651_ VGND VGND VPWR VPWR _04681_ sky130_fd_sc_hd__nor2_1
XFILLER_53_42 VPWR VGND VPWR VGND sky130_ef_sc_hd__decap_12
X_11673_ net269 net691 net302 net300 VGND VGND VPWR VPWR _04607_ sky130_fd_sc_hd__and4_1
X_13412_ clknet_3_7__leaf_clk _00052_ _00122_ VGND VGND VPWR VPWR net211 sky130_fd_sc_hd__dfrtp_1
X_10624_ net89 net342 VGND VGND VPWR VPWR _03464_ sky130_fd_sc_hd__and2_1
X_13343_ net398 VGND VGND VPWR VPWR _00117_ sky130_fd_sc_hd__inv_2
X_10555_ net482 net654 net652 net489 VGND VGND VPWR VPWR _03388_ sky130_fd_sc_hd__a22o_1
X_10486_ _03254_ _03311_ _03312_ VGND VGND VPWR VPWR _03313_ sky130_fd_sc_hd__nand3_1
X_13274_ _06347_ _06352_ VGND VGND VPWR VPWR _06353_ sky130_fd_sc_hd__xnor2_1
XFILLER_123_520 VGND VGND VPWR VPWR sky130_fd_sc_hd__decap_8
XTAP_TAPCELL_ROW_75_1342 VGND VPWR sky130_fd_sc_hd__tapvpwrvgnd_1
X_12225_ _05203_ _05206_ _05207_ VGND VGND VPWR VPWR _05208_ sky130_fd_sc_hd__nand3_1
XFILLER_6_699 VGND VGND VPWR VPWR sky130_fd_sc_hd__fill_1
XFILLER_135_391 VGND VGND VPWR VPWR sky130_fd_sc_hd__fill_1
X_12156_ _04863_ _04998_ _05131_ VGND VGND VPWR VPWR _05132_ sky130_fd_sc_hd__or3_1
XFILLER_110_214 VGND VGND VPWR VPWR sky130_fd_sc_hd__fill_1
XFILLER_78_72 VPWR VGND VPWR VGND sky130_ef_sc_hd__decap_12
XFILLER_69_629 VGND VGND VPWR VPWR sky130_fd_sc_hd__decap_8
X_11107_ _03969_ _03991_ VGND VGND VPWR VPWR _03993_ sky130_fd_sc_hd__xnor2_2
XFILLER_68_139 VGND VGND VPWR VPWR sky130_fd_sc_hd__fill_1
XFILLER_49_331 VGND VGND VPWR VPWR sky130_fd_sc_hd__decap_4
X_12087_ net457 net586 net584 net462 VGND VGND VPWR VPWR _05059_ sky130_fd_sc_hd__a22o_1
XFILLER_1_382 VGND VGND VPWR VPWR sky130_fd_sc_hd__decap_8
XFILLER_1_393 VPWR VGND VPWR VGND sky130_ef_sc_hd__decap_12
XFILLER_77_673 VGND VGND VPWR VPWR sky130_fd_sc_hd__decap_4
X_11038_ _03752_ _03916_ VGND VGND VPWR VPWR _03917_ sky130_fd_sc_hd__nor2_1
XFILLER_76_183 VPWR VGND VPWR VGND sky130_ef_sc_hd__decap_12
XFILLER_91_153 VGND VGND VPWR VPWR sky130_fd_sc_hd__decap_8
XFILLER_92_698 VGND VGND VPWR VPWR sky130_fd_sc_hd__fill_2
XFILLER_64_389 VGND VGND VPWR VPWR sky130_fd_sc_hd__decap_6
XFILLER_52_529 VGND VGND VPWR VPWR sky130_fd_sc_hd__decap_3
XFILLER_45_581 VPWR VGND VPWR VGND sky130_ef_sc_hd__decap_12
X_12989_ _06042_ _06043_ VGND VGND VPWR VPWR _06044_ sky130_fd_sc_hd__or2_1
XTAP_TAPCELL_ROW_86_1493 VGND VPWR sky130_fd_sc_hd__tapvpwrvgnd_1
XFILLER_60_584 VGND VGND VPWR VPWR sky130_fd_sc_hd__decap_4
XFILLER_32_253 VGND VGND VPWR VPWR sky130_fd_sc_hd__fill_1
X_08180_ _00800_ _00802_ _00914_ VGND VGND VPWR VPWR _00916_ sky130_fd_sc_hd__and3_1
X_07200_ net917 _06194_ _06489_ _06490_ VGND VGND VPWR VPWR _06492_ sky130_fd_sc_hd__o211ai_2
XFILLER_60_595 VGND VGND VPWR VPWR sky130_fd_sc_hd__decap_4
X_07131_ _06421_ _06422_ VGND VGND VPWR VPWR _06423_ sky130_fd_sc_hd__or2_1
XFILLER_20_459 VGND VGND VPWR VPWR sky130_fd_sc_hd__decap_6
XFILLER_9_493 VGND VGND VPWR VPWR sky130_fd_sc_hd__fill_2
X_07062_ _05352_ _05363_ _06183_ net915 VGND VGND VPWR VPWR _06205_ sky130_fd_sc_hd__o22a_4
Xoutput201 net201 VGND VGND VPWR VPWR out2[1] sky130_fd_sc_hd__buf_2
Xoutput212 net212 VGND VGND VPWR VPWR out3[11] sky130_fd_sc_hd__buf_2
Xoutput223 net223 VGND VGND VPWR VPWR out3[7] sky130_fd_sc_hd__buf_2
XFILLER_99_242 VPWR VGND VPWR VGND sky130_ef_sc_hd__decap_12
XFILLER_0_809 VGND VGND VPWR VPWR sky130_fd_sc_hd__fill_2
XFILLER_87_426 VGND VGND VPWR VPWR sky130_fd_sc_hd__decap_8
XFILLER_87_404 VGND VGND VPWR VPWR sky130_fd_sc_hd__fill_1
X_07964_ _00433_ _00567_ _00566_ VGND VGND VPWR VPWR _00702_ sky130_fd_sc_hd__a21oi_1
XFILLER_114_15 VPWR VGND VPWR VGND sky130_ef_sc_hd__decap_12
X_09703_ _02252_ _02463_ VGND VGND VPWR VPWR _02464_ sky130_fd_sc_hd__xnor2_1
X_06915_ _04589_ _04505_ _02813_ VGND VGND VPWR VPWR _04600_ sky130_fd_sc_hd__and3_1
XFILLER_74_109 VPWR VGND VPWR VGND sky130_ef_sc_hd__decap_12
X_07895_ _00626_ _00631_ VGND VGND VPWR VPWR _00633_ sky130_fd_sc_hd__xnor2_1
XFILLER_110_781 VPWR VGND VPWR VGND sky130_ef_sc_hd__decap_12
X_06846_ _02533_ _02932_ _03281_ VGND VGND VPWR VPWR _03850_ sky130_fd_sc_hd__or3_1
XFILLER_83_643 VPWR VGND VPWR VGND sky130_ef_sc_hd__decap_12
X_09634_ _01676_ _02388_ VGND VGND VPWR VPWR _02389_ sky130_fd_sc_hd__xnor2_1
X_06777_ _03074_ _03085_ VGND VGND VPWR VPWR _03096_ sky130_fd_sc_hd__nor2_1
X_09565_ _02308_ _02313_ VGND VGND VPWR VPWR _02314_ sky130_fd_sc_hd__xor2_2
X_09496_ _02106_ _02122_ _02121_ VGND VGND VPWR VPWR _02239_ sky130_fd_sc_hd__o21a_1
XFILLER_90_18 VGND VGND VPWR VPWR sky130_fd_sc_hd__fill_2
X_08516_ _01232_ _01243_ VGND VGND VPWR VPWR _01245_ sky130_fd_sc_hd__xnor2_1
XFILLER_82_197 VGND VGND VPWR VPWR sky130_fd_sc_hd__decap_3
X_08447_ net692 net258 net256 net270 VGND VGND VPWR VPWR _01176_ sky130_fd_sc_hd__a22oi_1
XFILLER_23_242 VPWR VGND VPWR VGND sky130_ef_sc_hd__decap_12
XTAP_TAPCELL_ROW_34_771 VGND VPWR sky130_fd_sc_hd__tapvpwrvgnd_1
XFILLER_11_426 VPWR VGND VPWR VGND sky130_ef_sc_hd__decap_12
XFILLER_23_45 VGND VGND VPWR VPWR sky130_fd_sc_hd__decap_8
XFILLER_23_297 VGND VGND VPWR VPWR sky130_fd_sc_hd__decap_8
X_08378_ _01108_ VGND VGND VPWR VPWR _01109_ sky130_fd_sc_hd__inv_2
X_07329_ _06617_ _06618_ net389 net310 VGND VGND VPWR VPWR _06620_ sky130_fd_sc_hd__and4bb_1
XTAP_TAPCELL_ROW_115_1910 VGND VPWR sky130_fd_sc_hd__tapvpwrvgnd_1
X_10340_ _03150_ _03132_ _03153_ VGND VGND VPWR VPWR _03155_ sky130_fd_sc_hd__or3_4
X_10271_ _02904_ _02906_ VGND VGND VPWR VPWR _03079_ sky130_fd_sc_hd__nor2_1
X_12010_ _04972_ _04855_ _04973_ VGND VGND VPWR VPWR _04975_ sky130_fd_sc_hd__or3_4
XFILLER_105_597 VGND VGND VPWR VPWR sky130_fd_sc_hd__decap_6
XTAP_TAPCELL_ROW_57_1094 VGND VPWR sky130_fd_sc_hd__tapvpwrvgnd_1
XFILLER_120_545 VGND VGND VPWR VPWR sky130_fd_sc_hd__decap_4
Xfanout450 net451 VGND VGND VPWR VPWR net450 sky130_fd_sc_hd__buf_2
Xfanout483 net484 VGND VGND VPWR VPWR net483 sky130_fd_sc_hd__buf_4
Xfanout461 net26 VGND VGND VPWR VPWR net461 sky130_fd_sc_hd__dlymetal6s2s_1
XTAP_TAPCELL_ROW_70_1272 VGND VPWR sky130_fd_sc_hd__tapvpwrvgnd_1
Xfanout472 net474 VGND VGND VPWR VPWR net472 sky130_fd_sc_hd__buf_1
Xfanout494 net22 VGND VGND VPWR VPWR net494 sky130_fd_sc_hd__clkbuf_4
XFILLER_100_280 VGND VGND VPWR VPWR sky130_fd_sc_hd__decap_8
XFILLER_58_172 VGND VGND VPWR VPWR sky130_fd_sc_hd__fill_2
X_12912_ _05958_ _05959_ VGND VGND VPWR VPWR _00027_ sky130_fd_sc_hd__xnor2_1
XFILLER_19_537 VGND VGND VPWR VPWR sky130_fd_sc_hd__decap_4
XFILLER_19_548 VPWR VGND VPWR VGND sky130_ef_sc_hd__decap_12
XFILLER_73_153 VPWR VGND VPWR VGND sky130_ef_sc_hd__decap_12
XFILLER_58_194 VGND VGND VPWR VPWR sky130_fd_sc_hd__fill_2
XFILLER_0_49 VGND VGND VPWR VPWR sky130_fd_sc_hd__decap_6
XFILLER_0_27 VGND VGND VPWR VPWR sky130_fd_sc_hd__fill_1
X_12843_ _05872_ _05883_ VGND VGND VPWR VPWR _05884_ sky130_fd_sc_hd__xor2_1
XFILLER_64_85 VGND VGND VPWR VPWR sky130_fd_sc_hd__fill_2
X_12774_ _05806_ _05807_ VGND VGND VPWR VPWR _05809_ sky130_fd_sc_hd__xor2_1
X_11725_ _04661_ _04662_ _04613_ VGND VGND VPWR VPWR _04663_ sky130_fd_sc_hd__or3b_2
XFILLER_14_253 VPWR VGND VPWR VGND sky130_ef_sc_hd__decap_12
XFILLER_15_765 VPWR VGND VPWR VGND sky130_ef_sc_hd__decap_12
XFILLER_80_40 VGND VGND VPWR VPWR sky130_fd_sc_hd__decap_8
XFILLER_30_757 VGND VGND VPWR VPWR sky130_fd_sc_hd__decap_8
XFILLER_128_601 VGND VGND VPWR VPWR sky130_fd_sc_hd__decap_3
X_11656_ _04586_ _04587_ VGND VGND VPWR VPWR _04588_ sky130_fd_sc_hd__nor2_1
XFILLER_128_645 VPWR VGND VPWR VGND sky130_ef_sc_hd__decap_12
XFILLER_127_111 VGND VGND VPWR VPWR sky130_fd_sc_hd__fill_1
XTAP_TAPCELL_ROW_12_465 VGND VPWR sky130_fd_sc_hd__tapvpwrvgnd_1
X_11587_ _04163_ _04410_ _04409_ VGND VGND VPWR VPWR _04517_ sky130_fd_sc_hd__a21o_1
X_10607_ _03283_ _03444_ VGND VGND VPWR VPWR _03446_ sky130_fd_sc_hd__nor2_1
X_13326_ net392 VGND VGND VPWR VPWR _00100_ sky130_fd_sc_hd__inv_2
X_10538_ _03365_ _03369_ VGND VGND VPWR VPWR _03370_ sky130_fd_sc_hd__xnor2_1
XFILLER_6_441 VGND VGND VPWR VPWR sky130_fd_sc_hd__decap_3
XFILLER_127_199 VGND VGND VPWR VPWR sky130_fd_sc_hd__decap_8
XFILLER_115_328 VGND VGND VPWR VPWR sky130_fd_sc_hd__decap_8
X_13257_ _06326_ _06331_ VGND VGND VPWR VPWR _06335_ sky130_fd_sc_hd__xnor2_1
X_10469_ _03291_ _03293_ _03290_ VGND VGND VPWR VPWR _03295_ sky130_fd_sc_hd__o21ai_1
X_12208_ _05031_ _05189_ VGND VGND VPWR VPWR _05190_ sky130_fd_sc_hd__xnor2_1
X_13188_ _06258_ _06260_ VGND VGND VPWR VPWR _06261_ sky130_fd_sc_hd__nor2_1
XFILLER_97_746 VGND VGND VPWR VPWR sky130_fd_sc_hd__decap_3
XFILLER_96_245 VGND VGND VPWR VPWR sky130_fd_sc_hd__fill_1
X_12139_ _04962_ _04964_ _05113_ net833 VGND VGND VPWR VPWR _05115_ sky130_fd_sc_hd__o211ai_2
XFILLER_49_150 VGND VGND VPWR VPWR sky130_fd_sc_hd__fill_2
XTAP_TAPCELL_ROW_88_1533 VGND VPWR sky130_fd_sc_hd__tapvpwrvgnd_1
XTAP_TAPCELL_ROW_88_1522 VGND VPWR sky130_fd_sc_hd__tapvpwrvgnd_1
X_06700_ net677 VGND VGND VPWR VPWR _02262_ sky130_fd_sc_hd__inv_2
X_07680_ _00262_ _00264_ _00418_ _00419_ VGND VGND VPWR VPWR _00420_ sky130_fd_sc_hd__o211ai_2
XFILLER_18_570 VPWR VGND VPWR VGND sky130_ef_sc_hd__decap_12
XFILLER_25_529 VGND VGND VPWR VPWR sky130_fd_sc_hd__fill_2
X_09350_ _02078_ _02080_ VGND VGND VPWR VPWR _00063_ sky130_fd_sc_hd__xnor2_1
XFILLER_64_197 VGND VGND VPWR VPWR sky130_fd_sc_hd__decap_3
X_08301_ _01033_ _01035_ VGND VGND VPWR VPWR _00043_ sky130_fd_sc_hd__xor2_1
X_09281_ _02002_ _02003_ net447 net537 VGND VGND VPWR VPWR _02005_ sky130_fd_sc_hd__and4bb_1
X_08232_ _00750_ _00966_ VGND VGND VPWR VPWR _00967_ sky130_fd_sc_hd__xnor2_1
XFILLER_20_245 VGND VGND VPWR VPWR sky130_fd_sc_hd__decap_6
XTAP_TAPCELL_ROW_31_730 VGND VPWR sky130_fd_sc_hd__tapvpwrvgnd_1
X_08163_ _00782_ _00786_ _00785_ VGND VGND VPWR VPWR _00899_ sky130_fd_sc_hd__a21bo_1
XFILLER_109_15 VPWR VGND VPWR VGND sky130_ef_sc_hd__decap_12
X_07114_ net527 net680 net678 net532 VGND VGND VPWR VPWR _06406_ sky130_fd_sc_hd__a22oi_1
XTAP_TAPCELL_ROW_99_1684 VGND VPWR sky130_fd_sc_hd__tapvpwrvgnd_1
X_08094_ _00387_ _00712_ VGND VGND VPWR VPWR _00830_ sky130_fd_sc_hd__nand2_1
XFILLER_134_637 VGND VGND VPWR VPWR sky130_fd_sc_hd__decap_6
XFILLER_133_125 VPWR VGND VPWR VGND sky130_ef_sc_hd__decap_12
XFILLER_106_328 VGND VGND VPWR VPWR sky130_fd_sc_hd__decap_8
X_07045_ _06008_ VGND VGND VPWR VPWR _06019_ sky130_fd_sc_hd__inv_2
XFILLER_69_19 VPWR VGND VPWR VGND sky130_ef_sc_hd__decap_12
XFILLER_133_169 VPWR VGND VPWR VGND sky130_ef_sc_hd__decap_12
XFILLER_114_350 VGND VGND VPWR VPWR sky130_fd_sc_hd__decap_4
XFILLER_102_501 VGND VGND VPWR VPWR sky130_fd_sc_hd__fill_1
XFILLER_0_617 VPWR VGND VPWR VGND sky130_ef_sc_hd__decap_12
XTAP_TAPCELL_ROW_110_1840 VGND VPWR sky130_fd_sc_hd__tapvpwrvgnd_1
XFILLER_102_545 VPWR VGND VPWR VGND sky130_ef_sc_hd__decap_12
X_08996_ _01705_ _01720_ VGND VGND VPWR VPWR _01722_ sky130_fd_sc_hd__xor2_1
XFILLER_125_69 VPWR VGND VPWR VGND sky130_ef_sc_hd__decap_12
X_07947_ _00659_ _00684_ VGND VGND VPWR VPWR _00685_ sky130_fd_sc_hd__and2b_1
XTAP_TAPCELL_ROW_126_2058 VGND VPWR sky130_fd_sc_hd__tapvpwrvgnd_1
X_07878_ net385 net383 net287 VGND VGND VPWR VPWR _00616_ sky130_fd_sc_hd__and3_1
XTAP_TAPCELL_ROW_39_841 VGND VPWR sky130_fd_sc_hd__tapvpwrvgnd_1
X_09617_ _02228_ _02229_ _02234_ VGND VGND VPWR VPWR _02372_ sky130_fd_sc_hd__o21ba_4
X_06829_ _03335_ _03642_ VGND VGND VPWR VPWR _03664_ sky130_fd_sc_hd__or2_1
XFILLER_56_687 VGND VGND VPWR VPWR sky130_fd_sc_hd__decap_4
XFILLER_43_315 VGND VGND VPWR VPWR sky130_fd_sc_hd__decap_4
X_09548_ _01677_ _02294_ VGND VGND VPWR VPWR _02297_ sky130_fd_sc_hd__xnor2_1
XFILLER_43_337 VGND VGND VPWR VPWR sky130_fd_sc_hd__fill_1
XFILLER_70_156 VGND VGND VPWR VPWR sky130_fd_sc_hd__decap_6
XFILLER_12_713 VPWR VGND VPWR VGND sky130_ef_sc_hd__decap_12
X_09479_ _02220_ _02221_ VGND VGND VPWR VPWR _02222_ sky130_fd_sc_hd__and2b_1
XFILLER_11_201 VGND VGND VPWR VPWR sky130_fd_sc_hd__decap_4
X_11510_ _03985_ _04320_ VGND VGND VPWR VPWR _04432_ sky130_fd_sc_hd__nor2_1
XFILLER_34_77 VGND VGND VPWR VPWR sky130_fd_sc_hd__decap_6
XFILLER_133_3 VPWR VGND VPWR VGND sky130_ef_sc_hd__decap_12
XTAP_TAPCELL_ROW_121_1991 VGND VPWR sky130_fd_sc_hd__tapvpwrvgnd_1
XFILLER_11_245 VPWR VGND VPWR VGND sky130_ef_sc_hd__decap_12
XFILLER_7_205 VPWR VGND VPWR VGND sky130_ef_sc_hd__decap_12
XFILLER_12_757 VPWR VGND VPWR VGND sky130_ef_sc_hd__decap_12
X_12490_ net592 net567 net296 net294 VGND VGND VPWR VPWR _05498_ sky130_fd_sc_hd__and4_1
X_11441_ _04332_ _04355_ VGND VGND VPWR VPWR _04357_ sky130_fd_sc_hd__xnor2_1
XFILLER_11_289 VGND VGND VPWR VPWR sky130_fd_sc_hd__decap_3
XTAP_TAPCELL_ROW_59_1123 VGND VPWR sky130_fd_sc_hd__tapvpwrvgnd_1
XFILLER_7_249 VPWR VGND VPWR VGND sky130_ef_sc_hd__decap_12
X_11372_ _04279_ _04280_ VGND VGND VPWR VPWR _04282_ sky130_fd_sc_hd__xor2_1
XFILLER_125_648 VPWR VGND VPWR VGND sky130_ef_sc_hd__decap_12
XFILLER_124_125 VGND VGND VPWR VPWR sky130_fd_sc_hd__fill_1
XFILLER_50_98 VPWR VGND VPWR VGND sky130_ef_sc_hd__decap_12
X_10323_ _03134_ _03135_ VGND VGND VPWR VPWR _03136_ sky130_fd_sc_hd__nor2_1
X_13111_ _06042_ _06176_ VGND VGND VPWR VPWR _06177_ sky130_fd_sc_hd__xnor2_1
XTAP_TAPCELL_ROW_72_1301 VGND VPWR sky130_fd_sc_hd__tapvpwrvgnd_1
XFILLER_124_169 VPWR VGND VPWR VGND sky130_ef_sc_hd__decap_12
XFILLER_112_309 VPWR VGND VPWR VGND sky130_ef_sc_hd__decap_12
X_10254_ net664 net278 VGND VGND VPWR VPWR _03060_ sky130_fd_sc_hd__nand2_1
XFILLER_59_30 VPWR VGND VPWR VGND sky130_ef_sc_hd__decap_12
X_13042_ net290 net361 _02284_ net312 VGND VGND VPWR VPWR _06101_ sky130_fd_sc_hd__o2bb2a_1
XFILLER_78_223 VGND VGND VPWR VPWR sky130_fd_sc_hd__decap_4
X_10185_ _02982_ net712 _02970_ VGND VGND VPWR VPWR _02985_ sky130_fd_sc_hd__a21o_1
XFILLER_59_96 VPWR VGND VPWR VGND sky130_ef_sc_hd__decap_12
XFILLER_120_397 VGND VGND VPWR VPWR sky130_fd_sc_hd__fill_2
XFILLER_93_237 VGND VGND VPWR VPWR sky130_fd_sc_hd__decap_3
XFILLER_78_289 VPWR VGND VPWR VGND sky130_ef_sc_hd__decap_12
Xfanout291 net292 VGND VGND VPWR VPWR net291 sky130_fd_sc_hd__buf_4
XFILLER_59_492 VGND VGND VPWR VPWR sky130_fd_sc_hd__decap_3
Xfanout280 net281 VGND VGND VPWR VPWR net280 sky130_fd_sc_hd__clkbuf_2
XFILLER_15_9 VGND VGND VPWR VPWR sky130_fd_sc_hd__fill_1
XFILLER_19_312 VGND VGND VPWR VPWR sky130_fd_sc_hd__fill_1
XFILLER_75_84 VGND VGND VPWR VPWR sky130_fd_sc_hd__decap_3
XFILLER_19_389 VGND VGND VPWR VPWR sky130_fd_sc_hd__decap_3
XFILLER_61_123 VGND VGND VPWR VPWR sky130_fd_sc_hd__decap_6
XFILLER_46_197 VGND VGND VPWR VPWR sky130_fd_sc_hd__decap_4
X_12826_ net315 net362 VGND VGND VPWR VPWR _05865_ sky130_fd_sc_hd__nand2_1
XTAP_TAPCELL_ROW_17_535 VGND VPWR sky130_fd_sc_hd__tapvpwrvgnd_1
XFILLER_34_348 VPWR VGND VPWR VGND sky130_ef_sc_hd__decap_12
XTAP_TAPCELL_ROW_83_1463 VGND VPWR sky130_fd_sc_hd__tapvpwrvgnd_1
XTAP_TAPCELL_ROW_83_1452 VGND VPWR sky130_fd_sc_hd__tapvpwrvgnd_1
XFILLER_15_551 VGND VGND VPWR VPWR sky130_fd_sc_hd__fill_1
X_12757_ _05773_ _05788_ VGND VGND VPWR VPWR _05791_ sky130_fd_sc_hd__xor2_1
XFILLER_30_510 VPWR VGND VPWR VGND sky130_ef_sc_hd__decap_12
X_11708_ _04642_ _04644_ VGND VGND VPWR VPWR _04645_ sky130_fd_sc_hd__and2_1
X_12688_ _05712_ _05714_ VGND VGND VPWR VPWR _05715_ sky130_fd_sc_hd__xnor2_1
XFILLER_42_392 VPWR VGND VPWR VGND sky130_ef_sc_hd__decap_12
X_11639_ _04572_ _04521_ VGND VGND VPWR VPWR _00018_ sky130_fd_sc_hd__xnor2_1
XFILLER_128_475 VGND VGND VPWR VPWR sky130_fd_sc_hd__fill_1
X_13309_ net396 VGND VGND VPWR VPWR _00083_ sky130_fd_sc_hd__inv_2
XFILLER_7_783 VGND VGND VPWR VPWR sky130_fd_sc_hd__fill_1
XFILLER_131_629 VPWR VGND VPWR VGND sky130_ef_sc_hd__decap_12
XFILLER_124_670 VGND VGND VPWR VPWR sky130_fd_sc_hd__fill_1
XFILLER_115_169 VPWR VGND VPWR VGND sky130_ef_sc_hd__decap_12
XFILLER_103_309 VGND VGND VPWR VPWR sky130_fd_sc_hd__fill_1
XFILLER_130_139 VGND VGND VPWR VPWR sky130_fd_sc_hd__fill_1
XFILLER_124_681 VPWR VGND VPWR VGND sky130_ef_sc_hd__decap_12
XFILLER_111_320 VGND VGND VPWR VPWR sky130_fd_sc_hd__fill_2
X_08850_ _01575_ _01574_ _01489_ VGND VGND VPWR VPWR _01577_ sky130_fd_sc_hd__a21o_1
X_07801_ _00538_ _00539_ VGND VGND VPWR VPWR _00540_ sky130_fd_sc_hd__xnor2_1
XFILLER_111_386 VGND VGND VPWR VPWR sky130_fd_sc_hd__decap_3
X_08781_ _01506_ _01507_ _01391_ VGND VGND VPWR VPWR _01508_ sky130_fd_sc_hd__a21oi_1
XFILLER_57_429 VPWR VGND VPWR VGND sky130_ef_sc_hd__decap_12
X_07732_ _00455_ _00470_ VGND VGND VPWR VPWR _00471_ sky130_fd_sc_hd__xnor2_1
X_07663_ _00396_ _00401_ VGND VGND VPWR VPWR _00403_ sky130_fd_sc_hd__xor2_1
XFILLER_53_602 VGND VGND VPWR VPWR sky130_fd_sc_hd__decap_3
XFILLER_1_81 VPWR VGND VPWR VGND sky130_ef_sc_hd__decap_12
XTAP_TAPCELL_ROW_36_800 VGND VPWR sky130_fd_sc_hd__tapvpwrvgnd_1
XFILLER_38_687 VGND VGND VPWR VPWR sky130_fd_sc_hd__fill_2
XFILLER_111_27 VGND VGND VPWR VPWR sky130_fd_sc_hd__decap_8
X_09402_ net631 net629 net480 VGND VGND VPWR VPWR _02137_ sky130_fd_sc_hd__o21a_1
XFILLER_80_443 VPWR VGND VPWR VGND sky130_ef_sc_hd__decap_12
XFILLER_80_421 VPWR VGND VPWR VGND sky130_ef_sc_hd__decap_12
XPHY_EDGE_ROW_9_Left_146 VGND VGND VPWR VPWR sky130_fd_sc_hd__decap_3
XFILLER_25_337 VPWR VGND VPWR VGND sky130_ef_sc_hd__decap_12
X_07594_ net684 net682 net483 net476 VGND VGND VPWR VPWR _00334_ sky130_fd_sc_hd__and4_1
X_09333_ _02059_ _02060_ _01893_ _01895_ VGND VGND VPWR VPWR _02062_ sky130_fd_sc_hd__a211o_4
XFILLER_33_381 VGND VGND VPWR VPWR sky130_fd_sc_hd__fill_1
X_09264_ _01825_ _01987_ VGND VGND VPWR VPWR _01988_ sky130_fd_sc_hd__xnor2_1
X_09195_ _01760_ _01776_ _01775_ VGND VGND VPWR VPWR _01919_ sky130_fd_sc_hd__o21a_1
X_08215_ _00831_ _00949_ VGND VGND VPWR VPWR _00950_ sky130_fd_sc_hd__xnor2_1
X_08146_ _00868_ _00881_ VGND VGND VPWR VPWR _00882_ sky130_fd_sc_hd__xnor2_1
XFILLER_5_709 VPWR VGND VPWR VGND sky130_ef_sc_hd__decap_12
XFILLER_119_486 VPWR VGND VPWR VGND sky130_ef_sc_hd__decap_12
XFILLER_134_445 VPWR VGND VPWR VGND sky130_ef_sc_hd__decap_12
X_08077_ _00813_ _00812_ VGND VGND VPWR VPWR _00814_ sky130_fd_sc_hd__nand2b_1
XFILLER_107_659 VGND VGND VPWR VPWR sky130_fd_sc_hd__fill_1
XFILLER_136_57 VPWR VGND VPWR VGND sky130_ef_sc_hd__decap_12
XFILLER_134_489 VPWR VGND VPWR VGND sky130_ef_sc_hd__decap_12
X_07028_ net695 net381 VGND VGND VPWR VPWR _05833_ sky130_fd_sc_hd__nand2_1
XFILLER_121_139 VGND VGND VPWR VPWR sky130_fd_sc_hd__decap_8
XFILLER_121_128 VGND VGND VPWR VPWR sky130_fd_sc_hd__fill_2
XFILLER_114_180 VGND VGND VPWR VPWR sky130_fd_sc_hd__fill_2
XTAP_TAPCELL_ROW_54_1053 VGND VPWR sky130_fd_sc_hd__tapvpwrvgnd_1
XFILLER_48_418 VGND VGND VPWR VPWR sky130_fd_sc_hd__fill_2
XFILLER_0_447 VGND VGND VPWR VPWR sky130_fd_sc_hd__fill_1
XFILLER_102_397 VPWR VGND VPWR VGND sky130_ef_sc_hd__decap_12
XFILLER_88_587 VGND VGND VPWR VPWR sky130_fd_sc_hd__fill_1
XFILLER_75_215 VGND VGND VPWR VPWR sky130_fd_sc_hd__decap_8
X_08979_ _01542_ _01704_ VGND VGND VPWR VPWR _01705_ sky130_fd_sc_hd__xnor2_1
XFILLER_91_708 VGND VGND VPWR VPWR sky130_fd_sc_hd__fill_2
X_11990_ _04947_ _04948_ _04950_ VGND VGND VPWR VPWR _04953_ sky130_fd_sc_hd__a21oi_1
XFILLER_28_120 VGND VGND VPWR VPWR sky130_fd_sc_hd__decap_6
X_10941_ _03807_ _03809_ _03810_ VGND VGND VPWR VPWR _03811_ sky130_fd_sc_hd__nor3_1
XFILLER_28_153 VGND VGND VPWR VPWR sky130_fd_sc_hd__decap_3
XFILLER_83_281 VGND VGND VPWR VPWR sky130_fd_sc_hd__fill_2
XFILLER_28_197 VPWR VGND VPWR VGND sky130_ef_sc_hd__decap_12
XFILLER_71_465 VGND VGND VPWR VPWR sky130_fd_sc_hd__decap_8
X_12611_ _05621_ _05630_ VGND VGND VPWR VPWR _05631_ sky130_fd_sc_hd__xor2_1
X_10872_ _03732_ _03733_ VGND VGND VPWR VPWR _03735_ sky130_fd_sc_hd__nor2_1
XFILLER_43_178 VPWR VGND VPWR VGND sky130_ef_sc_hd__decap_12
XFILLER_101_82 VGND VGND VPWR VPWR sky130_fd_sc_hd__fill_1
X_12542_ net492 net662 _05551_ _05554_ VGND VGND VPWR VPWR _05555_ sky130_fd_sc_hd__a22o_1
X_12473_ _05294_ _05296_ _05479_ _05478_ VGND VGND VPWR VPWR _05480_ sky130_fd_sc_hd__a211oi_4
XFILLER_6_15 VPWR VGND VPWR VGND sky130_ef_sc_hd__decap_12
X_11424_ _04336_ _04337_ VGND VGND VPWR VPWR _04338_ sky130_fd_sc_hd__or2_1
XFILLER_125_423 VPWR VGND VPWR VGND sky130_ef_sc_hd__decap_12
XFILLER_125_401 VGND VGND VPWR VPWR sky130_fd_sc_hd__decap_3
XANTENNA_8 _02098_ VGND VGND VPWR VPWR sky130_fd_sc_hd__diode_2
X_11355_ _04262_ _04255_ VGND VGND VPWR VPWR _04263_ sky130_fd_sc_hd__nand2b_1
X_10306_ net433 net443 net578 net576 VGND VGND VPWR VPWR _03117_ sky130_fd_sc_hd__and4_1
X_11286_ _04184_ _04185_ VGND VGND VPWR VPWR _04187_ sky130_fd_sc_hd__xnor2_1
XFILLER_79_532 VGND VGND VPWR VPWR sky130_fd_sc_hd__decap_8
X_10237_ _03041_ _03038_ _03040_ VGND VGND VPWR VPWR _03043_ sky130_fd_sc_hd__nor3b_2
X_13025_ _06080_ _06081_ VGND VGND VPWR VPWR _06083_ sky130_fd_sc_hd__xor2_1
XFILLER_121_673 VGND VGND VPWR VPWR sky130_fd_sc_hd__decap_8
XFILLER_94_513 VGND VGND VPWR VPWR sky130_fd_sc_hd__fill_2
XFILLER_79_587 VPWR VGND VPWR VGND sky130_ef_sc_hd__decap_12
XFILLER_67_749 VGND VGND VPWR VPWR sky130_fd_sc_hd__decap_6
XFILLER_66_204 VGND VGND VPWR VPWR sky130_fd_sc_hd__decap_3
X_10168_ net694 net348 VGND VGND VPWR VPWR _02967_ sky130_fd_sc_hd__nand2_1
XFILLER_39_418 VPWR VGND VPWR VGND sky130_ef_sc_hd__decap_12
X_10099_ net689 net279 VGND VGND VPWR VPWR _02891_ sky130_fd_sc_hd__nand2_1
XFILLER_66_248 VGND VGND VPWR VPWR sky130_fd_sc_hd__fill_1
XFILLER_62_421 VPWR VGND VPWR VGND sky130_ef_sc_hd__decap_12
XFILLER_35_657 VGND VGND VPWR VPWR sky130_fd_sc_hd__decap_4
XFILLER_50_605 VPWR VGND VPWR VGND sky130_ef_sc_hd__decap_12
XFILLER_43_690 VGND VGND VPWR VPWR sky130_fd_sc_hd__decap_8
XFILLER_15_370 VPWR VGND VPWR VGND sky130_ef_sc_hd__decap_12
X_12809_ _05524_ _05846_ VGND VGND VPWR VPWR _05847_ sky130_fd_sc_hd__xnor2_1
X_08000_ net602 _00735_ VGND VGND VPWR VPWR _00737_ sky130_fd_sc_hd__and2_1
XTAP_TAPCELL_ROW_96_1643 VGND VPWR sky130_fd_sc_hd__tapvpwrvgnd_1
XTAP_TAPCELL_ROW_96_1632 VGND VPWR sky130_fd_sc_hd__tapvpwrvgnd_1
XFILLER_116_445 VPWR VGND VPWR VGND sky130_ef_sc_hd__decap_12
Xmax_cap244 _05612_ VGND VGND VPWR VPWR net244 sky130_fd_sc_hd__buf_1
Xmax_cap233 _05460_ VGND VGND VPWR VPWR net233 sky130_fd_sc_hd__buf_1
X_09951_ _02674_ _02706_ VGND VGND VPWR VPWR _02733_ sky130_fd_sc_hd__nor2_1
XFILLER_104_618 VPWR VGND VPWR VGND sky130_ef_sc_hd__decap_12
XFILLER_89_318 VGND VGND VPWR VPWR sky130_fd_sc_hd__fill_1
XFILLER_131_426 VPWR VGND VPWR VGND sky130_ef_sc_hd__decap_12
X_08902_ _01626_ _01627_ VGND VGND VPWR VPWR _01628_ sky130_fd_sc_hd__nand2_1
XFILLER_106_27 VGND VGND VPWR VPWR sky130_fd_sc_hd__fill_1
XFILLER_97_340 VGND VGND VPWR VPWR sky130_fd_sc_hd__fill_1
X_09882_ _02654_ _02657_ VGND VGND VPWR VPWR _02659_ sky130_fd_sc_hd__or2_1
XFILLER_85_502 VGND VGND VPWR VPWR sky130_fd_sc_hd__fill_2
XFILLER_112_684 VGND VGND VPWR VPWR sky130_fd_sc_hd__decap_3
XFILLER_111_161 VGND VGND VPWR VPWR sky130_fd_sc_hd__decap_6
X_08833_ _01557_ _01558_ _01550_ VGND VGND VPWR VPWR _01560_ sky130_fd_sc_hd__a21o_1
X_08764_ net530 net625 VGND VGND VPWR VPWR _01491_ sky130_fd_sc_hd__nand2_1
X_07715_ _00451_ _00452_ VGND VGND VPWR VPWR _00454_ sky130_fd_sc_hd__xnor2_1
XTAP_TAPCELL_ROW_123_2017 VGND VPWR sky130_fd_sc_hd__tapvpwrvgnd_1
XFILLER_122_15 VPWR VGND VPWR VGND sky130_ef_sc_hd__decap_12
XFILLER_66_782 VGND VGND VPWR VPWR sky130_fd_sc_hd__decap_4
XFILLER_26_613 VPWR VGND VPWR VGND sky130_ef_sc_hd__decap_12
X_08695_ _01256_ _01268_ _01267_ VGND VGND VPWR VPWR _01423_ sky130_fd_sc_hd__a21bo_1
XFILLER_65_281 VPWR VGND VPWR VGND sky130_ef_sc_hd__decap_12
XTAP_TAPCELL_ROW_49_980 VGND VPWR sky130_fd_sc_hd__tapvpwrvgnd_1
XFILLER_26_657 VPWR VGND VPWR VGND sky130_ef_sc_hd__decap_12
XFILLER_38_495 VGND VGND VPWR VPWR sky130_fd_sc_hd__fill_1
XFILLER_81_785 VGND VGND VPWR VPWR sky130_fd_sc_hd__decap_4
XFILLER_81_774 VGND VGND VPWR VPWR sky130_fd_sc_hd__decap_8
X_07646_ net387 net310 _00231_ net713 VGND VGND VPWR VPWR _00386_ sky130_fd_sc_hd__a31o_1
XTAP_TAPCELL_ROW_0_277 VGND VPWR sky130_fd_sc_hd__tapvpwrvgnd_1
XTAP_TAPCELL_ROW_0_288 VGND VPWR sky130_fd_sc_hd__tapvpwrvgnd_1
XFILLER_15_13 VGND VGND VPWR VPWR sky130_fd_sc_hd__fill_2
X_07577_ _00140_ _00155_ _00154_ VGND VGND VPWR VPWR _00317_ sky130_fd_sc_hd__a21o_1
XTAP_TAPCELL_ROW_105_1761 VGND VPWR sky130_fd_sc_hd__tapvpwrvgnd_1
XTAP_TAPCELL_ROW_0_299 VGND VPWR sky130_fd_sc_hd__tapvpwrvgnd_1
XFILLER_15_57 VGND VGND VPWR VPWR sky130_fd_sc_hd__decap_8
XFILLER_80_295 VGND VGND VPWR VPWR sky130_fd_sc_hd__decap_3
X_09316_ _02041_ _02042_ VGND VGND VPWR VPWR _02043_ sky130_fd_sc_hd__xnor2_1
X_09247_ _02044_ net129 VGND VGND VPWR VPWR _01971_ sky130_fd_sc_hd__and2_1
XFILLER_135_721 VGND VGND VPWR VPWR sky130_fd_sc_hd__decap_6
XFILLER_126_209 VPWR VGND VPWR VGND sky130_ef_sc_hd__decap_12
X_09178_ _01734_ _01736_ _01901_ net883 VGND VGND VPWR VPWR _01903_ sky130_fd_sc_hd__o211ai_2
XFILLER_5_517 VPWR VGND VPWR VGND sky130_ef_sc_hd__decap_12
XFILLER_135_765 VPWR VGND VPWR VGND sky130_ef_sc_hd__decap_12
XTAP_TAPCELL_ROW_134_2168 VGND VPWR sky130_fd_sc_hd__tapvpwrvgnd_1
XFILLER_107_445 VGND VGND VPWR VPWR sky130_fd_sc_hd__decap_3
X_08129_ _00863_ _00864_ VGND VGND VPWR VPWR _00865_ sky130_fd_sc_hd__nor2_1
XFILLER_31_78 VGND VGND VPWR VPWR sky130_fd_sc_hd__decap_8
XFILLER_134_253 VPWR VGND VPWR VGND sky130_ef_sc_hd__decap_12
X_11140_ _03869_ _04027_ VGND VGND VPWR VPWR _04028_ sky130_fd_sc_hd__nor2_1
Xinput101 w20[3] VGND VGND VPWR VPWR net101 sky130_fd_sc_hd__clkbuf_1
X_11071_ _03951_ _03952_ VGND VGND VPWR VPWR _03953_ sky130_fd_sc_hd__nand2_1
Xinput123 w23[1] VGND VGND VPWR VPWR net123 sky130_fd_sc_hd__clkbuf_1
Xinput134 w30[4] VGND VGND VPWR VPWR net134 sky130_fd_sc_hd__buf_1
X_10022_ _02806_ _02807_ VGND VGND VPWR VPWR _02808_ sky130_fd_sc_hd__nand2_1
XFILLER_0_277 VGND VGND VPWR VPWR sky130_fd_sc_hd__decap_3
Xinput145 w31[7] VGND VGND VPWR VPWR net145 sky130_fd_sc_hd__buf_2
Xinput112 w21[6] VGND VGND VPWR VPWR net112 sky130_fd_sc_hd__buf_1
Xinput156 w33[2] VGND VGND VPWR VPWR net156 sky130_fd_sc_hd__buf_1
XFILLER_57_782 VGND VGND VPWR VPWR sky130_fd_sc_hd__fill_2
XTAP_TAPCELL_ROW_67_1233 VGND VPWR sky130_fd_sc_hd__tapvpwrvgnd_1
X_11973_ net515 net428 net367 net364 VGND VGND VPWR VPWR _04934_ sky130_fd_sc_hd__and4_1
XFILLER_44_421 VGND VGND VPWR VPWR sky130_fd_sc_hd__decap_6
XFILLER_44_410 VGND VGND VPWR VPWR sky130_fd_sc_hd__decap_8
XPHY_EDGE_ROW_113_Right_113 VGND VGND VPWR VPWR sky130_fd_sc_hd__decap_3
XFILLER_71_251 VGND VGND VPWR VPWR sky130_fd_sc_hd__fill_2
X_10924_ _03790_ _03791_ VGND VGND VPWR VPWR _03792_ sky130_fd_sc_hd__xnor2_1
XTAP_TAPCELL_ROW_80_1411 VGND VPWR sky130_fd_sc_hd__tapvpwrvgnd_1
XFILLER_72_796 VGND VGND VPWR VPWR sky130_fd_sc_hd__fill_1
XTAP_TAPCELL_ROW_27_674 VGND VPWR sky130_fd_sc_hd__tapvpwrvgnd_1
XFILLER_31_104 VGND VGND VPWR VPWR sky130_fd_sc_hd__decap_8
X_10855_ _03715_ VGND VGND VPWR VPWR _03716_ sky130_fd_sc_hd__inv_2
XFILLER_31_137 VGND VGND VPWR VPWR sky130_fd_sc_hd__decap_4
X_10786_ _03638_ _03639_ _03640_ VGND VGND VPWR VPWR _03641_ sky130_fd_sc_hd__nand3_1
X_12525_ _05532_ _05533_ VGND VGND VPWR VPWR _05536_ sky130_fd_sc_hd__xor2_1
XFILLER_8_333 VPWR VGND VPWR VGND sky130_ef_sc_hd__decap_12
XFILLER_8_377 VPWR VGND VPWR VGND sky130_ef_sc_hd__decap_12
X_12456_ _05422_ _05423_ _05458_ _05459_ VGND VGND VPWR VPWR _05461_ sky130_fd_sc_hd__o22a_1
X_11407_ _04093_ _04317_ VGND VGND VPWR VPWR _04320_ sky130_fd_sc_hd__and2_1
X_12387_ _02295_ _05195_ VGND VGND VPWR VPWR _05386_ sky130_fd_sc_hd__or2_2
XFILLER_125_253 VGND VGND VPWR VPWR sky130_fd_sc_hd__decap_8
XTAP_TAPCELL_ROW_78_1384 VGND VPWR sky130_fd_sc_hd__tapvpwrvgnd_1
X_11338_ _04028_ _04244_ VGND VGND VPWR VPWR _04245_ sky130_fd_sc_hd__xor2_1
XFILLER_125_275 VGND VGND VPWR VPWR sky130_fd_sc_hd__fill_1
XFILLER_113_415 VPWR VGND VPWR VGND sky130_ef_sc_hd__decap_12
XTAP_TAPCELL_ROW_91_1573 VGND VPWR sky130_fd_sc_hd__tapvpwrvgnd_1
XTAP_TAPCELL_ROW_91_1562 VGND VPWR sky130_fd_sc_hd__tapvpwrvgnd_1
X_11269_ _03943_ _04070_ _03812_ VGND VGND VPWR VPWR _04169_ sky130_fd_sc_hd__o21a_1
X_13008_ _06064_ _06056_ VGND VGND VPWR VPWR _06065_ sky130_fd_sc_hd__nand2b_1
XFILLER_11_3 VPWR VGND VPWR VGND sky130_ef_sc_hd__decap_12
XFILLER_82_516 VPWR VGND VPWR VGND sky130_ef_sc_hd__decap_12
X_07500_ _00239_ _00240_ VGND VGND VPWR VPWR _00241_ sky130_fd_sc_hd__xnor2_2
XFILLER_54_229 VGND VGND VPWR VPWR sky130_fd_sc_hd__fill_2
XFILLER_47_281 VGND VGND VPWR VPWR sky130_fd_sc_hd__fill_1
X_08480_ _01177_ _01208_ VGND VGND VPWR VPWR _01209_ sky130_fd_sc_hd__or2_1
XFILLER_62_251 VGND VGND VPWR VPWR sky130_fd_sc_hd__fill_1
XFILLER_35_443 VGND VGND VPWR VPWR sky130_fd_sc_hd__decap_4
X_07431_ net684 net682 net490 net483 VGND VGND VPWR VPWR _00172_ sky130_fd_sc_hd__and4_1
XFILLER_90_582 VGND VGND VPWR VPWR sky130_fd_sc_hd__decap_6
XFILLER_63_796 VGND VGND VPWR VPWR sky130_fd_sc_hd__decap_8
XFILLER_63_785 VGND VGND VPWR VPWR sky130_fd_sc_hd__decap_6
X_07362_ _06504_ _06651_ VGND VGND VPWR VPWR _06653_ sky130_fd_sc_hd__or2_1
XFILLER_50_457 VGND VGND VPWR VPWR sky130_fd_sc_hd__fill_1
XPHY_EDGE_ROW_99_Left_236 VGND VGND VPWR VPWR sky130_fd_sc_hd__decap_3
X_09101_ _01823_ _01825_ VGND VGND VPWR VPWR _01826_ sky130_fd_sc_hd__xnor2_1
X_07293_ _06582_ _06583_ VGND VGND VPWR VPWR _06584_ sky130_fd_sc_hd__nand2b_1
XFILLER_136_529 VGND VGND VPWR VPWR sky130_fd_sc_hd__decap_3
X_09032_ _01596_ _01598_ _01595_ VGND VGND VPWR VPWR _01757_ sky130_fd_sc_hd__a21oi_1
XTAP_TAPCELL_ROW_100_1691 VGND VPWR sky130_fd_sc_hd__tapvpwrvgnd_1
XFILLER_132_713 VPWR VGND VPWR VGND sky130_ef_sc_hd__decap_12
XFILLER_117_15 VPWR VGND VPWR VGND sky130_ef_sc_hd__decap_12
XFILLER_116_253 VGND VGND VPWR VPWR sky130_fd_sc_hd__decap_6
XFILLER_131_223 VGND VGND VPWR VPWR sky130_fd_sc_hd__fill_1
XFILLER_132_757 VPWR VGND VPWR VGND sky130_ef_sc_hd__decap_12
X_09934_ _02713_ _02714_ VGND VGND VPWR VPWR _02716_ sky130_fd_sc_hd__or2_1
X_09865_ _02531_ _02639_ VGND VGND VPWR VPWR _02640_ sky130_fd_sc_hd__and2_1
XTAP_TAPCELL_ROW_51_1012 VGND VPWR sky130_fd_sc_hd__tapvpwrvgnd_1
X_08816_ _01541_ _01542_ VGND VGND VPWR VPWR _01543_ sky130_fd_sc_hd__nor2_1
XTAP_TAPCELL_ROW_5_369 VGND VPWR sky130_fd_sc_hd__tapvpwrvgnd_1
XTAP_TAPCELL_ROW_5_358 VGND VPWR sky130_fd_sc_hd__tapvpwrvgnd_1
XFILLER_133_69 VPWR VGND VPWR VGND sky130_ef_sc_hd__decap_12
X_09796_ _02562_ _02563_ VGND VGND VPWR VPWR _02565_ sky130_fd_sc_hd__xnor2_1
XFILLER_85_376 VPWR VGND VPWR VGND sky130_ef_sc_hd__decap_12
XFILLER_85_365 VGND VGND VPWR VPWR sky130_fd_sc_hd__decap_4
X_08747_ net622 net260 VGND VGND VPWR VPWR _01474_ sky130_fd_sc_hd__nand2_1
XFILLER_73_549 VGND VGND VPWR VPWR sky130_fd_sc_hd__fill_1
XFILLER_39_782 VGND VGND VPWR VPWR sky130_fd_sc_hd__fill_2
X_08678_ net422 net557 _01254_ VGND VGND VPWR VPWR _01406_ sky130_fd_sc_hd__a21oi_1
XFILLER_54_774 VGND VGND VPWR VPWR sky130_fd_sc_hd__decap_3
XTAP_TAPCELL_ROW_44_909 VGND VPWR sky130_fd_sc_hd__tapvpwrvgnd_1
X_07629_ net607 net410 VGND VGND VPWR VPWR _00369_ sky130_fd_sc_hd__nand2_1
XFILLER_81_582 VGND VGND VPWR VPWR sky130_fd_sc_hd__decap_6
X_10640_ _03448_ _03480_ VGND VGND VPWR VPWR _03482_ sky130_fd_sc_hd__xnor2_1
XTAP_TAPCELL_ROW_24_633 VGND VPWR sky130_fd_sc_hd__tapvpwrvgnd_1
XTAP_TAPCELL_ROW_136_2208 VGND VPWR sky130_fd_sc_hd__tapvpwrvgnd_1
XTAP_TAPCELL_ROW_62_1163 VGND VPWR sky130_fd_sc_hd__tapvpwrvgnd_1
XTAP_TAPCELL_ROW_136_2219 VGND VPWR sky130_fd_sc_hd__tapvpwrvgnd_1
X_10571_ net434 net149 net564 net442 VGND VGND VPWR VPWR _03406_ sky130_fd_sc_hd__a22o_1
X_13290_ _04663_ _04852_ VGND VGND VPWR VPWR _00025_ sky130_fd_sc_hd__xnor2_1
X_12310_ _05299_ _05301_ VGND VGND VPWR VPWR _05302_ sky130_fd_sc_hd__or2_1
XTAP_TAPCELL_ROW_118_1952 VGND VPWR sky130_fd_sc_hd__tapvpwrvgnd_1
XTAP_TAPCELL_ROW_118_1941 VGND VPWR sky130_fd_sc_hd__tapvpwrvgnd_1
X_12241_ net405 net601 VGND VGND VPWR VPWR _05226_ sky130_fd_sc_hd__nand2_2
XFILLER_135_573 VPWR VGND VPWR VGND sky130_ef_sc_hd__decap_12
XFILLER_123_702 VGND VGND VPWR VPWR sky130_fd_sc_hd__decap_3
X_12172_ net541 net302 _05149_ VGND VGND VPWR VPWR _05150_ sky130_fd_sc_hd__and3_1
XFILLER_122_256 VGND VGND VPWR VPWR sky130_fd_sc_hd__decap_6
X_11123_ _04007_ _04008_ VGND VGND VPWR VPWR _04010_ sky130_fd_sc_hd__xor2_2
XFILLER_1_553 VGND VGND VPWR VPWR sky130_fd_sc_hd__decap_6
XFILLER_3_27 VPWR VGND VPWR VGND sky130_ef_sc_hd__decap_12
XFILLER_49_513 VGND VGND VPWR VPWR sky130_fd_sc_hd__fill_1
X_11054_ _03927_ _03933_ VGND VGND VPWR VPWR _03934_ sky130_fd_sc_hd__xnor2_1
XFILLER_67_63 VGND VGND VPWR VPWR sky130_fd_sc_hd__fill_1
X_10005_ net513 net353 net350 net694 VGND VGND VPWR VPWR _02789_ sky130_fd_sc_hd__a22o_1
XFILLER_49_535 VGND VGND VPWR VPWR sky130_fd_sc_hd__fill_2
XFILLER_1_597 VPWR VGND VPWR VGND sky130_ef_sc_hd__decap_12
XFILLER_91_379 VGND VGND VPWR VPWR sky130_fd_sc_hd__decap_3
XFILLER_91_357 VGND VGND VPWR VPWR sky130_fd_sc_hd__decap_3
X_11956_ _04913_ _04914_ VGND VGND VPWR VPWR _04915_ sky130_fd_sc_hd__or2_1
XFILLER_83_95 VPWR VGND VPWR VGND sky130_ef_sc_hd__decap_12
XFILLER_60_722 VGND VGND VPWR VPWR sky130_fd_sc_hd__decap_8
XFILLER_32_402 VGND VGND VPWR VPWR sky130_fd_sc_hd__fill_2
X_10907_ _03770_ _03771_ VGND VGND VPWR VPWR _03774_ sky130_fd_sc_hd__and2b_1
X_11887_ _04834_ _04839_ _04831_ _04828_ VGND VGND VPWR VPWR _04841_ sky130_fd_sc_hd__a211oi_4
XFILLER_32_468 VGND VGND VPWR VPWR sky130_fd_sc_hd__fill_1
X_10838_ _03566_ _03602_ _03601_ VGND VGND VPWR VPWR _03698_ sky130_fd_sc_hd__a21o_1
XFILLER_9_631 VPWR VGND VPWR VGND sky130_ef_sc_hd__decap_12
X_10769_ _03440_ _03442_ _03621_ _03622_ VGND VGND VPWR VPWR _03623_ sky130_fd_sc_hd__a211oi_4
X_12508_ _05348_ _05350_ _05347_ VGND VGND VPWR VPWR _05518_ sky130_fd_sc_hd__a21o_1
X_12439_ net359 net334 net366 net364 VGND VGND VPWR VPWR _05443_ sky130_fd_sc_hd__and4_1
XFILLER_99_402 VGND VGND VPWR VPWR sky130_fd_sc_hd__fill_2
XTAP_TAPCELL_ROW_93_1602 VGND VPWR sky130_fd_sc_hd__tapvpwrvgnd_1
XFILLER_113_212 VGND VGND VPWR VPWR sky130_fd_sc_hd__fill_2
XFILLER_99_424 VPWR VGND VPWR VGND sky130_ef_sc_hd__decap_12
XFILLER_114_757 VPWR VGND VPWR VGND sky130_ef_sc_hd__decap_12
X_07980_ _06588_ _00630_ _00629_ VGND VGND VPWR VPWR _00717_ sky130_fd_sc_hd__o21ba_1
X_06931_ _04654_ _04730_ _04719_ VGND VGND VPWR VPWR _04774_ sky130_fd_sc_hd__a21oi_1
X_09650_ net415 _02405_ _02404_ VGND VGND VPWR VPWR _02406_ sky130_fd_sc_hd__a21bo_1
XFILLER_67_332 VGND VGND VPWR VPWR sky130_fd_sc_hd__decap_4
XFILLER_95_685 VGND VGND VPWR VPWR sky130_fd_sc_hd__decap_4
X_08601_ _01324_ _01328_ _01329_ VGND VGND VPWR VPWR _01330_ sky130_fd_sc_hd__and3_4
X_06862_ _03992_ _04014_ VGND VGND VPWR VPWR _04024_ sky130_fd_sc_hd__nor2_1
XFILLER_55_516 VGND VGND VPWR VPWR sky130_fd_sc_hd__fill_1
XTAP_TAPCELL_ROW_2_317 VGND VPWR sky130_fd_sc_hd__tapvpwrvgnd_1
XTAP_TAPCELL_ROW_2_328 VGND VPWR sky130_fd_sc_hd__tapvpwrvgnd_1
XFILLER_28_719 VGND VGND VPWR VPWR sky130_fd_sc_hd__fill_1
X_09581_ _02138_ _02331_ VGND VGND VPWR VPWR _02332_ sky130_fd_sc_hd__xnor2_1
X_06793_ net98 net506 VGND VGND VPWR VPWR _03270_ sky130_fd_sc_hd__nand2_2
X_08532_ _01258_ _01259_ _01257_ VGND VGND VPWR VPWR _01261_ sky130_fd_sc_hd__o21ai_1
X_08463_ _01151_ _01154_ VGND VGND VPWR VPWR _01192_ sky130_fd_sc_hd__or2_1
X_07414_ _00141_ _00153_ VGND VGND VPWR VPWR _00155_ sky130_fd_sc_hd__xnor2_1
XTAP_TAPCELL_ROW_102_1720 VGND VPWR sky130_fd_sc_hd__tapvpwrvgnd_1
XFILLER_50_221 VPWR VGND VPWR VGND sky130_ef_sc_hd__decap_12
XFILLER_23_424 VGND VGND VPWR VPWR sky130_fd_sc_hd__fill_1
XFILLER_35_295 VGND VGND VPWR VPWR sky130_fd_sc_hd__decap_6
X_08394_ net517 net824 net341 net339 VGND VGND VPWR VPWR _01124_ sky130_fd_sc_hd__and4_1
XFILLER_10_107 VGND VGND VPWR VPWR sky130_fd_sc_hd__fill_1
X_07345_ _06633_ _06634_ VGND VGND VPWR VPWR _06636_ sky130_fd_sc_hd__xnor2_1
XFILLER_50_287 VGND VGND VPWR VPWR sky130_fd_sc_hd__decap_8
X_07276_ net469 net136 _06435_ _06434_ VGND VGND VPWR VPWR _06567_ sky130_fd_sc_hd__a31o_1
XFILLER_136_337 VGND VGND VPWR VPWR sky130_fd_sc_hd__fill_2
X_09015_ _01592_ _01740_ VGND VGND VPWR VPWR _01741_ sky130_fd_sc_hd__nand2_1
XTAP_TAPCELL_ROW_131_2127 VGND VPWR sky130_fd_sc_hd__tapvpwrvgnd_1
XFILLER_117_540 VGND VGND VPWR VPWR sky130_fd_sc_hd__fill_1
XFILLER_104_201 VPWR VGND VPWR VGND sky130_ef_sc_hd__decap_12
XFILLER_88_29 VGND VGND VPWR VPWR sky130_fd_sc_hd__fill_2
XFILLER_105_768 VPWR VGND VPWR VGND sky130_ef_sc_hd__decap_12
XFILLER_132_587 VGND VGND VPWR VPWR sky130_fd_sc_hd__fill_1
Xfanout621 net623 VGND VGND VPWR VPWR net621 sky130_fd_sc_hd__buf_2
XTAP_TAPCELL_ROW_113_1882 VGND VPWR sky130_fd_sc_hd__tapvpwrvgnd_1
XTAP_TAPCELL_ROW_113_1871 VGND VPWR sky130_fd_sc_hd__tapvpwrvgnd_1
X_09917_ _02688_ _02696_ VGND VGND VPWR VPWR _02698_ sky130_fd_sc_hd__xnor2_1
Xfanout632 net124 VGND VGND VPWR VPWR net632 sky130_fd_sc_hd__clkbuf_2
Xfanout610 net132 VGND VGND VPWR VPWR net610 sky130_fd_sc_hd__clkbuf_2
Xfanout643 net646 VGND VGND VPWR VPWR net643 sky130_fd_sc_hd__clkbuf_2
XFILLER_86_641 VGND VGND VPWR VPWR sky130_fd_sc_hd__decap_3
Xfanout665 net666 VGND VGND VPWR VPWR net665 sky130_fd_sc_hd__buf_2
Xfanout654 net115 VGND VGND VPWR VPWR net654 sky130_fd_sc_hd__clkbuf_4
Xfanout676 net107 VGND VGND VPWR VPWR net676 sky130_fd_sc_hd__clkbuf_4
Xfanout687 net689 VGND VGND VPWR VPWR net687 sky130_fd_sc_hd__buf_2
X_09848_ _02619_ _02620_ VGND VGND VPWR VPWR _02623_ sky130_fd_sc_hd__xnor2_1
XFILLER_86_663 VPWR VGND VPWR VGND sky130_ef_sc_hd__decap_12
XFILLER_58_365 VPWR VGND VPWR VGND sky130_ef_sc_hd__decap_12
XFILLER_58_343 VGND VGND VPWR VPWR sky130_fd_sc_hd__decap_6
Xfanout698 net700 VGND VGND VPWR VPWR net698 sky130_fd_sc_hd__buf_2
XTAP_TAPCELL_ROW_29_703 VGND VPWR sky130_fd_sc_hd__tapvpwrvgnd_1
X_09779_ net250 net624 _02546_ VGND VGND VPWR VPWR _02547_ sky130_fd_sc_hd__and3_1
XFILLER_85_184 VGND VGND VPWR VPWR sky130_fd_sc_hd__fill_2
XFILLER_73_357 VPWR VGND VPWR VGND sky130_ef_sc_hd__decap_12
XFILLER_61_508 VGND VGND VPWR VPWR sky130_fd_sc_hd__fill_1
X_11810_ _04751_ _04755_ VGND VGND VPWR VPWR _04756_ sky130_fd_sc_hd__and2_1
X_12790_ net567 net293 _05825_ VGND VGND VPWR VPWR _05826_ sky130_fd_sc_hd__a21oi_1
XFILLER_27_741 VPWR VGND VPWR VGND sky130_ef_sc_hd__decap_12
X_11741_ _04677_ _04678_ _04679_ VGND VGND VPWR VPWR _04680_ sky130_fd_sc_hd__a21oi_1
XFILLER_26_251 VGND VGND VPWR VPWR sky130_fd_sc_hd__fill_1
XFILLER_26_273 VPWR VGND VPWR VGND sky130_ef_sc_hd__decap_12
XFILLER_27_785 VPWR VGND VPWR VGND sky130_ef_sc_hd__decap_12
XFILLER_81_390 VGND VGND VPWR VPWR sky130_fd_sc_hd__fill_2
XFILLER_53_54 VGND VGND VPWR VPWR sky130_fd_sc_hd__fill_2
XFILLER_14_446 VGND VGND VPWR VPWR sky130_fd_sc_hd__decap_8
X_11672_ net691 net302 net299 net269 VGND VGND VPWR VPWR _04606_ sky130_fd_sc_hd__a22oi_1
XFILLER_41_265 VGND VGND VPWR VPWR sky130_fd_sc_hd__fill_2
XFILLER_128_805 VGND VGND VPWR VPWR sky130_fd_sc_hd__decap_6
X_13411_ clknet_3_6__leaf_clk _00063_ _00121_ VGND VGND VPWR VPWR net225 sky130_fd_sc_hd__dfrtp_1
X_10623_ _03461_ _03462_ VGND VGND VPWR VPWR _03463_ sky130_fd_sc_hd__nor2_1
X_13342_ net398 VGND VGND VPWR VPWR _00116_ sky130_fd_sc_hd__inv_2
X_10554_ net482 net653 _03101_ VGND VGND VPWR VPWR _03387_ sky130_fd_sc_hd__and3_1
XFILLER_6_601 VPWR VGND VPWR VGND sky130_ef_sc_hd__decap_12
XFILLER_6_645 VPWR VGND VPWR VGND sky130_ef_sc_hd__decap_12
XFILLER_5_111 VGND VGND VPWR VPWR sky130_fd_sc_hd__fill_1
X_10485_ _03309_ _03310_ _03157_ net238 VGND VGND VPWR VPWR _03312_ sky130_fd_sc_hd__a211o_1
X_13273_ _06346_ _06351_ VGND VGND VPWR VPWR _06352_ sky130_fd_sc_hd__xnor2_1
XTAP_TAPCELL_ROW_75_1343 VGND VPWR sky130_fd_sc_hd__tapvpwrvgnd_1
X_12224_ net454 net584 _05204_ _05205_ VGND VGND VPWR VPWR _05207_ sky130_fd_sc_hd__nand4_1
XFILLER_111_705 VGND VGND VPWR VPWR sky130_fd_sc_hd__decap_6
X_12155_ _04985_ _05021_ _05023_ VGND VGND VPWR VPWR _05131_ sky130_fd_sc_hd__a21oi_1
XFILLER_96_416 VGND VGND VPWR VPWR sky130_fd_sc_hd__decap_4
X_11106_ _03971_ _03990_ VGND VGND VPWR VPWR _03991_ sky130_fd_sc_hd__xor2_2
XFILLER_96_449 VGND VGND VPWR VPWR sky130_fd_sc_hd__fill_2
XFILLER_77_641 VGND VGND VPWR VPWR sky130_fd_sc_hd__decap_4
XFILLER_49_321 VGND VGND VPWR VPWR sky130_fd_sc_hd__decap_3
X_12086_ net462 net457 net586 net583 VGND VGND VPWR VPWR _05057_ sky130_fd_sc_hd__and4_1
X_11037_ net652 net650 net475 VGND VGND VPWR VPWR _03916_ sky130_fd_sc_hd__o21ai_2
XFILLER_77_685 VPWR VGND VPWR VGND sky130_ef_sc_hd__decap_12
XFILLER_76_195 VGND VGND VPWR VPWR sky130_fd_sc_hd__fill_1
X_12988_ net567 net284 _02273_ net592 VGND VGND VPWR VPWR _06043_ sky130_fd_sc_hd__o2bb2a_1
XTAP_TAPCELL_ROW_86_1494 VGND VPWR sky130_fd_sc_hd__tapvpwrvgnd_1
X_11939_ _04892_ _04893_ _04895_ VGND VGND VPWR VPWR _04897_ sky130_fd_sc_hd__a21o_1
XFILLER_45_593 VGND VGND VPWR VPWR sky130_fd_sc_hd__decap_6
XFILLER_32_232 VPWR VGND VPWR VGND sky130_ef_sc_hd__decap_12
XFILLER_32_265 VGND VGND VPWR VPWR sky130_fd_sc_hd__fill_1
XFILLER_33_766 VGND VGND VPWR VPWR sky130_fd_sc_hd__fill_1
X_07130_ _05648_ _06419_ _06420_ VGND VGND VPWR VPWR _06422_ sky130_fd_sc_hd__and3_1
XFILLER_13_490 VGND VGND VPWR VPWR sky130_fd_sc_hd__decap_6
XFILLER_9_472 VGND VGND VPWR VPWR sky130_fd_sc_hd__decap_3
XFILLER_118_359 VGND VGND VPWR VPWR sky130_fd_sc_hd__fill_2
X_07061_ _05352_ _05363_ _06172_ _06183_ VGND VGND VPWR VPWR _06194_ sky130_fd_sc_hd__nor4_4
Xoutput213 net213 VGND VGND VPWR VPWR out3[12] sky130_fd_sc_hd__buf_2
Xoutput224 net224 VGND VGND VPWR VPWR out3[8] sky130_fd_sc_hd__buf_2
XFILLER_114_510 VGND VGND VPWR VPWR sky130_fd_sc_hd__decap_4
Xoutput202 net202 VGND VGND VPWR VPWR out2[2] sky130_fd_sc_hd__buf_2
XFILLER_99_254 VGND VGND VPWR VPWR sky130_fd_sc_hd__fill_1
XFILLER_114_587 VGND VGND VPWR VPWR sky130_fd_sc_hd__fill_1
X_07963_ _00435_ _00700_ VGND VGND VPWR VPWR _00701_ sky130_fd_sc_hd__xnor2_2
XFILLER_101_215 VGND VGND VPWR VPWR sky130_fd_sc_hd__fill_1
XFILLER_87_449 VGND VGND VPWR VPWR sky130_fd_sc_hd__fill_1
XFILLER_68_641 VGND VGND VPWR VPWR sky130_fd_sc_hd__decap_3
X_09702_ _02461_ _02462_ VGND VGND VPWR VPWR _02463_ sky130_fd_sc_hd__nand2_1
XFILLER_114_27 VGND VGND VPWR VPWR sky130_fd_sc_hd__fill_1
X_06914_ _04472_ _04494_ _04483_ VGND VGND VPWR VPWR _04589_ sky130_fd_sc_hd__a21o_1
X_07894_ _00626_ _00631_ VGND VGND VPWR VPWR _00632_ sky130_fd_sc_hd__and2b_1
XFILLER_28_505 VPWR VGND VPWR VGND sky130_ef_sc_hd__decap_12
XFILLER_110_793 VPWR VGND VPWR VGND sky130_ef_sc_hd__decap_12
X_06845_ _03270_ _03817_ _03806_ VGND VGND VPWR VPWR _03839_ sky130_fd_sc_hd__o21ai_2
X_09633_ _02386_ _02387_ VGND VGND VPWR VPWR _02388_ sky130_fd_sc_hd__nor2_1
XFILLER_28_549 VGND VGND VPWR VPWR sky130_fd_sc_hd__fill_1
X_09564_ _02311_ _02312_ VGND VGND VPWR VPWR _02313_ sky130_fd_sc_hd__xnor2_2
XFILLER_82_121 VPWR VGND VPWR VGND sky130_ef_sc_hd__decap_12
XFILLER_55_368 VGND VGND VPWR VPWR sky130_fd_sc_hd__fill_1
XFILLER_130_15 VPWR VGND VPWR VGND sky130_ef_sc_hd__decap_12
X_06776_ net267 net318 _03053_ _03063_ VGND VGND VPWR VPWR _03085_ sky130_fd_sc_hd__a22oi_1
XFILLER_82_187 VGND VGND VPWR VPWR sky130_fd_sc_hd__decap_8
XFILLER_82_176 VGND VGND VPWR VPWR sky130_fd_sc_hd__decap_4
XFILLER_82_154 VGND VGND VPWR VPWR sky130_fd_sc_hd__fill_1
X_08515_ net474 net551 _01243_ VGND VGND VPWR VPWR _01244_ sky130_fd_sc_hd__and3_1
XFILLER_43_519 VGND VGND VPWR VPWR sky130_fd_sc_hd__decap_8
X_09495_ _02236_ _02237_ VGND VGND VPWR VPWR _02238_ sky130_fd_sc_hd__nor2_1
XFILLER_24_755 VGND VGND VPWR VPWR sky130_fd_sc_hd__fill_1
X_08446_ _01146_ _01174_ VGND VGND VPWR VPWR _01175_ sky130_fd_sc_hd__nor2_1
XFILLER_11_405 VGND VGND VPWR VPWR sky130_fd_sc_hd__fill_2
XFILLER_23_254 VGND VGND VPWR VPWR sky130_fd_sc_hd__decap_6
X_08377_ net530 net633 VGND VGND VPWR VPWR _01108_ sky130_fd_sc_hd__and2_1
XFILLER_11_438 VGND VGND VPWR VPWR sky130_fd_sc_hd__decap_8
XTAP_TAPCELL_ROW_34_772 VGND VPWR sky130_fd_sc_hd__tapvpwrvgnd_1
X_07328_ net389 net310 _06617_ _06618_ VGND VGND VPWR VPWR _06619_ sky130_fd_sc_hd__o2bb2a_1
XFILLER_11_449 VGND VGND VPWR VPWR sky130_fd_sc_hd__decap_4
XFILLER_23_57 VPWR VGND VPWR VGND sky130_ef_sc_hd__decap_12
XFILLER_109_348 VGND VGND VPWR VPWR sky130_fd_sc_hd__fill_2
XTAP_TAPCELL_ROW_115_1911 VGND VPWR sky130_fd_sc_hd__tapvpwrvgnd_1
XTAP_TAPCELL_ROW_115_1900 VGND VPWR sky130_fd_sc_hd__tapvpwrvgnd_1
X_07259_ _06505_ _06548_ VGND VGND VPWR VPWR _06550_ sky130_fd_sc_hd__xnor2_1
X_10270_ _02927_ _03077_ VGND VGND VPWR VPWR _03078_ sky130_fd_sc_hd__xor2_1
XFILLER_3_615 VGND VGND VPWR VPWR sky130_fd_sc_hd__fill_1
XTAP_TAPCELL_ROW_57_1095 VGND VPWR sky130_fd_sc_hd__tapvpwrvgnd_1
Xfanout440 net441 VGND VGND VPWR VPWR net440 sky130_fd_sc_hd__buf_2
XFILLER_120_568 VGND VGND VPWR VPWR sky130_fd_sc_hd__decap_8
Xfanout484 net485 VGND VGND VPWR VPWR net484 sky130_fd_sc_hd__buf_4
Xfanout473 net474 VGND VGND VPWR VPWR net473 sky130_fd_sc_hd__buf_2
XTAP_TAPCELL_ROW_70_1273 VGND VPWR sky130_fd_sc_hd__tapvpwrvgnd_1
Xfanout451 net27 VGND VGND VPWR VPWR net451 sky130_fd_sc_hd__buf_1
XFILLER_48_76 VGND VGND VPWR VPWR sky130_fd_sc_hd__fill_1
Xfanout462 net466 VGND VGND VPWR VPWR net462 sky130_fd_sc_hd__buf_2
XFILLER_19_505 VGND VGND VPWR VPWR sky130_fd_sc_hd__fill_1
XFILLER_59_696 VPWR VGND VPWR VGND sky130_ef_sc_hd__decap_12
Xfanout495 net498 VGND VGND VPWR VPWR net495 sky130_fd_sc_hd__buf_2
X_12911_ _05810_ _05811_ _05816_ VGND VGND VPWR VPWR _05959_ sky130_fd_sc_hd__o21a_1
XFILLER_73_165 VGND VGND VPWR VPWR sky130_fd_sc_hd__decap_3
XFILLER_61_305 VPWR VGND VPWR VGND sky130_ef_sc_hd__decap_12
XFILLER_46_379 VGND VGND VPWR VPWR sky130_fd_sc_hd__fill_1
X_12842_ _05873_ _05882_ VGND VGND VPWR VPWR _05883_ sky130_fd_sc_hd__xnor2_1
XFILLER_73_198 VGND VGND VPWR VPWR sky130_fd_sc_hd__decap_8
X_12773_ _05806_ _05807_ VGND VGND VPWR VPWR _05808_ sky130_fd_sc_hd__nor2_1
X_11724_ _04603_ _04609_ _04660_ VGND VGND VPWR VPWR _04662_ sky130_fd_sc_hd__and3_1
XFILLER_9_15 VPWR VGND VPWR VGND sky130_ef_sc_hd__decap_12
XFILLER_14_265 VPWR VGND VPWR VGND sky130_ef_sc_hd__decap_12
XFILLER_15_777 VGND VGND VPWR VPWR sky130_fd_sc_hd__decap_6
X_11655_ net462 net600 _04583_ _04585_ VGND VGND VPWR VPWR _04587_ sky130_fd_sc_hd__a22oi_1
XFILLER_30_725 VPWR VGND VPWR VGND sky130_ef_sc_hd__decap_12
XFILLER_80_85 VPWR VGND VPWR VGND sky130_ef_sc_hd__decap_12
X_11586_ _04404_ _04514_ VGND VGND VPWR VPWR _04515_ sky130_fd_sc_hd__xnor2_1
XTAP_TAPCELL_ROW_12_466 VGND VPWR sky130_fd_sc_hd__tapvpwrvgnd_1
X_10606_ _03442_ _03443_ VGND VGND VPWR VPWR _03444_ sky130_fd_sc_hd__nand2_1
XFILLER_128_657 VPWR VGND VPWR VGND sky130_ef_sc_hd__decap_12
X_13325_ net392 VGND VGND VPWR VPWR _00099_ sky130_fd_sc_hd__inv_2
X_10537_ _03366_ _03367_ VGND VGND VPWR VPWR _03369_ sky130_fd_sc_hd__nand2b_1
XFILLER_10_482 VGND VGND VPWR VPWR sky130_fd_sc_hd__decap_8
X_10468_ _03290_ _03291_ _03293_ VGND VGND VPWR VPWR _03294_ sky130_fd_sc_hd__or3_1
X_13256_ _06324_ _06328_ VGND VGND VPWR VPWR _06333_ sky130_fd_sc_hd__xor2_1
X_12207_ _05186_ _05187_ VGND VGND VPWR VPWR _05189_ sky130_fd_sc_hd__and2b_1
XFILLER_111_502 VGND VGND VPWR VPWR sky130_fd_sc_hd__fill_2
XFILLER_97_714 VPWR VGND VPWR VGND sky130_ef_sc_hd__decap_12
X_10399_ _03218_ _03215_ VGND VGND VPWR VPWR _03219_ sky130_fd_sc_hd__and2b_1
X_13187_ _06145_ _06147_ _06257_ VGND VGND VPWR VPWR _06260_ sky130_fd_sc_hd__and3_1
XFILLER_96_224 VPWR VGND VPWR VGND sky130_ef_sc_hd__decap_12
X_12138_ _05111_ _05110_ _05054_ VGND VGND VPWR VPWR _05114_ sky130_fd_sc_hd__a21o_1
XFILLER_2_681 VPWR VGND VPWR VGND sky130_ef_sc_hd__decap_12
XFILLER_84_419 VGND VGND VPWR VPWR sky130_fd_sc_hd__fill_1
X_12069_ _05037_ _05038_ VGND VGND VPWR VPWR _05039_ sky130_fd_sc_hd__xnor2_1
XTAP_TAPCELL_ROW_88_1523 VGND VPWR sky130_fd_sc_hd__tapvpwrvgnd_1
XFILLER_64_187 VGND VGND VPWR VPWR sky130_fd_sc_hd__decap_8
XFILLER_18_582 VGND VGND VPWR VPWR sky130_fd_sc_hd__decap_6
X_08300_ _00826_ _00939_ _00829_ _01034_ _00937_ VGND VGND VPWR VPWR _01035_ sky130_fd_sc_hd__o311a_4
X_09280_ net447 net537 _02002_ _02003_ VGND VGND VPWR VPWR _02004_ sky130_fd_sc_hd__o2bb2a_1
X_08231_ net105 _02175_ _00865_ VGND VGND VPWR VPWR _00966_ sky130_fd_sc_hd__a21oi_1
XFILLER_20_213 VGND VGND VPWR VPWR sky130_fd_sc_hd__decap_4
XTAP_TAPCELL_ROW_31_731 VGND VPWR sky130_fd_sc_hd__tapvpwrvgnd_1
X_08162_ _00896_ _00897_ VGND VGND VPWR VPWR _00898_ sky130_fd_sc_hd__and2_1
XFILLER_20_279 VGND VGND VPWR VPWR sky130_fd_sc_hd__decap_6
X_08093_ _00829_ _00826_ VGND VGND VPWR VPWR _00041_ sky130_fd_sc_hd__xor2_1
XFILLER_119_668 VGND VGND VPWR VPWR sky130_fd_sc_hd__decap_4
X_07113_ net532 net680 _06404_ VGND VGND VPWR VPWR _06405_ sky130_fd_sc_hd__and3_1
XTAP_TAPCELL_ROW_99_1685 VGND VPWR sky130_fd_sc_hd__tapvpwrvgnd_1
XTAP_TAPCELL_ROW_99_1674 VGND VPWR sky130_fd_sc_hd__tapvpwrvgnd_1
XFILLER_106_307 VGND VGND VPWR VPWR sky130_fd_sc_hd__fill_1
X_07044_ _05975_ _05997_ _05986_ VGND VGND VPWR VPWR _06008_ sky130_fd_sc_hd__and3_4
XFILLER_133_137 VPWR VGND VPWR VGND sky130_ef_sc_hd__decap_12
XFILLER_125_15 VPWR VGND VPWR VGND sky130_ef_sc_hd__decap_12
XFILLER_0_629 VPWR VGND VPWR VGND sky130_ef_sc_hd__decap_12
XTAP_TAPCELL_ROW_110_1841 VGND VPWR sky130_fd_sc_hd__tapvpwrvgnd_1
XTAP_TAPCELL_ROW_110_1830 VGND VPWR sky130_fd_sc_hd__tapvpwrvgnd_1
X_08995_ _01705_ _01720_ VGND VGND VPWR VPWR _01721_ sky130_fd_sc_hd__nor2_1
XFILLER_102_557 VGND VGND VPWR VPWR sky130_fd_sc_hd__decap_4
X_07946_ _00672_ _00683_ VGND VGND VPWR VPWR _00684_ sky130_fd_sc_hd__xor2_1
XFILLER_56_611 VGND VGND VPWR VPWR sky130_fd_sc_hd__fill_2
XTAP_TAPCELL_ROW_126_2059 VGND VPWR sky130_fd_sc_hd__tapvpwrvgnd_1
X_07877_ _00579_ _00613_ VGND VGND VPWR VPWR _00615_ sky130_fd_sc_hd__xnor2_1
XTAP_TAPCELL_ROW_39_842 VGND VPWR sky130_fd_sc_hd__tapvpwrvgnd_1
X_09616_ _02368_ _02369_ VGND VGND VPWR VPWR _02370_ sky130_fd_sc_hd__xor2_1
X_06828_ _03335_ _03642_ VGND VGND VPWR VPWR _03653_ sky130_fd_sc_hd__nand2_1
XFILLER_56_699 VGND VGND VPWR VPWR sky130_fd_sc_hd__fill_1
XFILLER_55_165 VGND VGND VPWR VPWR sky130_fd_sc_hd__decap_3
X_06759_ _02877_ _02888_ VGND VGND VPWR VPWR _02899_ sky130_fd_sc_hd__nor2_1
X_09547_ _01676_ _02294_ VGND VGND VPWR VPWR _02296_ sky130_fd_sc_hd__nand2_1
XFILLER_34_23 VGND VGND VPWR VPWR sky130_fd_sc_hd__decap_4
X_09478_ _01965_ _02062_ _02061_ VGND VGND VPWR VPWR _02221_ sky130_fd_sc_hd__a21bo_1
XFILLER_12_725 VPWR VGND VPWR VGND sky130_ef_sc_hd__decap_12
XTAP_TAPCELL_ROW_121_1992 VGND VPWR sky130_fd_sc_hd__tapvpwrvgnd_1
X_08429_ _01150_ _01157_ VGND VGND VPWR VPWR _01159_ sky130_fd_sc_hd__xnor2_1
XFILLER_51_393 VGND VGND VPWR VPWR sky130_fd_sc_hd__fill_2
XFILLER_11_257 VGND VGND VPWR VPWR sky130_fd_sc_hd__decap_8
XFILLER_12_769 VPWR VGND VPWR VGND sky130_ef_sc_hd__decap_12
XFILLER_126_3 VPWR VGND VPWR VGND sky130_ef_sc_hd__decap_12
Xclkload0 clknet_3_0__leaf_clk VGND VGND VPWR VPWR clkload0/Y sky130_fd_sc_hd__clkinv_2
XFILLER_7_217 VGND VGND VPWR VPWR sky130_fd_sc_hd__decap_6
X_11440_ _04332_ _04355_ VGND VGND VPWR VPWR _04356_ sky130_fd_sc_hd__and2_1
XFILLER_109_145 VGND VGND VPWR VPWR sky130_fd_sc_hd__fill_1
XTAP_TAPCELL_ROW_59_1124 VGND VPWR sky130_fd_sc_hd__tapvpwrvgnd_1
X_11371_ _04279_ _04280_ VGND VGND VPWR VPWR _04281_ sky130_fd_sc_hd__or2_1
X_10322_ net425 net349 net347 net512 VGND VGND VPWR VPWR _03135_ sky130_fd_sc_hd__a22oi_1
X_13110_ _06174_ _06175_ VGND VGND VPWR VPWR _06176_ sky130_fd_sc_hd__nor2_1
XFILLER_124_137 VGND VGND VPWR VPWR sky130_fd_sc_hd__decap_3
X_13041_ _05748_ _05867_ VGND VGND VPWR VPWR _06100_ sky130_fd_sc_hd__or2_1
XFILLER_133_671 VGND VGND VPWR VPWR sky130_fd_sc_hd__fill_1
XTAP_TAPCELL_ROW_72_1302 VGND VPWR sky130_fd_sc_hd__tapvpwrvgnd_1
X_10253_ net686 net664 net278 net276 VGND VGND VPWR VPWR _03059_ sky130_fd_sc_hd__and4_1
XFILLER_59_42 VGND VGND VPWR VPWR sky130_fd_sc_hd__decap_4
X_10184_ _02970_ _02982_ _02983_ VGND VGND VPWR VPWR _02984_ sky130_fd_sc_hd__nand3_1
XFILLER_120_365 VGND VGND VPWR VPWR sky130_fd_sc_hd__decap_8
XFILLER_120_376 VPWR VGND VPWR VGND sky130_ef_sc_hd__decap_12
Xfanout270 net271 VGND VGND VPWR VPWR net270 sky130_fd_sc_hd__buf_2
XFILLER_75_30 VGND VGND VPWR VPWR sky130_fd_sc_hd__fill_1
Xfanout292 net8 VGND VGND VPWR VPWR net292 sky130_fd_sc_hd__buf_2
Xfanout281 net83 VGND VGND VPWR VPWR net281 sky130_fd_sc_hd__clkbuf_2
XFILLER_115_92 VPWR VGND VPWR VGND sky130_ef_sc_hd__decap_12
XFILLER_75_63 VGND VGND VPWR VPWR sky130_fd_sc_hd__fill_2
XFILLER_34_305 VGND VGND VPWR VPWR sky130_fd_sc_hd__decap_3
XFILLER_61_135 VGND VGND VPWR VPWR sky130_fd_sc_hd__decap_6
X_12825_ _05748_ _05863_ VGND VGND VPWR VPWR _05864_ sky130_fd_sc_hd__nor2_1
XTAP_TAPCELL_ROW_17_536 VGND VPWR sky130_fd_sc_hd__tapvpwrvgnd_1
XFILLER_34_327 VGND VGND VPWR VPWR sky130_fd_sc_hd__fill_1
XTAP_TAPCELL_ROW_83_1453 VGND VPWR sky130_fd_sc_hd__tapvpwrvgnd_1
X_12756_ _05773_ _05788_ VGND VGND VPWR VPWR _05789_ sky130_fd_sc_hd__nor2_1
XFILLER_30_522 VGND VGND VPWR VPWR sky130_fd_sc_hd__decap_8
X_11707_ _04640_ _04641_ VGND VGND VPWR VPWR _04644_ sky130_fd_sc_hd__nand2_1
X_12687_ net507 net657 VGND VGND VPWR VPWR _05714_ sky130_fd_sc_hd__and2b_1
XFILLER_30_533 VGND VGND VPWR VPWR sky130_fd_sc_hd__decap_4
XFILLER_30_555 VPWR VGND VPWR VGND sky130_ef_sc_hd__decap_12
XFILLER_128_421 VPWR VGND VPWR VGND sky130_ef_sc_hd__decap_12
XFILLER_128_410 VGND VGND VPWR VPWR sky130_fd_sc_hd__decap_8
X_11638_ _04522_ _04571_ VGND VGND VPWR VPWR _04572_ sky130_fd_sc_hd__xnor2_1
XFILLER_116_605 VPWR VGND VPWR VGND sky130_ef_sc_hd__decap_12
XFILLER_115_104 VGND VGND VPWR VPWR sky130_fd_sc_hd__decap_8
X_13308_ net396 VGND VGND VPWR VPWR _00082_ sky130_fd_sc_hd__inv_2
X_11569_ _04354_ _04356_ _04496_ VGND VGND VPWR VPWR _04497_ sky130_fd_sc_hd__o21ba_1
XFILLER_97_511 VGND VGND VPWR VPWR sky130_fd_sc_hd__fill_1
X_13239_ _06313_ _06314_ VGND VGND VPWR VPWR _06316_ sky130_fd_sc_hd__xor2_1
XFILLER_124_693 VGND VGND VPWR VPWR sky130_fd_sc_hd__decap_6
XPHY_EDGE_ROW_71_Left_208 VGND VGND VPWR VPWR sky130_fd_sc_hd__decap_3
X_08780_ net250 _02186_ _01379_ VGND VGND VPWR VPWR _01507_ sky130_fd_sc_hd__or3b_4
X_07800_ net435 net602 VGND VGND VPWR VPWR _00539_ sky130_fd_sc_hd__nand2_1
XPHY_EDGE_ROW_127_Right_127 VGND VGND VPWR VPWR sky130_fd_sc_hd__decap_3
X_07731_ _00466_ _00467_ VGND VGND VPWR VPWR _00470_ sky130_fd_sc_hd__xor2_1
XFILLER_69_279 VGND VGND VPWR VPWR sky130_fd_sc_hd__fill_1
XFILLER_38_611 VGND VGND VPWR VPWR sky130_fd_sc_hd__fill_2
XFILLER_93_783 VGND VGND VPWR VPWR sky130_fd_sc_hd__fill_1
XFILLER_80_400 VGND VGND VPWR VPWR sky130_fd_sc_hd__decap_8
X_07662_ _00396_ _00401_ VGND VGND VPWR VPWR _00402_ sky130_fd_sc_hd__and2_1
XFILLER_65_474 VGND VGND VPWR VPWR sky130_fd_sc_hd__fill_2
XFILLER_65_463 VGND VGND VPWR VPWR sky130_fd_sc_hd__fill_1
XTAP_TAPCELL_ROW_36_801 VGND VPWR sky130_fd_sc_hd__tapvpwrvgnd_1
X_07593_ net684 net682 net476 VGND VGND VPWR VPWR _00333_ sky130_fd_sc_hd__and3_1
X_09401_ net631 net629 net480 VGND VGND VPWR VPWR _02136_ sky130_fd_sc_hd__o21ai_1
XFILLER_80_433 VGND VGND VPWR VPWR sky130_fd_sc_hd__decap_3
XFILLER_1_93 VPWR VGND VPWR VGND sky130_ef_sc_hd__decap_12
XFILLER_25_349 VGND VGND VPWR VPWR sky130_fd_sc_hd__decap_3
X_09332_ _01893_ _01895_ _02059_ _02060_ VGND VGND VPWR VPWR _02061_ sky130_fd_sc_hd__o211ai_2
XFILLER_80_477 VPWR VGND VPWR VGND sky130_ef_sc_hd__decap_12
XFILLER_80_455 VGND VGND VPWR VPWR sky130_fd_sc_hd__decap_8
XFILLER_53_669 VGND VGND VPWR VPWR sky130_fd_sc_hd__decap_3
XPHY_EDGE_ROW_80_Left_217 VGND VGND VPWR VPWR sky130_fd_sc_hd__decap_3
XFILLER_40_319 VPWR VGND VPWR VGND sky130_ef_sc_hd__decap_12
X_09263_ _01649_ _01986_ VGND VGND VPWR VPWR _01987_ sky130_fd_sc_hd__xnor2_1
X_09194_ _01754_ _01801_ _01800_ VGND VGND VPWR VPWR _01918_ sky130_fd_sc_hd__a21oi_1
X_08214_ _00941_ _00947_ VGND VGND VPWR VPWR _00949_ sky130_fd_sc_hd__xnor2_1
X_08145_ _00879_ _00880_ VGND VGND VPWR VPWR _00881_ sky130_fd_sc_hd__nor2_1
XFILLER_119_498 VGND VGND VPWR VPWR sky130_fd_sc_hd__decap_6
XFILLER_4_209 VPWR VGND VPWR VGND sky130_ef_sc_hd__decap_12
XFILLER_134_457 VPWR VGND VPWR VGND sky130_ef_sc_hd__decap_12
X_08076_ _00689_ _00690_ _00692_ VGND VGND VPWR VPWR _00813_ sky130_fd_sc_hd__o21a_1
XFILLER_88_500 VGND VGND VPWR VPWR sky130_fd_sc_hd__decap_3
X_07027_ _05801_ _05812_ VGND VGND VPWR VPWR _05822_ sky130_fd_sc_hd__or2_1
XFILLER_136_69 VPWR VGND VPWR VGND sky130_ef_sc_hd__decap_12
XFILLER_96_18 VGND VGND VPWR VPWR sky130_fd_sc_hd__decap_6
XTAP_TAPCELL_ROW_54_1054 VGND VPWR sky130_fd_sc_hd__tapvpwrvgnd_1
X_08978_ _01702_ _01703_ VGND VGND VPWR VPWR _01704_ sky130_fd_sc_hd__and2b_1
XFILLER_29_611 VGND VGND VPWR VPWR sky130_fd_sc_hd__decap_4
X_07929_ _00484_ _00666_ VGND VGND VPWR VPWR _00667_ sky130_fd_sc_hd__xnor2_1
XFILLER_71_400 VGND VGND VPWR VPWR sky130_fd_sc_hd__decap_8
X_10940_ _03635_ _03636_ _03808_ VGND VGND VPWR VPWR _03810_ sky130_fd_sc_hd__and3_1
XPHY_EDGE_ROW_119_Left_256 VGND VGND VPWR VPWR sky130_fd_sc_hd__decap_3
XFILLER_45_55 VGND VGND VPWR VPWR sky130_fd_sc_hd__fill_1
XFILLER_45_44 VGND VGND VPWR VPWR sky130_fd_sc_hd__fill_2
XFILLER_16_327 VGND VGND VPWR VPWR sky130_fd_sc_hd__fill_1
XFILLER_45_77 VGND VGND VPWR VPWR sky130_fd_sc_hd__fill_2
X_12610_ _05622_ _05628_ VGND VGND VPWR VPWR _05630_ sky130_fd_sc_hd__xor2_1
XFILLER_31_308 VPWR VGND VPWR VGND sky130_ef_sc_hd__decap_12
X_10871_ _03732_ _03733_ VGND VGND VPWR VPWR _03734_ sky130_fd_sc_hd__nand2_1
XFILLER_12_500 VPWR VGND VPWR VGND sky130_ef_sc_hd__decap_12
XFILLER_12_544 VGND VGND VPWR VPWR sky130_fd_sc_hd__decap_8
XFILLER_12_533 VGND VGND VPWR VPWR sky130_fd_sc_hd__decap_4
XFILLER_8_504 VPWR VGND VPWR VGND sky130_ef_sc_hd__decap_12
X_12541_ _05553_ VGND VGND VPWR VPWR _05554_ sky130_fd_sc_hd__inv_2
X_12472_ _05475_ _05477_ _05310_ VGND VGND VPWR VPWR _05479_ sky130_fd_sc_hd__a21oi_2
XFILLER_12_566 VGND VGND VPWR VPWR sky130_fd_sc_hd__fill_1
X_11423_ net250 net635 _04335_ VGND VGND VPWR VPWR _04337_ sky130_fd_sc_hd__a21oi_1
XANTENNA_9 _02109_ VGND VGND VPWR VPWR sky130_fd_sc_hd__diode_2
XFILLER_6_27 VGND VGND VPWR VPWR sky130_fd_sc_hd__fill_1
XPHY_EDGE_ROW_128_Left_265 VGND VGND VPWR VPWR sky130_fd_sc_hd__decap_3
XFILLER_125_435 VPWR VGND VPWR VGND sky130_ef_sc_hd__decap_12
X_11354_ _04260_ _04261_ VGND VGND VPWR VPWR _04262_ sky130_fd_sc_hd__nand2_1
X_10305_ net451 net574 VGND VGND VPWR VPWR _03116_ sky130_fd_sc_hd__nand2_1
X_11285_ _04185_ _04184_ VGND VGND VPWR VPWR _04186_ sky130_fd_sc_hd__nand2b_1
XFILLER_112_129 VGND VGND VPWR VPWR sky130_fd_sc_hd__fill_1
X_10236_ _03030_ _03036_ _03037_ VGND VGND VPWR VPWR _03041_ sky130_fd_sc_hd__a21oi_4
X_13024_ _06080_ _06081_ VGND VGND VPWR VPWR _06082_ sky130_fd_sc_hd__or2_1
XFILLER_105_192 VPWR VGND VPWR VGND sky130_ef_sc_hd__decap_12
XFILLER_105_181 VGND VGND VPWR VPWR sky130_fd_sc_hd__decap_4
XFILLER_79_599 VGND VGND VPWR VPWR sky130_fd_sc_hd__decap_8
X_10167_ _02962_ _02964_ VGND VGND VPWR VPWR _02966_ sky130_fd_sc_hd__or2_1
XFILLER_120_195 VGND VGND VPWR VPWR sky130_fd_sc_hd__fill_1
X_10098_ _02855_ _02858_ _02854_ VGND VGND VPWR VPWR _02890_ sky130_fd_sc_hd__o21ba_1
XFILLER_75_783 VGND VGND VPWR VPWR sky130_fd_sc_hd__fill_1
XFILLER_62_433 VPWR VGND VPWR VGND sky130_ef_sc_hd__decap_12
XFILLER_35_625 VPWR VGND VPWR VGND sky130_ef_sc_hd__decap_12
XFILLER_23_809 VGND VGND VPWR VPWR sky130_fd_sc_hd__fill_2
XFILLER_35_669 VGND VGND VPWR VPWR sky130_fd_sc_hd__decap_3
XFILLER_62_477 VGND VGND VPWR VPWR sky130_fd_sc_hd__decap_4
XFILLER_50_617 VPWR VGND VPWR VGND sky130_ef_sc_hd__decap_12
X_12808_ _05711_ _05714_ _05710_ VGND VGND VPWR VPWR _05846_ sky130_fd_sc_hd__a21oi_1
XFILLER_34_168 VPWR VGND VPWR VGND sky130_ef_sc_hd__decap_12
XFILLER_15_382 VGND VGND VPWR VPWR sky130_fd_sc_hd__decap_4
X_12739_ _05767_ _05769_ VGND VGND VPWR VPWR _05771_ sky130_fd_sc_hd__xnor2_1
XFILLER_30_363 VGND VGND VPWR VPWR sky130_fd_sc_hd__fill_1
XTAP_TAPCELL_ROW_41_870 VGND VPWR sky130_fd_sc_hd__tapvpwrvgnd_1
XFILLER_129_741 VPWR VGND VPWR VGND sky130_ef_sc_hd__decap_12
XFILLER_30_385 VPWR VGND VPWR VGND sky130_ef_sc_hd__decap_12
XFILLER_129_785 VPWR VGND VPWR VGND sky130_ef_sc_hd__decap_12
XFILLER_128_273 VPWR VGND VPWR VGND sky130_ef_sc_hd__decap_12
XTAP_TAPCELL_ROW_96_1644 VGND VPWR sky130_fd_sc_hd__tapvpwrvgnd_1
XTAP_TAPCELL_ROW_96_1633 VGND VPWR sky130_fd_sc_hd__tapvpwrvgnd_1
XFILLER_128_295 VPWR VGND VPWR VGND sky130_ef_sc_hd__decap_12
Xmax_cap234 _04959_ VGND VGND VPWR VPWR net234 sky130_fd_sc_hd__buf_6
XFILLER_131_405 VPWR VGND VPWR VGND sky130_ef_sc_hd__decap_12
X_09950_ _02711_ _02717_ _02710_ VGND VGND VPWR VPWR _02732_ sky130_fd_sc_hd__a21o_1
XFILLER_116_457 VPWR VGND VPWR VGND sky130_ef_sc_hd__decap_12
Xmax_cap245 _04577_ VGND VGND VPWR VPWR net245 sky130_fd_sc_hd__buf_1
XFILLER_131_449 VPWR VGND VPWR VGND sky130_ef_sc_hd__decap_12
XFILLER_131_438 VGND VGND VPWR VPWR sky130_fd_sc_hd__decap_8
X_08901_ _01618_ _01625_ VGND VGND VPWR VPWR _01627_ sky130_fd_sc_hd__or2_1
XFILLER_112_663 VGND VGND VPWR VPWR sky130_fd_sc_hd__fill_1
XFILLER_106_39 VPWR VGND VPWR VGND sky130_ef_sc_hd__decap_12
XFILLER_100_803 VGND VGND VPWR VPWR sky130_fd_sc_hd__decap_4
X_09881_ _02654_ _02657_ VGND VGND VPWR VPWR _02658_ sky130_fd_sc_hd__and2_1
X_08832_ _01550_ _01557_ _01558_ VGND VGND VPWR VPWR _01559_ sky130_fd_sc_hd__nand3_1
X_08763_ _01377_ _01384_ _01383_ VGND VGND VPWR VPWR _01490_ sky130_fd_sc_hd__a21oi_1
XFILLER_85_569 VGND VGND VPWR VPWR sky130_fd_sc_hd__fill_1
XFILLER_57_238 VPWR VGND VPWR VGND sky130_ef_sc_hd__decap_12
X_07714_ _00452_ _00451_ VGND VGND VPWR VPWR _00453_ sky130_fd_sc_hd__and2b_1
XTAP_TAPCELL_ROW_123_2018 VGND VPWR sky130_fd_sc_hd__tapvpwrvgnd_1
XFILLER_122_27 VGND VGND VPWR VPWR sky130_fd_sc_hd__fill_1
XFILLER_38_441 VPWR VGND VPWR VGND sky130_ef_sc_hd__decap_12
X_08694_ _01419_ _01420_ _01412_ VGND VGND VPWR VPWR _01422_ sky130_fd_sc_hd__a21o_1
XFILLER_65_293 VGND VGND VPWR VPWR sky130_fd_sc_hd__fill_1
XTAP_TAPCELL_ROW_49_981 VGND VPWR sky130_fd_sc_hd__tapvpwrvgnd_1
XFILLER_26_625 VPWR VGND VPWR VGND sky130_ef_sc_hd__decap_12
X_07645_ _00229_ _00230_ _00383_ VGND VGND VPWR VPWR _00385_ sky130_fd_sc_hd__o21bai_1
XTAP_TAPCELL_ROW_0_278 VGND VPWR sky130_fd_sc_hd__tapvpwrvgnd_1
XFILLER_26_669 VPWR VGND VPWR VGND sky130_ef_sc_hd__decap_12
X_07576_ _00305_ _00315_ VGND VGND VPWR VPWR _00316_ sky130_fd_sc_hd__xor2_1
XTAP_TAPCELL_ROW_105_1762 VGND VPWR sky130_fd_sc_hd__tapvpwrvgnd_1
XFILLER_80_285 VGND VGND VPWR VPWR sky130_fd_sc_hd__fill_1
XTAP_TAPCELL_ROW_0_289 VGND VPWR sky130_fd_sc_hd__tapvpwrvgnd_1
XFILLER_41_617 VGND VGND VPWR VPWR sky130_fd_sc_hd__decap_8
X_09315_ net849 net65 VGND VGND VPWR VPWR _02042_ sky130_fd_sc_hd__and2b_1
X_09246_ _01968_ _01969_ VGND VGND VPWR VPWR _01970_ sky130_fd_sc_hd__nand2b_1
XFILLER_21_374 VGND VGND VPWR VPWR sky130_fd_sc_hd__decap_3
XFILLER_31_35 VGND VGND VPWR VPWR sky130_fd_sc_hd__fill_1
X_09177_ _01897_ _01899_ _01802_ VGND VGND VPWR VPWR _01902_ sky130_fd_sc_hd__a21o_1
XFILLER_5_529 VPWR VGND VPWR VGND sky130_ef_sc_hd__decap_12
XFILLER_31_57 VGND VGND VPWR VPWR sky130_fd_sc_hd__decap_8
XTAP_TAPCELL_ROW_134_2169 VGND VPWR sky130_fd_sc_hd__tapvpwrvgnd_1
XFILLER_134_221 VPWR VGND VPWR VGND sky130_ef_sc_hd__decap_12
X_08128_ net679 net678 net476 VGND VGND VPWR VPWR _00864_ sky130_fd_sc_hd__o21ai_1
XFILLER_135_777 VGND VGND VPWR VPWR sky130_fd_sc_hd__decap_6
XFILLER_134_265 VPWR VGND VPWR VGND sky130_ef_sc_hd__decap_12
XFILLER_107_468 VGND VGND VPWR VPWR sky130_fd_sc_hd__decap_3
X_08059_ net249 _00660_ _00664_ VGND VGND VPWR VPWR _00796_ sky130_fd_sc_hd__or3_1
X_11070_ _03805_ _03813_ _03811_ VGND VGND VPWR VPWR _03952_ sky130_fd_sc_hd__a21o_1
Xinput102 w20[4] VGND VGND VPWR VPWR net102 sky130_fd_sc_hd__clkbuf_2
X_10021_ _02799_ _02805_ VGND VGND VPWR VPWR _02807_ sky130_fd_sc_hd__or2_1
XFILLER_49_706 VGND VGND VPWR VPWR sky130_fd_sc_hd__decap_3
XFILLER_0_245 VGND VGND VPWR VPWR sky130_fd_sc_hd__decap_6
Xinput124 w23[2] VGND VGND VPWR VPWR net124 sky130_fd_sc_hd__buf_1
Xinput135 w30[5] VGND VGND VPWR VPWR net135 sky130_fd_sc_hd__buf_1
XFILLER_49_739 VGND VGND VPWR VPWR sky130_fd_sc_hd__decap_6
XFILLER_48_205 VGND VGND VPWR VPWR sky130_fd_sc_hd__decap_6
Xinput113 w21[7] VGND VGND VPWR VPWR net113 sky130_fd_sc_hd__buf_1
XFILLER_102_195 VGND VGND VPWR VPWR sky130_fd_sc_hd__fill_1
Xinput157 w33[3] VGND VGND VPWR VPWR net157 sky130_fd_sc_hd__dlymetal6s2s_1
XFILLER_0_289 VGND VGND VPWR VPWR sky130_fd_sc_hd__fill_1
Xinput146 w32[0] VGND VGND VPWR VPWR net146 sky130_fd_sc_hd__clkbuf_1
XFILLER_63_219 VGND VGND VPWR VPWR sky130_fd_sc_hd__decap_4
XTAP_TAPCELL_ROW_67_1234 VGND VPWR sky130_fd_sc_hd__tapvpwrvgnd_1
XFILLER_56_98 VGND VGND VPWR VPWR sky130_fd_sc_hd__fill_1
X_11972_ net698 net362 VGND VGND VPWR VPWR _04933_ sky130_fd_sc_hd__nand2_1
XFILLER_17_669 VGND VGND VPWR VPWR sky130_fd_sc_hd__decap_3
XPHY_EDGE_ROW_19_Right_19 VGND VGND VPWR VPWR sky130_fd_sc_hd__decap_3
X_10923_ net408 net574 VGND VGND VPWR VPWR _03791_ sky130_fd_sc_hd__nand2_1
XTAP_TAPCELL_ROW_80_1412 VGND VPWR sky130_fd_sc_hd__tapvpwrvgnd_1
XFILLER_44_477 VGND VGND VPWR VPWR sky130_fd_sc_hd__decap_6
XTAP_TAPCELL_ROW_27_675 VGND VPWR sky130_fd_sc_hd__tapvpwrvgnd_1
X_10854_ _03713_ _03714_ VGND VGND VPWR VPWR _03715_ sky130_fd_sc_hd__or2_1
X_10785_ net121 _03465_ _03464_ VGND VGND VPWR VPWR _03640_ sky130_fd_sc_hd__a21o_1
X_12524_ _05532_ _05533_ VGND VGND VPWR VPWR _05535_ sky130_fd_sc_hd__nor2_1
XFILLER_8_345 VPWR VGND VPWR VGND sky130_ef_sc_hd__decap_12
Xclkbuf_3_1__f_clk clknet_0_clk VGND VGND VPWR VPWR clknet_3_1__leaf_clk sky130_fd_sc_hd__clkbuf_16
X_12455_ _05422_ _05423_ _05458_ _05459_ VGND VGND VPWR VPWR _05460_ sky130_fd_sc_hd__nor4_4
XFILLER_126_755 VGND VGND VPWR VPWR sky130_fd_sc_hd__fill_1
X_11406_ _04093_ _04317_ VGND VGND VPWR VPWR _04318_ sky130_fd_sc_hd__nor2_1
XFILLER_8_389 VPWR VGND VPWR VGND sky130_ef_sc_hd__decap_12
X_12386_ net462 net145 VGND VGND VPWR VPWR _05384_ sky130_fd_sc_hd__and2b_1
XFILLER_125_265 VGND VGND VPWR VPWR sky130_fd_sc_hd__fill_2
XFILLER_125_232 VGND VGND VPWR VPWR sky130_fd_sc_hd__decap_8
XFILLER_99_617 VGND VGND VPWR VPWR sky130_fd_sc_hd__fill_2
XTAP_TAPCELL_ROW_78_1385 VGND VPWR sky130_fd_sc_hd__tapvpwrvgnd_1
X_11337_ net540 net274 VGND VGND VPWR VPWR _04244_ sky130_fd_sc_hd__nand2_1
XPHY_EDGE_ROW_28_Right_28 VGND VGND VPWR VPWR sky130_fd_sc_hd__decap_3
XFILLER_113_427 VGND VGND VPWR VPWR sky130_fd_sc_hd__decap_8
XFILLER_113_449 VPWR VGND VPWR VGND sky130_ef_sc_hd__decap_12
XTAP_TAPCELL_ROW_91_1574 VGND VPWR sky130_fd_sc_hd__tapvpwrvgnd_1
XTAP_TAPCELL_ROW_91_1563 VGND VPWR sky130_fd_sc_hd__tapvpwrvgnd_1
X_11268_ _03944_ _04167_ VGND VGND VPWR VPWR _04168_ sky130_fd_sc_hd__xor2_1
XFILLER_67_503 VGND VGND VPWR VPWR sky130_fd_sc_hd__fill_1
X_10219_ _03019_ _03018_ _02942_ VGND VGND VPWR VPWR _03023_ sky130_fd_sc_hd__o21ai_2
X_11199_ _03789_ _03982_ _03985_ VGND VGND VPWR VPWR _04093_ sky130_fd_sc_hd__a21oi_2
X_13007_ _06057_ _06061_ VGND VGND VPWR VPWR _06064_ sky130_fd_sc_hd__xnor2_1
XFILLER_94_333 VGND VGND VPWR VPWR sky130_fd_sc_hd__fill_2
XFILLER_94_388 VPWR VGND VPWR VGND sky130_ef_sc_hd__decap_12
XFILLER_82_528 VGND VGND VPWR VPWR sky130_fd_sc_hd__decap_4
XPHY_EDGE_ROW_37_Right_37 VGND VGND VPWR VPWR sky130_fd_sc_hd__decap_3
XTAP_TAPCELL_ROW_46_940 VGND VPWR sky130_fd_sc_hd__tapvpwrvgnd_1
X_07430_ _00169_ _00170_ VGND VGND VPWR VPWR _00171_ sky130_fd_sc_hd__xnor2_1
XFILLER_23_639 VGND VGND VPWR VPWR sky130_fd_sc_hd__fill_1
X_07361_ _06504_ _06651_ VGND VGND VPWR VPWR _06652_ sky130_fd_sc_hd__nand2_1
XFILLER_22_149 VGND VGND VPWR VPWR sky130_fd_sc_hd__fill_1
X_09100_ net479 net633 VGND VGND VPWR VPWR _01825_ sky130_fd_sc_hd__nand2_4
X_09031_ net644 net257 _01602_ _01601_ VGND VGND VPWR VPWR _01756_ sky130_fd_sc_hd__a31oi_1
X_07292_ _06580_ _06581_ _06552_ VGND VGND VPWR VPWR _06583_ sky130_fd_sc_hd__a21o_1
XTAP_TAPCELL_ROW_100_1692 VGND VPWR sky130_fd_sc_hd__tapvpwrvgnd_1
XPHY_EDGE_ROW_46_Right_46 VGND VGND VPWR VPWR sky130_fd_sc_hd__decap_3
XFILLER_117_744 VPWR VGND VPWR VGND sky130_ef_sc_hd__decap_12
XFILLER_117_27 VPWR VGND VPWR VGND sky130_ef_sc_hd__decap_12
XFILLER_132_725 VPWR VGND VPWR VGND sky130_ef_sc_hd__decap_12
XFILLER_132_769 VPWR VGND VPWR VGND sky130_ef_sc_hd__decap_12
X_09933_ _02713_ _02714_ VGND VGND VPWR VPWR _02715_ sky130_fd_sc_hd__nand2_1
XFILLER_98_672 VGND VGND VPWR VPWR sky130_fd_sc_hd__fill_1
X_09864_ _02513_ _02517_ _02519_ VGND VGND VPWR VPWR _02639_ sky130_fd_sc_hd__a21bo_1
XFILLER_58_514 VGND VGND VPWR VPWR sky130_fd_sc_hd__fill_1
XTAP_TAPCELL_ROW_51_1013 VGND VPWR sky130_fd_sc_hd__tapvpwrvgnd_1
XTAP_TAPCELL_ROW_51_1002 VGND VPWR sky130_fd_sc_hd__tapvpwrvgnd_1
XFILLER_133_15 VPWR VGND VPWR VGND sky130_ef_sc_hd__decap_12
X_08815_ net699 net414 net557 net325 VGND VGND VPWR VPWR _01542_ sky130_fd_sc_hd__and4_1
XTAP_TAPCELL_ROW_5_359 VGND VPWR sky130_fd_sc_hd__tapvpwrvgnd_1
X_09795_ _02562_ _02563_ VGND VGND VPWR VPWR _02564_ sky130_fd_sc_hd__or2_1
XPHY_EDGE_ROW_55_Right_55 VGND VGND VPWR VPWR sky130_fd_sc_hd__decap_3
X_08746_ _01471_ _01472_ VGND VGND VPWR VPWR _01473_ sky130_fd_sc_hd__and2b_1
XFILLER_85_388 VGND VGND VPWR VPWR sky130_fd_sc_hd__decap_4
XFILLER_81_550 VGND VGND VPWR VPWR sky130_fd_sc_hd__decap_8
X_08677_ net422 net557 _01254_ VGND VGND VPWR VPWR _01405_ sky130_fd_sc_hd__and3_1
X_07628_ _00206_ _00367_ VGND VGND VPWR VPWR _00368_ sky130_fd_sc_hd__nor2_1
XFILLER_26_477 VGND VGND VPWR VPWR sky130_fd_sc_hd__fill_2
XFILLER_41_403 VPWR VGND VPWR VGND sky130_ef_sc_hd__decap_12
XTAP_TAPCELL_ROW_24_634 VGND VPWR sky130_fd_sc_hd__tapvpwrvgnd_1
XFILLER_41_447 VGND VGND VPWR VPWR sky130_fd_sc_hd__fill_1
XTAP_TAPCELL_ROW_136_2209 VGND VPWR sky130_fd_sc_hd__tapvpwrvgnd_1
X_07559_ _00295_ _00298_ VGND VGND VPWR VPWR _00299_ sky130_fd_sc_hd__xnor2_1
XTAP_TAPCELL_ROW_62_1164 VGND VPWR sky130_fd_sc_hd__tapvpwrvgnd_1
XFILLER_41_469 VGND VGND VPWR VPWR sky130_fd_sc_hd__fill_2
XPHY_EDGE_ROW_64_Right_64 VGND VGND VPWR VPWR sky130_fd_sc_hd__decap_3
X_10570_ net434 net442 net149 net564 VGND VGND VPWR VPWR _03405_ sky130_fd_sc_hd__nand4_1
XFILLER_42_56 VGND VGND VPWR VPWR sky130_fd_sc_hd__fill_1
XFILLER_42_67 VGND VGND VPWR VPWR sky130_fd_sc_hd__fill_1
X_09229_ _01945_ _01951_ VGND VGND VPWR VPWR _01953_ sky130_fd_sc_hd__xor2_2
XFILLER_6_805 VGND VGND VPWR VPWR sky130_fd_sc_hd__decap_6
XTAP_TAPCELL_ROW_118_1953 VGND VPWR sky130_fd_sc_hd__tapvpwrvgnd_1
XTAP_TAPCELL_ROW_118_1942 VGND VPWR sky130_fd_sc_hd__tapvpwrvgnd_1
XFILLER_5_337 VPWR VGND VPWR VGND sky130_ef_sc_hd__decap_12
X_12240_ net405 net601 VGND VGND VPWR VPWR _05225_ sky130_fd_sc_hd__and2_2
XFILLER_135_541 VPWR VGND VPWR VGND sky130_ef_sc_hd__decap_12
X_12171_ net534 net657 VGND VGND VPWR VPWR _05149_ sky130_fd_sc_hd__and2b_1
XFILLER_135_585 VPWR VGND VPWR VGND sky130_ef_sc_hd__decap_12
XFILLER_122_235 VGND VGND VPWR VPWR sky130_fd_sc_hd__fill_2
XFILLER_96_609 VGND VGND VPWR VPWR sky130_fd_sc_hd__fill_1
X_11122_ _04007_ _04008_ VGND VGND VPWR VPWR _04009_ sky130_fd_sc_hd__nor2_1
XFILLER_110_408 VPWR VGND VPWR VGND sky130_ef_sc_hd__decap_12
XFILLER_107_71 VPWR VGND VPWR VGND sky130_ef_sc_hd__decap_12
XFILLER_49_503 VGND VGND VPWR VPWR sky130_fd_sc_hd__fill_1
XFILLER_3_39 VPWR VGND VPWR VGND sky130_ef_sc_hd__decap_12
X_11053_ _03928_ _03931_ VGND VGND VPWR VPWR _03933_ sky130_fd_sc_hd__xnor2_1
XPHY_EDGE_ROW_73_Right_73 VGND VGND VPWR VPWR sky130_fd_sc_hd__decap_3
X_10004_ _02787_ _02788_ VGND VGND VPWR VPWR _00000_ sky130_fd_sc_hd__and2_1
XFILLER_49_558 VGND VGND VPWR VPWR sky130_fd_sc_hd__fill_2
XFILLER_57_580 VPWR VGND VPWR VGND sky130_ef_sc_hd__decap_12
XFILLER_123_81 VGND VGND VPWR VPWR sky130_fd_sc_hd__decap_8
X_11955_ net471 net463 net586 net583 VGND VGND VPWR VPWR _04914_ sky130_fd_sc_hd__and4_1
XFILLER_44_241 VGND VGND VPWR VPWR sky130_fd_sc_hd__decap_8
XFILLER_72_583 VGND VGND VPWR VPWR sky130_fd_sc_hd__decap_4
XFILLER_60_701 VGND VGND VPWR VPWR sky130_fd_sc_hd__decap_6
X_10906_ _03771_ _03770_ VGND VGND VPWR VPWR _03772_ sky130_fd_sc_hd__nand2b_1
X_11886_ _04834_ _04836_ _04837_ VGND VGND VPWR VPWR _04839_ sky130_fd_sc_hd__nand3_2
XFILLER_44_285 VGND VGND VPWR VPWR sky130_fd_sc_hd__fill_1
XPHY_EDGE_ROW_82_Right_82 VGND VGND VPWR VPWR sky130_fd_sc_hd__decap_3
XFILLER_60_778 VGND VGND VPWR VPWR sky130_fd_sc_hd__decap_6
X_10837_ _03558_ _03560_ VGND VGND VPWR VPWR _03697_ sky130_fd_sc_hd__nand2_1
XFILLER_80_7 VGND VGND VPWR VPWR sky130_fd_sc_hd__decap_4
XFILLER_12_160 VPWR VGND VPWR VGND sky130_ef_sc_hd__decap_12
XFILLER_9_643 VGND VGND VPWR VPWR sky130_fd_sc_hd__decap_8
X_10768_ _03618_ _03619_ _03604_ VGND VGND VPWR VPWR _03622_ sky130_fd_sc_hd__a21oi_1
X_12507_ _05318_ _05514_ VGND VGND VPWR VPWR _05517_ sky130_fd_sc_hd__xor2_1
XFILLER_8_197 VPWR VGND VPWR VGND sky130_ef_sc_hd__decap_12
X_12438_ _05437_ _05438_ _05439_ VGND VGND VPWR VPWR _05442_ sky130_fd_sc_hd__a21o_1
X_10699_ net539 net279 _03542_ _03544_ VGND VGND VPWR VPWR _03546_ sky130_fd_sc_hd__and4_1
XTAP_TAPCELL_ROW_93_1603 VGND VPWR sky130_fd_sc_hd__tapvpwrvgnd_1
XFILLER_126_585 VGND VGND VPWR VPWR sky130_fd_sc_hd__decap_3
XFILLER_99_436 VPWR VGND VPWR VGND sky130_ef_sc_hd__decap_12
X_12369_ _05224_ _05246_ _05245_ VGND VGND VPWR VPWR _05366_ sky130_fd_sc_hd__a21oi_1
XFILLER_114_769 VPWR VGND VPWR VGND sky130_ef_sc_hd__decap_12
XFILLER_113_268 VGND VGND VPWR VPWR sky130_fd_sc_hd__fill_1
X_06930_ _03335_ _04752_ VGND VGND VPWR VPWR _04763_ sky130_fd_sc_hd__or2_1
XPHY_EDGE_ROW_91_Right_91 VGND VGND VPWR VPWR sky130_fd_sc_hd__decap_3
XFILLER_79_182 VPWR VGND VPWR VGND sky130_ef_sc_hd__decap_12
XFILLER_94_141 VGND VGND VPWR VPWR sky130_fd_sc_hd__decap_4
X_06861_ _03992_ _04003_ net470 net607 VGND VGND VPWR VPWR _04014_ sky130_fd_sc_hd__and4bb_1
X_08600_ _01105_ _01112_ _01149_ _01158_ VGND VGND VPWR VPWR _01329_ sky130_fd_sc_hd__a31o_1
XTAP_TAPCELL_ROW_2_318 VGND VPWR sky130_fd_sc_hd__tapvpwrvgnd_1
XTAP_TAPCELL_ROW_2_329 VGND VPWR sky130_fd_sc_hd__tapvpwrvgnd_1
X_06792_ _03237_ _03248_ VGND VGND VPWR VPWR _03259_ sky130_fd_sc_hd__or2_1
X_09580_ net480 net628 VGND VGND VPWR VPWR _02331_ sky130_fd_sc_hd__nand2_1
X_08531_ _01257_ _01258_ _01259_ VGND VGND VPWR VPWR _01260_ sky130_fd_sc_hd__or3_4
X_08462_ _01184_ _01189_ VGND VGND VPWR VPWR _01191_ sky130_fd_sc_hd__xnor2_1
XFILLER_63_572 VPWR VGND VPWR VGND sky130_ef_sc_hd__decap_12
XFILLER_35_241 VGND VGND VPWR VPWR sky130_fd_sc_hd__decap_8
XFILLER_36_786 VPWR VGND VPWR VGND sky130_ef_sc_hd__decap_12
X_07413_ _00141_ _00153_ VGND VGND VPWR VPWR _00154_ sky130_fd_sc_hd__and2b_1
XTAP_TAPCELL_ROW_102_1721 VGND VPWR sky130_fd_sc_hd__tapvpwrvgnd_1
XFILLER_50_233 VPWR VGND VPWR VGND sky130_ef_sc_hd__decap_12
XFILLER_23_447 VGND VGND VPWR VPWR sky130_fd_sc_hd__fill_1
X_08393_ net699 net60 VGND VGND VPWR VPWR _01123_ sky130_fd_sc_hd__nand2_1
X_07344_ _06634_ _06633_ VGND VGND VPWR VPWR _06635_ sky130_fd_sc_hd__nand2b_1
X_07275_ _06556_ _06565_ VGND VGND VPWR VPWR _06566_ sky130_fd_sc_hd__xor2_1
XFILLER_12_15 VPWR VGND VPWR VGND sky130_ef_sc_hd__decap_12
XFILLER_136_349 VGND VGND VPWR VPWR sky130_fd_sc_hd__decap_4
XFILLER_128_15 VPWR VGND VPWR VGND sky130_ef_sc_hd__decap_12
X_09014_ _01737_ _01738_ VGND VGND VPWR VPWR _01740_ sky130_fd_sc_hd__xor2_1
XTAP_TAPCELL_ROW_131_2128 VGND VPWR sky130_fd_sc_hd__tapvpwrvgnd_1
XFILLER_117_596 VGND VGND VPWR VPWR sky130_fd_sc_hd__decap_8
XFILLER_104_213 VPWR VGND VPWR VGND sky130_ef_sc_hd__decap_12
XFILLER_2_307 VGND VGND VPWR VPWR sky130_fd_sc_hd__fill_1
XFILLER_132_533 VPWR VGND VPWR VGND sky130_ef_sc_hd__decap_12
Xfanout622 net623 VGND VGND VPWR VPWR net622 sky130_fd_sc_hd__dlymetal6s2s_1
XTAP_TAPCELL_ROW_113_1883 VGND VPWR sky130_fd_sc_hd__tapvpwrvgnd_1
XTAP_TAPCELL_ROW_113_1872 VGND VPWR sky130_fd_sc_hd__tapvpwrvgnd_1
X_09916_ _02694_ _02695_ VGND VGND VPWR VPWR _02696_ sky130_fd_sc_hd__and2b_1
XFILLER_104_257 VGND VGND VPWR VPWR sky130_fd_sc_hd__fill_1
Xfanout633 net123 VGND VGND VPWR VPWR net633 sky130_fd_sc_hd__clkbuf_4
Xfanout611 net612 VGND VGND VPWR VPWR net611 sky130_fd_sc_hd__buf_2
XFILLER_77_119 VGND VGND VPWR VPWR sky130_fd_sc_hd__fill_1
XFILLER_77_108 VGND VGND VPWR VPWR sky130_fd_sc_hd__decap_4
Xfanout600 net601 VGND VGND VPWR VPWR net600 sky130_fd_sc_hd__buf_2
Xfanout644 net646 VGND VGND VPWR VPWR net644 sky130_fd_sc_hd__buf_2
Xfanout666 net671 VGND VGND VPWR VPWR net666 sky130_fd_sc_hd__clkbuf_2
Xfanout655 net114 VGND VGND VPWR VPWR net655 sky130_fd_sc_hd__clkbuf_4
Xfanout688 net689 VGND VGND VPWR VPWR net688 sky130_fd_sc_hd__buf_1
X_09847_ _02620_ _02619_ VGND VGND VPWR VPWR _02622_ sky130_fd_sc_hd__and2b_1
XFILLER_86_675 VGND VGND VPWR VPWR sky130_fd_sc_hd__decap_8
XFILLER_85_130 VGND VGND VPWR VPWR sky130_fd_sc_hd__decap_8
Xfanout699 net700 VGND VGND VPWR VPWR net699 sky130_fd_sc_hd__buf_2
Xfanout677 net106 VGND VGND VPWR VPWR net677 sky130_fd_sc_hd__clkbuf_4
XTAP_TAPCELL_ROW_29_704 VGND VPWR sky130_fd_sc_hd__tapvpwrvgnd_1
X_09778_ _02421_ _02545_ VGND VGND VPWR VPWR _02546_ sky130_fd_sc_hd__nor2_1
XFILLER_100_474 VGND VGND VPWR VPWR sky130_fd_sc_hd__fill_2
XFILLER_86_697 VGND VGND VPWR VPWR sky130_fd_sc_hd__decap_3
XFILLER_58_377 VGND VGND VPWR VPWR sky130_fd_sc_hd__fill_1
XFILLER_37_45 VGND VGND VPWR VPWR sky130_fd_sc_hd__decap_8
X_08729_ net644 net259 net257 net669 VGND VGND VPWR VPWR _01456_ sky130_fd_sc_hd__a22oi_1
XFILLER_73_369 VPWR VGND VPWR VGND sky130_ef_sc_hd__decap_12
XFILLER_27_753 VPWR VGND VPWR VGND sky130_ef_sc_hd__decap_12
X_11740_ net271 net690 net297 net295 VGND VGND VPWR VPWR _04679_ sky130_fd_sc_hd__and4_1
XFILLER_27_775 VGND VGND VPWR VPWR sky130_fd_sc_hd__decap_8
XFILLER_27_797 VGND VGND VPWR VPWR sky130_fd_sc_hd__decap_8
XFILLER_26_285 VPWR VGND VPWR VGND sky130_ef_sc_hd__decap_12
X_11671_ _04603_ _04604_ VGND VGND VPWR VPWR _04605_ sky130_fd_sc_hd__nand2_1
XFILLER_42_789 VGND VGND VPWR VPWR sky130_fd_sc_hd__decap_3
X_13410_ clknet_3_7__leaf_clk _00062_ _00120_ VGND VGND VPWR VPWR net224 sky130_fd_sc_hd__dfrtp_1
X_10622_ _03459_ _03460_ net311 net350 VGND VGND VPWR VPWR _03462_ sky130_fd_sc_hd__and4bb_1
XFILLER_127_305 VGND VGND VPWR VPWR sky130_fd_sc_hd__decap_4
X_13341_ net398 VGND VGND VPWR VPWR _00115_ sky130_fd_sc_hd__inv_2
X_10553_ _03255_ _03275_ _03274_ VGND VGND VPWR VPWR _03386_ sky130_fd_sc_hd__o21bai_1
XFILLER_10_653 VGND VGND VPWR VPWR sky130_fd_sc_hd__fill_1
XFILLER_127_316 VGND VGND VPWR VPWR sky130_fd_sc_hd__decap_6
XFILLER_6_613 VPWR VGND VPWR VGND sky130_ef_sc_hd__decap_12
X_10484_ _03157_ net238 _03310_ _03309_ VGND VGND VPWR VPWR _03311_ sky130_fd_sc_hd__o211ai_2
XFILLER_6_657 VPWR VGND VPWR VGND sky130_ef_sc_hd__decap_12
X_13272_ _06349_ _06350_ VGND VGND VPWR VPWR _06351_ sky130_fd_sc_hd__xnor2_1
XFILLER_123_500 VGND VGND VPWR VPWR sky130_fd_sc_hd__decap_4
XTAP_TAPCELL_ROW_75_1344 VGND VPWR sky130_fd_sc_hd__tapvpwrvgnd_1
X_12223_ net454 net584 _05204_ _05205_ VGND VGND VPWR VPWR _05206_ sky130_fd_sc_hd__a22o_1
XFILLER_5_167 VGND VGND VPWR VPWR sky130_fd_sc_hd__fill_1
XFILLER_135_393 VPWR VGND VPWR VGND sky130_ef_sc_hd__decap_12
X_12154_ _05128_ _05130_ VGND VGND VPWR VPWR _00034_ sky130_fd_sc_hd__xor2_1
XFILLER_110_205 VGND VGND VPWR VPWR sky130_fd_sc_hd__decap_3
XFILLER_96_406 VGND VGND VPWR VPWR sky130_fd_sc_hd__decap_3
X_11105_ _03972_ _03988_ VGND VGND VPWR VPWR _03990_ sky130_fd_sc_hd__xor2_2
X_12085_ net471 net581 VGND VGND VPWR VPWR _05056_ sky130_fd_sc_hd__nand2_1
XFILLER_76_141 VGND VGND VPWR VPWR sky130_fd_sc_hd__decap_4
X_11036_ _03912_ _03913_ VGND VGND VPWR VPWR _03914_ sky130_fd_sc_hd__xnor2_1
XFILLER_92_634 VGND VGND VPWR VPWR sky130_fd_sc_hd__decap_3
XFILLER_77_697 VGND VGND VPWR VPWR sky130_fd_sc_hd__decap_8
XFILLER_92_645 VGND VGND VPWR VPWR sky130_fd_sc_hd__fill_1
XFILLER_91_177 VPWR VGND VPWR VGND sky130_ef_sc_hd__decap_12
X_12987_ _02098_ net567 net284 net81 VGND VGND VPWR VPWR _06042_ sky130_fd_sc_hd__and4_1
XTAP_TAPCELL_ROW_86_1495 VGND VPWR sky130_fd_sc_hd__tapvpwrvgnd_1
XFILLER_60_531 VGND VGND VPWR VPWR sky130_fd_sc_hd__fill_1
X_11938_ _04892_ _04893_ _04895_ VGND VGND VPWR VPWR _04896_ sky130_fd_sc_hd__and3_1
X_11869_ _04642_ _04674_ VGND VGND VPWR VPWR _04821_ sky130_fd_sc_hd__and2_1
XFILLER_32_244 VGND VGND VPWR VPWR sky130_fd_sc_hd__decap_8
XFILLER_20_417 VGND VGND VPWR VPWR sky130_fd_sc_hd__decap_3
XFILLER_119_806 VGND VGND VPWR VPWR sky130_fd_sc_hd__fill_1
X_07060_ _06161_ _06150_ net802 _04686_ VGND VGND VPWR VPWR _06183_ sky130_fd_sc_hd__a211oi_4
XFILLER_118_349 VGND VGND VPWR VPWR sky130_fd_sc_hd__decap_6
Xoutput214 net214 VGND VGND VPWR VPWR out3[13] sky130_fd_sc_hd__buf_2
Xoutput225 net225 VGND VGND VPWR VPWR out3[9] sky130_fd_sc_hd__buf_2
Xoutput203 net203 VGND VGND VPWR VPWR out2[3] sky130_fd_sc_hd__buf_2
XFILLER_114_555 VPWR VGND VPWR VGND sky130_ef_sc_hd__decap_12
XFILLER_114_533 VGND VGND VPWR VPWR sky130_fd_sc_hd__decap_8
XFILLER_114_522 VGND VGND VPWR VPWR sky130_fd_sc_hd__decap_8
XFILLER_59_119 VGND VGND VPWR VPWR sky130_fd_sc_hd__fill_1
X_09701_ _02247_ _02255_ _02460_ VGND VGND VPWR VPWR _02462_ sky130_fd_sc_hd__nand3_1
X_07962_ _00697_ _00698_ VGND VGND VPWR VPWR _00700_ sky130_fd_sc_hd__xor2_2
XFILLER_99_288 VPWR VGND VPWR VGND sky130_ef_sc_hd__decap_12
X_06913_ _04526_ _04548_ _04145_ VGND VGND VPWR VPWR _04579_ sky130_fd_sc_hd__o21a_1
X_07893_ _06587_ _00630_ VGND VGND VPWR VPWR _00631_ sky130_fd_sc_hd__xnor2_1
XFILLER_67_141 VGND VGND VPWR VPWR sky130_fd_sc_hd__fill_1
X_06844_ _03270_ _03817_ VGND VGND VPWR VPWR _03828_ sky130_fd_sc_hd__nor2_1
XFILLER_95_461 VPWR VGND VPWR VGND sky130_ef_sc_hd__decap_12
X_09632_ net336 net314 net325 net324 VGND VGND VPWR VPWR _02387_ sky130_fd_sc_hd__and4b_1
XFILLER_67_163 VGND VGND VPWR VPWR sky130_fd_sc_hd__decap_4
XTAP_TAPCELL_ROW_128_2090 VGND VPWR sky130_fd_sc_hd__tapvpwrvgnd_1
X_09563_ net423 net537 VGND VGND VPWR VPWR _02312_ sky130_fd_sc_hd__nand2_1
XFILLER_83_667 VGND VGND VPWR VPWR sky130_fd_sc_hd__fill_1
XFILLER_82_133 VGND VGND VPWR VPWR sky130_fd_sc_hd__decap_6
XFILLER_130_27 VGND VGND VPWR VPWR sky130_fd_sc_hd__fill_1
X_06775_ net267 net318 _03053_ _03063_ VGND VGND VPWR VPWR _03074_ sky130_fd_sc_hd__and4_1
X_08514_ _01237_ _01241_ VGND VGND VPWR VPWR _01243_ sky130_fd_sc_hd__xnor2_1
XFILLER_70_317 VPWR VGND VPWR VGND sky130_ef_sc_hd__decap_12
X_09494_ _02124_ _02126_ _02235_ VGND VGND VPWR VPWR _02237_ sky130_fd_sc_hd__and3_1
XFILLER_63_380 VPWR VGND VPWR VGND sky130_ef_sc_hd__decap_12
XFILLER_24_723 VGND VGND VPWR VPWR sky130_fd_sc_hd__fill_2
X_08445_ _01168_ _01173_ VGND VGND VPWR VPWR _01174_ sky130_fd_sc_hd__xnor2_1
X_08376_ net535 net633 VGND VGND VPWR VPWR _01107_ sky130_fd_sc_hd__nand2_1
XFILLER_23_277 VGND VGND VPWR VPWR sky130_fd_sc_hd__decap_3
XTAP_TAPCELL_ROW_34_773 VGND VPWR sky130_fd_sc_hd__tapvpwrvgnd_1
X_07327_ net391 net288 net137 VGND VGND VPWR VPWR _06618_ sky130_fd_sc_hd__and3_1
XFILLER_23_69 VGND VGND VPWR VPWR sky130_fd_sc_hd__decap_3
XFILLER_136_113 VPWR VGND VPWR VGND sky130_ef_sc_hd__decap_12
XTAP_TAPCELL_ROW_115_1901 VGND VPWR sky130_fd_sc_hd__tapvpwrvgnd_1
X_07258_ _06505_ _06548_ VGND VGND VPWR VPWR _06549_ sky130_fd_sc_hd__nand2_1
XFILLER_117_371 VGND VGND VPWR VPWR sky130_fd_sc_hd__fill_2
X_07189_ _06452_ net800 _06480_ VGND VGND VPWR VPWR _06481_ sky130_fd_sc_hd__nand3_1
XFILLER_117_393 VPWR VGND VPWR VGND sky130_ef_sc_hd__decap_12
XFILLER_105_533 VGND VGND VPWR VPWR sky130_fd_sc_hd__decap_6
XFILLER_132_363 VGND VGND VPWR VPWR sky130_fd_sc_hd__fill_1
XTAP_TAPCELL_ROW_57_1096 VGND VPWR sky130_fd_sc_hd__tapvpwrvgnd_1
XFILLER_78_428 VGND VGND VPWR VPWR sky130_fd_sc_hd__decap_8
Xfanout430 net431 VGND VGND VPWR VPWR net430 sky130_fd_sc_hd__buf_8
Xfanout441 net29 VGND VGND VPWR VPWR net441 sky130_fd_sc_hd__clkbuf_4
Xfanout452 net453 VGND VGND VPWR VPWR net452 sky130_fd_sc_hd__buf_2
XTAP_TAPCELL_ROW_70_1274 VGND VPWR sky130_fd_sc_hd__tapvpwrvgnd_1
XFILLER_58_141 VGND VGND VPWR VPWR sky130_fd_sc_hd__decap_6
Xfanout463 net466 VGND VGND VPWR VPWR net463 sky130_fd_sc_hd__dlymetal6s2s_1
Xfanout474 net25 VGND VGND VPWR VPWR net474 sky130_fd_sc_hd__buf_2
Xfanout485 net23 VGND VGND VPWR VPWR net485 sky130_fd_sc_hd__buf_8
XFILLER_101_783 VGND VGND VPWR VPWR sky130_fd_sc_hd__fill_1
XFILLER_86_483 VPWR VGND VPWR VGND sky130_ef_sc_hd__decap_12
XFILLER_74_634 VGND VGND VPWR VPWR sky130_fd_sc_hd__fill_1
XFILLER_58_163 VGND VGND VPWR VPWR sky130_fd_sc_hd__fill_2
X_12910_ _05955_ _05956_ VGND VGND VPWR VPWR _05958_ sky130_fd_sc_hd__xor2_1
Xfanout496 net498 VGND VGND VPWR VPWR net496 sky130_fd_sc_hd__buf_1
XPHY_EDGE_ROW_100_Left_237 VGND VGND VPWR VPWR sky130_fd_sc_hd__decap_3
XFILLER_64_21 VGND VGND VPWR VPWR sky130_fd_sc_hd__decap_6
XFILLER_0_29 VGND VGND VPWR VPWR sky130_fd_sc_hd__fill_2
X_12841_ _05874_ _05880_ VGND VGND VPWR VPWR _05882_ sky130_fd_sc_hd__xor2_1
XFILLER_104_83 VGND VGND VPWR VPWR sky130_fd_sc_hd__fill_1
XFILLER_64_54 VPWR VGND VPWR VGND sky130_ef_sc_hd__decap_12
XFILLER_61_317 VPWR VGND VPWR VGND sky130_ef_sc_hd__decap_12
XFILLER_27_550 VGND VGND VPWR VPWR sky130_fd_sc_hd__fill_2
XFILLER_27_561 VGND VGND VPWR VPWR sky130_fd_sc_hd__decap_8
X_12772_ _05647_ _05650_ VGND VGND VPWR VPWR _05807_ sky130_fd_sc_hd__and2_1
X_11723_ _04603_ _04609_ _04660_ VGND VGND VPWR VPWR _04661_ sky130_fd_sc_hd__a21oi_1
XFILLER_9_27 VPWR VGND VPWR VGND sky130_ef_sc_hd__decap_12
X_11654_ net462 net600 _04583_ _04585_ VGND VGND VPWR VPWR _04586_ sky130_fd_sc_hd__and4_1
XFILLER_14_277 VGND VGND VPWR VPWR sky130_fd_sc_hd__fill_2
XFILLER_30_737 VGND VGND VPWR VPWR sky130_fd_sc_hd__decap_8
XFILLER_42_586 VGND VGND VPWR VPWR sky130_fd_sc_hd__fill_2
XFILLER_80_64 VGND VGND VPWR VPWR sky130_fd_sc_hd__fill_2
X_10605_ _03440_ _03441_ _03431_ VGND VGND VPWR VPWR _03443_ sky130_fd_sc_hd__a21o_1
XFILLER_127_113 VPWR VGND VPWR VGND sky130_ef_sc_hd__decap_12
XFILLER_80_97 VPWR VGND VPWR VGND sky130_ef_sc_hd__decap_12
XTAP_TAPCELL_ROW_12_456 VGND VPWR sky130_fd_sc_hd__tapvpwrvgnd_1
X_11585_ _04511_ _04512_ VGND VGND VPWR VPWR _04514_ sky130_fd_sc_hd__xnor2_1
XTAP_TAPCELL_ROW_12_467 VGND VPWR sky130_fd_sc_hd__tapvpwrvgnd_1
XFILLER_128_669 VPWR VGND VPWR VGND sky130_ef_sc_hd__decap_12
X_13324_ net392 VGND VGND VPWR VPWR _00098_ sky130_fd_sc_hd__inv_2
X_10536_ net503 net118 net648 net520 VGND VGND VPWR VPWR _03367_ sky130_fd_sc_hd__a22o_1
XFILLER_6_421 VPWR VGND VPWR VGND sky130_ef_sc_hd__decap_12
XPHY_EDGE_ROW_108_Right_108 VGND VGND VPWR VPWR sky130_fd_sc_hd__decap_3
X_10467_ net309 net352 net350 net332 VGND VGND VPWR VPWR _03293_ sky130_fd_sc_hd__a22oi_2
X_13255_ _06325_ _06330_ VGND VGND VPWR VPWR _06332_ sky130_fd_sc_hd__xnor2_1
XFILLER_89_73 VGND VGND VPWR VPWR sky130_fd_sc_hd__decap_6
X_12206_ net488 net676 net674 net492 VGND VGND VPWR VPWR _05187_ sky130_fd_sc_hd__a22o_1
XFILLER_97_726 VGND VGND VPWR VPWR sky130_fd_sc_hd__fill_2
XFILLER_96_203 VPWR VGND VPWR VGND sky130_ef_sc_hd__decap_12
X_10398_ _02927_ _03077_ _03217_ VGND VGND VPWR VPWR _03218_ sky130_fd_sc_hd__a21oi_1
X_13186_ _06145_ _06147_ _06257_ VGND VGND VPWR VPWR _06258_ sky130_fd_sc_hd__a21oi_1
XFILLER_111_547 VGND VGND VPWR VPWR sky130_fd_sc_hd__decap_4
XFILLER_96_236 VGND VGND VPWR VPWR sky130_fd_sc_hd__fill_2
X_12137_ _05054_ _05110_ _05111_ VGND VGND VPWR VPWR _05113_ sky130_fd_sc_hd__nand3_1
XFILLER_2_693 VGND VGND VPWR VPWR sky130_fd_sc_hd__decap_6
XFILLER_111_558 VGND VGND VPWR VPWR sky130_fd_sc_hd__fill_2
X_12068_ _04890_ _04892_ VGND VGND VPWR VPWR _05038_ sky130_fd_sc_hd__nand2_1
XFILLER_1_181 VPWR VGND VPWR VGND sky130_ef_sc_hd__decap_12
XTAP_TAPCELL_ROW_88_1524 VGND VPWR sky130_fd_sc_hd__tapvpwrvgnd_1
XFILLER_77_461 VPWR VGND VPWR VGND sky130_ef_sc_hd__decap_12
X_11019_ _03888_ _03895_ VGND VGND VPWR VPWR _03896_ sky130_fd_sc_hd__and2_1
XFILLER_37_303 VPWR VGND VPWR VGND sky130_ef_sc_hd__decap_12
XFILLER_92_442 VPWR VGND VPWR VGND sky130_ef_sc_hd__decap_12
XFILLER_65_645 VGND VGND VPWR VPWR sky130_fd_sc_hd__decap_3
XFILLER_65_634 VGND VGND VPWR VPWR sky130_fd_sc_hd__fill_1
XFILLER_53_807 VGND VGND VPWR VPWR sky130_fd_sc_hd__decap_4
XFILLER_37_325 VGND VGND VPWR VPWR sky130_fd_sc_hd__fill_2
XFILLER_92_475 VGND VGND VPWR VPWR sky130_fd_sc_hd__fill_1
XFILLER_52_306 VGND VGND VPWR VPWR sky130_fd_sc_hd__fill_2
XFILLER_25_509 VPWR VGND VPWR VGND sky130_ef_sc_hd__decap_12
XFILLER_100_19 VGND VGND VPWR VPWR sky130_fd_sc_hd__decap_8
XFILLER_45_391 VGND VGND VPWR VPWR sky130_fd_sc_hd__fill_1
X_08230_ _00847_ _00854_ _00853_ VGND VGND VPWR VPWR _00965_ sky130_fd_sc_hd__a21bo_1
XFILLER_60_372 VGND VGND VPWR VPWR sky130_fd_sc_hd__decap_8
XFILLER_21_715 VGND VGND VPWR VPWR sky130_fd_sc_hd__fill_1
XFILLER_119_603 VPWR VGND VPWR VGND sky130_ef_sc_hd__decap_12
XTAP_TAPCELL_ROW_31_732 VGND VPWR sky130_fd_sc_hd__tapvpwrvgnd_1
X_08161_ _00894_ _00895_ _00893_ VGND VGND VPWR VPWR _00897_ sky130_fd_sc_hd__o21bai_1
X_08092_ _00570_ _00703_ _00574_ _00828_ _00704_ VGND VGND VPWR VPWR _00829_ sky130_fd_sc_hd__a221oi_4
XFILLER_107_809 VGND VGND VPWR VPWR sky130_fd_sc_hd__fill_2
X_07112_ net527 net678 VGND VGND VPWR VPWR _06404_ sky130_fd_sc_hd__and2_1
XTAP_TAPCELL_ROW_99_1686 VGND VPWR sky130_fd_sc_hd__tapvpwrvgnd_1
XTAP_TAPCELL_ROW_99_1675 VGND VPWR sky130_fd_sc_hd__tapvpwrvgnd_1
XFILLER_9_281 VGND VGND VPWR VPWR sky130_fd_sc_hd__decap_6
XFILLER_133_105 VGND VGND VPWR VPWR sky130_fd_sc_hd__decap_6
X_07043_ _04188_ _04319_ _04308_ VGND VGND VPWR VPWR _05997_ sky130_fd_sc_hd__a21bo_1
XFILLER_133_149 VPWR VGND VPWR VGND sky130_ef_sc_hd__decap_12
XFILLER_126_190 VGND VGND VPWR VPWR sky130_fd_sc_hd__decap_6
XFILLER_125_27 VPWR VGND VPWR VGND sky130_ef_sc_hd__decap_12
XTAP_TAPCELL_ROW_110_1831 VGND VPWR sky130_fd_sc_hd__tapvpwrvgnd_1
X_08994_ _01717_ _01718_ VGND VGND VPWR VPWR _01720_ sky130_fd_sc_hd__xnor2_1
X_07945_ _00680_ _00681_ VGND VGND VPWR VPWR _00683_ sky130_fd_sc_hd__xnor2_1
XFILLER_28_303 VGND VGND VPWR VPWR sky130_fd_sc_hd__decap_4
X_09615_ _02081_ _02227_ _02226_ VGND VGND VPWR VPWR _02369_ sky130_fd_sc_hd__a21oi_1
X_07876_ _00579_ _00613_ VGND VGND VPWR VPWR _00614_ sky130_fd_sc_hd__and2_1
XFILLER_83_420 VPWR VGND VPWR VGND sky130_ef_sc_hd__decap_12
XFILLER_56_645 VGND VGND VPWR VPWR sky130_fd_sc_hd__decap_8
XFILLER_44_807 VGND VGND VPWR VPWR sky130_fd_sc_hd__fill_1
XFILLER_28_325 VGND VGND VPWR VPWR sky130_fd_sc_hd__decap_3
XFILLER_28_336 VGND VGND VPWR VPWR sky130_fd_sc_hd__decap_6
XTAP_TAPCELL_ROW_39_843 VGND VPWR sky130_fd_sc_hd__tapvpwrvgnd_1
X_06827_ _03379_ _03620_ VGND VGND VPWR VPWR _03642_ sky130_fd_sc_hd__xnor2_1
XFILLER_71_615 VGND VGND VPWR VPWR sky130_fd_sc_hd__fill_1
XFILLER_43_306 VGND VGND VPWR VPWR sky130_fd_sc_hd__fill_1
X_06758_ _02501_ _02511_ _02479_ VGND VGND VPWR VPWR _02888_ sky130_fd_sc_hd__o21a_1
XFILLER_83_497 VGND VGND VPWR VPWR sky130_fd_sc_hd__fill_1
X_09546_ _02292_ _02293_ VGND VGND VPWR VPWR _02294_ sky130_fd_sc_hd__xnor2_1
XFILLER_55_177 VGND VGND VPWR VPWR sky130_fd_sc_hd__fill_1
X_09477_ _02127_ _02218_ VGND VGND VPWR VPWR _02220_ sky130_fd_sc_hd__xnor2_1
XFILLER_24_531 VGND VGND VPWR VPWR sky130_fd_sc_hd__fill_1
XFILLER_36_391 VGND VGND VPWR VPWR sky130_fd_sc_hd__fill_1
X_08428_ _01150_ _01157_ VGND VGND VPWR VPWR _01158_ sky130_fd_sc_hd__nor2_1
X_06689_ net373 VGND VGND VPWR VPWR _02142_ sky130_fd_sc_hd__inv_2
XFILLER_12_737 VPWR VGND VPWR VGND sky130_ef_sc_hd__decap_12
XFILLER_24_586 VGND VGND VPWR VPWR sky130_fd_sc_hd__fill_2
XFILLER_34_57 VGND VGND VPWR VPWR sky130_fd_sc_hd__fill_1
XTAP_TAPCELL_ROW_121_1993 VGND VPWR sky130_fd_sc_hd__tapvpwrvgnd_1
XTAP_TAPCELL_ROW_121_1982 VGND VPWR sky130_fd_sc_hd__tapvpwrvgnd_1
X_08359_ _01086_ _01087_ _01088_ VGND VGND VPWR VPWR _01091_ sky130_fd_sc_hd__o21a_1
Xclkload1 clknet_3_1__leaf_clk VGND VGND VPWR VPWR clkload1/Y sky130_fd_sc_hd__clkinv_2
XTAP_TAPCELL_ROW_59_1114 VGND VPWR sky130_fd_sc_hd__tapvpwrvgnd_1
XFILLER_20_781 VPWR VGND VPWR VGND sky130_ef_sc_hd__decap_12
X_11370_ _04023_ _04151_ _04150_ VGND VGND VPWR VPWR _04280_ sky130_fd_sc_hd__a21oi_1
XFILLER_119_3 VPWR VGND VPWR VGND sky130_ef_sc_hd__decap_12
XTAP_TAPCELL_ROW_59_1125 VGND VPWR sky130_fd_sc_hd__tapvpwrvgnd_1
X_10321_ net512 net425 net349 net346 VGND VGND VPWR VPWR _03134_ sky130_fd_sc_hd__and4_1
X_13040_ _05748_ _05867_ VGND VGND VPWR VPWR _06099_ sky130_fd_sc_hd__nor2_1
XFILLER_79_704 VGND VGND VPWR VPWR sky130_fd_sc_hd__fill_2
XTAP_TAPCELL_ROW_72_1303 VGND VPWR sky130_fd_sc_hd__tapvpwrvgnd_1
X_10252_ _02883_ _02887_ _02912_ _02909_ VGND VGND VPWR VPWR _03058_ sky130_fd_sc_hd__a31o_1
XFILLER_1_3 VPWR VGND VPWR VGND sky130_ef_sc_hd__decap_12
XFILLER_79_737 VGND VGND VPWR VPWR sky130_fd_sc_hd__decap_8
X_10183_ _02975_ _02974_ _02981_ VGND VGND VPWR VPWR _02983_ sky130_fd_sc_hd__a21o_1
XFILLER_94_707 VGND VGND VPWR VPWR sky130_fd_sc_hd__fill_1
XFILLER_120_388 VGND VGND VPWR VPWR sky130_fd_sc_hd__decap_4
Xfanout260 net92 VGND VGND VPWR VPWR net260 sky130_fd_sc_hd__buf_2
XFILLER_59_483 VGND VGND VPWR VPWR sky130_fd_sc_hd__fill_1
Xfanout282 net283 VGND VGND VPWR VPWR net282 sky130_fd_sc_hd__clkbuf_2
Xfanout271 net9 VGND VGND VPWR VPWR net271 sky130_fd_sc_hd__clkbuf_4
XFILLER_47_656 VGND VGND VPWR VPWR sky130_fd_sc_hd__fill_1
Xfanout293 net79 VGND VGND VPWR VPWR net293 sky130_fd_sc_hd__buf_2
XFILLER_19_369 VPWR VGND VPWR VGND sky130_ef_sc_hd__decap_12
XFILLER_46_188 VGND VGND VPWR VPWR sky130_fd_sc_hd__decap_8
X_12824_ net366 net364 net290 VGND VGND VPWR VPWR _05863_ sky130_fd_sc_hd__o21ai_1
XTAP_TAPCELL_ROW_17_526 VGND VPWR sky130_fd_sc_hd__tapvpwrvgnd_1
XTAP_TAPCELL_ROW_17_537 VGND VPWR sky130_fd_sc_hd__tapvpwrvgnd_1
XFILLER_27_380 VPWR VGND VPWR VGND sky130_ef_sc_hd__decap_12
XFILLER_131_81 VPWR VGND VPWR VGND sky130_ef_sc_hd__decap_12
XTAP_TAPCELL_ROW_83_1454 VGND VPWR sky130_fd_sc_hd__tapvpwrvgnd_1
XFILLER_61_169 VGND VGND VPWR VPWR sky130_fd_sc_hd__decap_4
X_12755_ _05778_ _05787_ VGND VGND VPWR VPWR _05788_ sky130_fd_sc_hd__xnor2_1
X_11706_ _04640_ _04641_ VGND VGND VPWR VPWR _04642_ sky130_fd_sc_hd__or2_1
XFILLER_30_501 VGND VGND VPWR VPWR sky130_fd_sc_hd__decap_4
X_12686_ _05710_ _05711_ VGND VGND VPWR VPWR _05712_ sky130_fd_sc_hd__nand2b_1
XFILLER_30_545 VGND VGND VPWR VPWR sky130_fd_sc_hd__fill_2
XFILLER_128_400 VGND VGND VPWR VPWR sky130_fd_sc_hd__decap_3
X_11637_ _04523_ _04569_ VGND VGND VPWR VPWR _04571_ sky130_fd_sc_hd__xnor2_1
XFILLER_30_567 VGND VGND VPWR VPWR sky130_fd_sc_hd__decap_6
XFILLER_30_589 VPWR VGND VPWR VGND sky130_ef_sc_hd__decap_12
XFILLER_128_433 VPWR VGND VPWR VGND sky130_ef_sc_hd__decap_12
XFILLER_7_741 VPWR VGND VPWR VGND sky130_ef_sc_hd__decap_12
X_11568_ _04480_ _04495_ VGND VGND VPWR VPWR _04496_ sky130_fd_sc_hd__xnor2_1
XFILLER_128_477 VPWR VGND VPWR VGND sky130_ef_sc_hd__decap_12
X_13307_ net396 VGND VGND VPWR VPWR _00081_ sky130_fd_sc_hd__inv_2
X_10519_ net539 net283 VGND VGND VPWR VPWR _03349_ sky130_fd_sc_hd__nand2_1
XFILLER_7_785 VPWR VGND VPWR VGND sky130_ef_sc_hd__decap_12
XFILLER_6_251 VGND VGND VPWR VPWR sky130_fd_sc_hd__fill_1
X_11499_ net342 net343 net286 VGND VGND VPWR VPWR _04420_ sky130_fd_sc_hd__mux2_1
XFILLER_131_609 VGND VGND VPWR VPWR sky130_fd_sc_hd__decap_6
XFILLER_124_661 VGND VGND VPWR VPWR sky130_fd_sc_hd__decap_6
XFILLER_97_501 VGND VGND VPWR VPWR sky130_fd_sc_hd__decap_3
X_13238_ _06313_ _06314_ VGND VGND VPWR VPWR _06315_ sky130_fd_sc_hd__nand2b_1
XFILLER_69_225 VPWR VGND VPWR VGND sky130_ef_sc_hd__decap_12
X_13169_ _06234_ _06238_ VGND VGND VPWR VPWR _06240_ sky130_fd_sc_hd__xnor2_1
X_07730_ _00466_ _00467_ VGND VGND VPWR VPWR _00469_ sky130_fd_sc_hd__nor2_1
XFILLER_78_792 VPWR VGND VPWR VGND sky130_ef_sc_hd__decap_12
XFILLER_77_291 VGND VGND VPWR VPWR sky130_fd_sc_hd__fill_1
XFILLER_65_431 VGND VGND VPWR VPWR sky130_fd_sc_hd__decap_6
XFILLER_38_645 VPWR VGND VPWR VGND sky130_ef_sc_hd__decap_12
X_07661_ _06587_ _00400_ VGND VGND VPWR VPWR _00401_ sky130_fd_sc_hd__xnor2_1
XFILLER_53_615 VGND VGND VPWR VPWR sky130_fd_sc_hd__fill_1
XTAP_TAPCELL_ROW_36_802 VGND VPWR sky130_fd_sc_hd__tapvpwrvgnd_1
XFILLER_37_144 VGND VGND VPWR VPWR sky130_fd_sc_hd__fill_1
XFILLER_38_667 VPWR VGND VPWR VGND sky130_ef_sc_hd__decap_12
X_09400_ _02133_ _02134_ VGND VGND VPWR VPWR _02135_ sky130_fd_sc_hd__xnor2_1
X_07592_ _00330_ _00331_ VGND VGND VPWR VPWR _00332_ sky130_fd_sc_hd__xnor2_1
XFILLER_65_497 VGND VGND VPWR VPWR sky130_fd_sc_hd__decap_3
XFILLER_52_125 VGND VGND VPWR VPWR sky130_fd_sc_hd__decap_4
X_09331_ _02058_ _02057_ _01999_ VGND VGND VPWR VPWR _02060_ sky130_fd_sc_hd__a21o_1
XFILLER_80_489 VPWR VGND VPWR VGND sky130_ef_sc_hd__decap_12
XFILLER_33_361 VGND VGND VPWR VPWR sky130_fd_sc_hd__decap_4
XFILLER_40_309 VGND VGND VPWR VPWR sky130_fd_sc_hd__fill_1
X_09262_ net456 net161 VGND VGND VPWR VPWR _01986_ sky130_fd_sc_hd__and2b_1
X_09193_ _01915_ _01917_ VGND VGND VPWR VPWR _00062_ sky130_fd_sc_hd__xnor2_1
X_08213_ _00941_ _00947_ VGND VGND VPWR VPWR _00948_ sky130_fd_sc_hd__nand2b_1
XFILLER_21_589 VPWR VGND VPWR VGND sky130_ef_sc_hd__decap_12
X_08144_ _00877_ _00878_ VGND VGND VPWR VPWR _00880_ sky130_fd_sc_hd__and2_1
XFILLER_136_15 VPWR VGND VPWR VGND sky130_ef_sc_hd__decap_12
X_08075_ _00777_ _00811_ VGND VGND VPWR VPWR _00812_ sky130_fd_sc_hd__xor2_1
XFILLER_134_469 VGND VGND VPWR VPWR sky130_fd_sc_hd__decap_6
X_07026_ net613 net419 _04166_ VGND VGND VPWR VPWR _05812_ sky130_fd_sc_hd__a21oi_1
XFILLER_88_512 VGND VGND VPWR VPWR sky130_fd_sc_hd__decap_3
XTAP_TAPCELL_ROW_54_1044 VGND VPWR sky130_fd_sc_hd__tapvpwrvgnd_1
XFILLER_0_427 VGND VGND VPWR VPWR sky130_fd_sc_hd__decap_3
XTAP_TAPCELL_ROW_54_1055 VGND VPWR sky130_fd_sc_hd__tapvpwrvgnd_1
XFILLER_0_449 VGND VGND VPWR VPWR sky130_fd_sc_hd__fill_2
XFILLER_88_589 VPWR VGND VPWR VGND sky130_ef_sc_hd__decap_12
XFILLER_69_781 VGND VGND VPWR VPWR sky130_fd_sc_hd__decap_3
X_08977_ _01700_ _01701_ _01697_ VGND VGND VPWR VPWR _01703_ sky130_fd_sc_hd__a21o_1
X_07928_ net681 net476 VGND VGND VPWR VPWR _00666_ sky130_fd_sc_hd__nand2_1
XFILLER_29_634 VGND VGND VPWR VPWR sky130_fd_sc_hd__fill_1
X_07859_ _00448_ _00596_ VGND VGND VPWR VPWR _00597_ sky130_fd_sc_hd__xnor2_1
XFILLER_16_306 VGND VGND VPWR VPWR sky130_fd_sc_hd__fill_2
XFILLER_71_412 VGND VGND VPWR VPWR sky130_fd_sc_hd__decap_3
X_10870_ _03538_ _03555_ _03553_ VGND VGND VPWR VPWR _03733_ sky130_fd_sc_hd__o21ai_2
X_09529_ _02260_ _02275_ VGND VGND VPWR VPWR _02276_ sky130_fd_sc_hd__xnor2_1
XFILLER_43_169 VGND VGND VPWR VPWR sky130_fd_sc_hd__fill_2
XFILLER_12_512 VPWR VGND VPWR VGND sky130_ef_sc_hd__decap_12
X_12540_ net486 net478 net674 net672 VGND VGND VPWR VPWR _05553_ sky130_fd_sc_hd__and4_1
X_12471_ _05310_ _05475_ _05477_ VGND VGND VPWR VPWR _05478_ sky130_fd_sc_hd__and3_4
XFILLER_8_516 VPWR VGND VPWR VGND sky130_ef_sc_hd__decap_12
XFILLER_12_578 VGND VGND VPWR VPWR sky130_fd_sc_hd__fill_1
XFILLER_12_589 VGND VGND VPWR VPWR sky130_fd_sc_hd__decap_8
X_11422_ net250 net635 _04335_ VGND VGND VPWR VPWR _04336_ sky130_fd_sc_hd__and3_1
XFILLER_125_447 VGND VGND VPWR VPWR sky130_fd_sc_hd__fill_1
X_11353_ _04119_ _04122_ _04259_ VGND VGND VPWR VPWR _04261_ sky130_fd_sc_hd__or3_1
XFILLER_98_309 VGND VGND VPWR VPWR sky130_fd_sc_hd__fill_1
XFILLER_79_501 VGND VGND VPWR VPWR sky130_fd_sc_hd__decap_3
X_10304_ _03113_ _03114_ VGND VGND VPWR VPWR _03115_ sky130_fd_sc_hd__or2_1
XFILLER_4_755 VGND VGND VPWR VPWR sky130_fd_sc_hd__fill_1
X_11284_ _04074_ _04085_ _04073_ VGND VGND VPWR VPWR _04185_ sky130_fd_sc_hd__o21a_1
X_10235_ _02919_ _03039_ VGND VGND VPWR VPWR _03040_ sky130_fd_sc_hd__nor2_1
XFILLER_10_70 VPWR VGND VPWR VGND sky130_ef_sc_hd__decap_12
X_13023_ _05820_ _05949_ _05948_ VGND VGND VPWR VPWR _06081_ sky130_fd_sc_hd__a21oi_1
XFILLER_121_697 VGND VGND VPWR VPWR sky130_fd_sc_hd__decap_6
XFILLER_120_141 VPWR VGND VPWR VGND sky130_ef_sc_hd__decap_12
XFILLER_67_729 VGND VGND VPWR VPWR sky130_fd_sc_hd__fill_1
X_10166_ _02958_ _02961_ VGND VGND VPWR VPWR _02964_ sky130_fd_sc_hd__nor2_1
XFILLER_86_85 VPWR VGND VPWR VGND sky130_ef_sc_hd__decap_12
X_10097_ _02883_ _02887_ VGND VGND VPWR VPWR _02889_ sky130_fd_sc_hd__nand2_1
XFILLER_81_209 VGND VGND VPWR VPWR sky130_fd_sc_hd__decap_8
XFILLER_47_442 VGND VGND VPWR VPWR sky130_fd_sc_hd__decap_6
XFILLER_62_401 VPWR VGND VPWR VGND sky130_ef_sc_hd__decap_12
XFILLER_19_166 VGND VGND VPWR VPWR sky130_fd_sc_hd__fill_2
XFILLER_35_637 VGND VGND VPWR VPWR sky130_fd_sc_hd__decap_6
XFILLER_74_294 VGND VGND VPWR VPWR sky130_fd_sc_hd__fill_2
XFILLER_62_445 VPWR VGND VPWR VGND sky130_ef_sc_hd__decap_12
X_12807_ _05715_ _05725_ _05723_ VGND VGND VPWR VPWR _05845_ sky130_fd_sc_hd__a21boi_1
XFILLER_50_629 VPWR VGND VPWR VGND sky130_ef_sc_hd__decap_12
XFILLER_43_670 VGND VGND VPWR VPWR sky130_fd_sc_hd__fill_2
X_10999_ _03872_ _03873_ VGND VGND VPWR VPWR _03874_ sky130_fd_sc_hd__xor2_1
X_12738_ _05767_ _05769_ VGND VGND VPWR VPWR _05770_ sky130_fd_sc_hd__and2b_1
XFILLER_30_331 VGND VGND VPWR VPWR sky130_fd_sc_hd__decap_8
X_12669_ _05689_ _05692_ VGND VGND VPWR VPWR _05694_ sky130_fd_sc_hd__xnor2_1
XFILLER_129_753 VPWR VGND VPWR VGND sky130_ef_sc_hd__decap_12
XFILLER_30_397 VGND VGND VPWR VPWR sky130_fd_sc_hd__decap_8
XTAP_TAPCELL_ROW_41_871 VGND VPWR sky130_fd_sc_hd__tapvpwrvgnd_1
XFILLER_129_797 VPWR VGND VPWR VGND sky130_ef_sc_hd__decap_12
XTAP_TAPCELL_ROW_96_1634 VGND VPWR sky130_fd_sc_hd__tapvpwrvgnd_1
XFILLER_128_285 VGND VGND VPWR VPWR sky130_fd_sc_hd__decap_4
XTAP_TAPCELL_ROW_96_1645 VGND VPWR sky130_fd_sc_hd__tapvpwrvgnd_1
Xmax_cap235 _04801_ VGND VGND VPWR VPWR net235 sky130_fd_sc_hd__clkbuf_2
XFILLER_116_469 VGND VGND VPWR VPWR sky130_fd_sc_hd__decap_6
Xmax_cap246 _03811_ VGND VGND VPWR VPWR net246 sky130_fd_sc_hd__buf_1
XFILLER_131_417 VGND VGND VPWR VPWR sky130_fd_sc_hd__decap_6
X_08900_ _01618_ _01625_ VGND VGND VPWR VPWR _01626_ sky130_fd_sc_hd__nand2_1
X_09880_ _01825_ _02656_ VGND VGND VPWR VPWR _02657_ sky130_fd_sc_hd__xnor2_1
XFILLER_112_642 VGND VGND VPWR VPWR sky130_fd_sc_hd__fill_2
XFILLER_106_29 VGND VGND VPWR VPWR sky130_fd_sc_hd__decap_4
X_08831_ _01555_ _01554_ _01556_ VGND VGND VPWR VPWR _01558_ sky130_fd_sc_hd__a21o_1
X_08762_ _01452_ _01487_ VGND VGND VPWR VPWR _01489_ sky130_fd_sc_hd__xnor2_1
XFILLER_85_559 VGND VGND VPWR VPWR sky130_fd_sc_hd__fill_1
X_07713_ _00295_ _00298_ _00294_ VGND VGND VPWR VPWR _00452_ sky130_fd_sc_hd__a21oi_1
XTAP_TAPCELL_ROW_123_2019 VGND VPWR sky130_fd_sc_hd__tapvpwrvgnd_1
X_08693_ _01412_ _01419_ _01420_ VGND VGND VPWR VPWR _01421_ sky130_fd_sc_hd__nand3_1
XFILLER_66_762 VGND VGND VPWR VPWR sky130_fd_sc_hd__decap_4
XFILLER_38_453 VPWR VGND VPWR VGND sky130_ef_sc_hd__decap_12
X_07644_ _02033_ net707 _00230_ VGND VGND VPWR VPWR _00384_ sky130_fd_sc_hd__or3_1
XFILLER_53_401 VGND VGND VPWR VPWR sky130_fd_sc_hd__decap_3
XTAP_TAPCELL_ROW_49_982 VGND VPWR sky130_fd_sc_hd__tapvpwrvgnd_1
XFILLER_26_637 VGND VGND VPWR VPWR sky130_fd_sc_hd__decap_6
XFILLER_53_467 VGND VGND VPWR VPWR sky130_fd_sc_hd__fill_2
XTAP_TAPCELL_ROW_0_279 VGND VPWR sky130_fd_sc_hd__tapvpwrvgnd_1
X_07575_ _00306_ _00313_ VGND VGND VPWR VPWR _00315_ sky130_fd_sc_hd__xor2_1
XTAP_TAPCELL_ROW_105_1763 VGND VPWR sky130_fd_sc_hd__tapvpwrvgnd_1
XFILLER_25_169 VPWR VGND VPWR VGND sky130_ef_sc_hd__decap_12
XFILLER_40_117 VGND VGND VPWR VPWR sky130_fd_sc_hd__fill_1
X_09314_ net784 net325 VGND VGND VPWR VPWR _02041_ sky130_fd_sc_hd__nand2_1
XFILLER_34_681 VPWR VGND VPWR VGND sky130_ef_sc_hd__decap_12
XFILLER_40_139 VGND VGND VPWR VPWR sky130_fd_sc_hd__fill_1
X_09245_ net501 net626 net625 net510 VGND VGND VPWR VPWR _01969_ sky130_fd_sc_hd__a22o_1
XFILLER_119_241 VGND VGND VPWR VPWR sky130_fd_sc_hd__fill_2
X_09176_ _01802_ net846 _01899_ VGND VGND VPWR VPWR _01901_ sky130_fd_sc_hd__nand3_1
X_08127_ net679 net678 net476 VGND VGND VPWR VPWR _00863_ sky130_fd_sc_hd__and3_1
XFILLER_134_233 VPWR VGND VPWR VGND sky130_ef_sc_hd__decap_12
X_08058_ _00660_ _00664_ net249 VGND VGND VPWR VPWR _00795_ sky130_fd_sc_hd__o21ai_1
XFILLER_134_277 VGND VGND VPWR VPWR sky130_fd_sc_hd__decap_4
XFILLER_122_428 VPWR VGND VPWR VGND sky130_ef_sc_hd__decap_12
XFILLER_122_417 VGND VGND VPWR VPWR sky130_fd_sc_hd__decap_3
X_07009_ _05604_ _05615_ VGND VGND VPWR VPWR _05626_ sky130_fd_sc_hd__or2_4
X_10020_ _02799_ _02805_ VGND VGND VPWR VPWR _02806_ sky130_fd_sc_hd__nand2_1
Xinput103 w20[5] VGND VGND VPWR VPWR net103 sky130_fd_sc_hd__buf_1
XFILLER_102_141 VPWR VGND VPWR VGND sky130_ef_sc_hd__decap_12
Xinput125 w23[3] VGND VGND VPWR VPWR net125 sky130_fd_sc_hd__buf_1
Xinput136 w30[6] VGND VGND VPWR VPWR net136 sky130_fd_sc_hd__clkbuf_2
Xinput114 w22[0] VGND VGND VPWR VPWR net114 sky130_fd_sc_hd__buf_1
Xinput158 w33[4] VGND VGND VPWR VPWR net158 sky130_fd_sc_hd__buf_1
Xinput147 w32[1] VGND VGND VPWR VPWR net147 sky130_fd_sc_hd__buf_1
XFILLER_48_228 VGND VGND VPWR VPWR sky130_fd_sc_hd__decap_4
X_11971_ _04930_ _04931_ VGND VGND VPWR VPWR _04932_ sky130_fd_sc_hd__or2_1
XFILLER_29_464 VGND VGND VPWR VPWR sky130_fd_sc_hd__decap_8
XFILLER_56_250 VGND VGND VPWR VPWR sky130_fd_sc_hd__fill_2
XFILLER_56_77 VGND VGND VPWR VPWR sky130_fd_sc_hd__fill_1
XFILLER_17_615 VGND VGND VPWR VPWR sky130_fd_sc_hd__fill_1
XFILLER_17_626 VGND VGND VPWR VPWR sky130_fd_sc_hd__fill_1
X_10922_ _03788_ _03789_ VGND VGND VPWR VPWR _03790_ sky130_fd_sc_hd__nor2_1
XTAP_TAPCELL_ROW_67_1235 VGND VPWR sky130_fd_sc_hd__tapvpwrvgnd_1
XFILLER_44_456 VGND VGND VPWR VPWR sky130_fd_sc_hd__fill_2
XFILLER_112_83 VGND VGND VPWR VPWR sky130_fd_sc_hd__fill_1
XFILLER_44_489 VPWR VGND VPWR VGND sky130_ef_sc_hd__decap_12
XTAP_TAPCELL_ROW_27_676 VGND VPWR sky130_fd_sc_hd__tapvpwrvgnd_1
XFILLER_32_618 VGND VGND VPWR VPWR sky130_fd_sc_hd__decap_4
X_10853_ _03528_ _03530_ _03712_ VGND VGND VPWR VPWR _03714_ sky130_fd_sc_hd__and3_1
XTAP_TAPCELL_ROW_80_1413 VGND VPWR sky130_fd_sc_hd__tapvpwrvgnd_1
X_10784_ _03635_ _03636_ _03637_ VGND VGND VPWR VPWR _03639_ sky130_fd_sc_hd__nand3_1
XFILLER_12_353 VGND VGND VPWR VPWR sky130_fd_sc_hd__decap_8
X_12523_ _05532_ _05533_ VGND VGND VPWR VPWR _05534_ sky130_fd_sc_hd__nand2_1
XFILLER_126_701 VPWR VGND VPWR VGND sky130_ef_sc_hd__decap_12
XFILLER_8_357 VGND VGND VPWR VPWR sky130_fd_sc_hd__decap_6
X_12454_ _05456_ _05457_ _05272_ _05274_ VGND VGND VPWR VPWR _05459_ sky130_fd_sc_hd__a211oi_2
X_11405_ _04194_ _04316_ VGND VGND VPWR VPWR _04317_ sky130_fd_sc_hd__nor2_1
X_12385_ net421 net588 _05229_ _05227_ VGND VGND VPWR VPWR _05383_ sky130_fd_sc_hd__a31o_1
XTAP_TAPCELL_ROW_78_1386 VGND VPWR sky130_fd_sc_hd__tapvpwrvgnd_1
X_11336_ _04240_ _04241_ VGND VGND VPWR VPWR _04242_ sky130_fd_sc_hd__or2_1
XFILLER_98_139 VGND VGND VPWR VPWR sky130_fd_sc_hd__fill_1
XTAP_TAPCELL_ROW_91_1575 VGND VPWR sky130_fd_sc_hd__tapvpwrvgnd_1
XTAP_TAPCELL_ROW_91_1564 VGND VPWR sky130_fd_sc_hd__tapvpwrvgnd_1
X_11267_ _04069_ _04165_ VGND VGND VPWR VPWR _04167_ sky130_fd_sc_hd__nor2_1
X_13006_ _06057_ _06061_ VGND VGND VPWR VPWR _06062_ sky130_fd_sc_hd__nand2_1
X_10218_ _02942_ _03018_ _03019_ VGND VGND VPWR VPWR _03022_ sky130_fd_sc_hd__or3_4
X_11198_ _03955_ _03964_ _03963_ VGND VGND VPWR VPWR _04092_ sky130_fd_sc_hd__a21o_1
XFILLER_67_559 VGND VGND VPWR VPWR sky130_fd_sc_hd__fill_1
X_10149_ net450 net442 net578 net575 VGND VGND VPWR VPWR _02946_ sky130_fd_sc_hd__and4_1
XTAP_TAPCELL_ROW_7_390 VGND VPWR sky130_fd_sc_hd__tapvpwrvgnd_1
XFILLER_54_209 VPWR VGND VPWR VGND sky130_ef_sc_hd__decap_12
XFILLER_75_592 VGND VGND VPWR VPWR sky130_fd_sc_hd__fill_1
XFILLER_63_743 VPWR VGND VPWR VGND sky130_ef_sc_hd__decap_12
XTAP_TAPCELL_ROW_46_941 VGND VPWR sky130_fd_sc_hd__tapvpwrvgnd_1
XFILLER_62_253 VPWR VGND VPWR VGND sky130_ef_sc_hd__decap_12
X_07360_ _06648_ _06649_ VGND VGND VPWR VPWR _06651_ sky130_fd_sc_hd__xor2_1
XFILLER_62_286 VPWR VGND VPWR VGND sky130_ef_sc_hd__decap_12
XFILLER_22_117 VGND VGND VPWR VPWR sky130_fd_sc_hd__decap_4
XFILLER_22_128 VPWR VGND VPWR VGND sky130_ef_sc_hd__decap_12
X_07291_ _06552_ _06580_ _06581_ VGND VGND VPWR VPWR _06582_ sky130_fd_sc_hd__and3_1
X_09030_ _01639_ _01673_ _01671_ VGND VGND VPWR VPWR _01755_ sky130_fd_sc_hd__o21ba_1
XFILLER_129_561 VPWR VGND VPWR VGND sky130_ef_sc_hd__decap_12
XTAP_TAPCELL_ROW_100_1693 VGND VPWR sky130_fd_sc_hd__tapvpwrvgnd_1
XFILLER_117_723 VGND VGND VPWR VPWR sky130_fd_sc_hd__decap_4
XFILLER_7_82 VPWR VGND VPWR VGND sky130_ef_sc_hd__decap_12
XFILLER_117_756 VPWR VGND VPWR VGND sky130_ef_sc_hd__decap_12
XFILLER_132_737 VPWR VGND VPWR VGND sky130_ef_sc_hd__decap_12
X_09932_ _02451_ _02587_ _02586_ VGND VGND VPWR VPWR _02714_ sky130_fd_sc_hd__a21o_1
XFILLER_117_39 VPWR VGND VPWR VGND sky130_ef_sc_hd__decap_12
XFILLER_131_247 VGND VGND VPWR VPWR sky130_fd_sc_hd__fill_2
XFILLER_98_651 VGND VGND VPWR VPWR sky130_fd_sc_hd__decap_8
XFILLER_131_258 VGND VGND VPWR VPWR sky130_fd_sc_hd__decap_6
X_09863_ _02203_ _02530_ VGND VGND VPWR VPWR _02638_ sky130_fd_sc_hd__nand2_1
XTAP_TAPCELL_ROW_51_1014 VGND VPWR sky130_fd_sc_hd__tapvpwrvgnd_1
XTAP_TAPCELL_ROW_51_1003 VGND VPWR sky130_fd_sc_hd__tapvpwrvgnd_1
XFILLER_133_27 VPWR VGND VPWR VGND sky130_ef_sc_hd__decap_12
XFILLER_112_483 VGND VGND VPWR VPWR sky130_fd_sc_hd__decap_8
XFILLER_100_645 VPWR VGND VPWR VGND sky130_ef_sc_hd__decap_12
XFILLER_97_194 VPWR VGND VPWR VGND sky130_ef_sc_hd__decap_12
X_09794_ _02429_ _02432_ _02434_ VGND VGND VPWR VPWR _02563_ sky130_fd_sc_hd__a21oi_1
X_08814_ net414 net557 net325 net699 VGND VGND VPWR VPWR _01541_ sky130_fd_sc_hd__a22oi_1
X_08745_ net573 net264 net262 net597 VGND VGND VPWR VPWR _01472_ sky130_fd_sc_hd__a22o_1
XFILLER_39_740 VGND VGND VPWR VPWR sky130_fd_sc_hd__decap_8
XFILLER_73_529 VGND VGND VPWR VPWR sky130_fd_sc_hd__fill_2
XFILLER_38_272 VGND VGND VPWR VPWR sky130_fd_sc_hd__fill_1
X_08676_ _01242_ _01244_ _01402_ VGND VGND VPWR VPWR _01404_ sky130_fd_sc_hd__nor3_1
XFILLER_26_456 VGND VGND VPWR VPWR sky130_fd_sc_hd__decap_3
X_07627_ net612 net609 net402 VGND VGND VPWR VPWR _00367_ sky130_fd_sc_hd__o21ai_1
XFILLER_53_264 VGND VGND VPWR VPWR sky130_fd_sc_hd__decap_6
XFILLER_41_415 VPWR VGND VPWR VGND sky130_ef_sc_hd__decap_12
X_07558_ _00296_ _00297_ VGND VGND VPWR VPWR _00298_ sky130_fd_sc_hd__nor2_1
XFILLER_81_595 VGND VGND VPWR VPWR sky130_fd_sc_hd__fill_1
XTAP_TAPCELL_ROW_24_624 VGND VPWR sky130_fd_sc_hd__tapvpwrvgnd_1
XTAP_TAPCELL_ROW_24_635 VGND VPWR sky130_fd_sc_hd__tapvpwrvgnd_1
X_07489_ net391 net389 net288 VGND VGND VPWR VPWR _00230_ sky130_fd_sc_hd__o21ai_1
XTAP_TAPCELL_ROW_62_1165 VGND VPWR sky130_fd_sc_hd__tapvpwrvgnd_1
XFILLER_108_701 VPWR VGND VPWR VGND sky130_ef_sc_hd__decap_12
X_09228_ _01945_ _01951_ VGND VGND VPWR VPWR _01952_ sky130_fd_sc_hd__and2b_1
XTAP_TAPCELL_ROW_118_1943 VGND VPWR sky130_fd_sc_hd__tapvpwrvgnd_1
X_09159_ _01879_ _01880_ _01881_ VGND VGND VPWR VPWR _01884_ sky130_fd_sc_hd__a21o_1
XFILLER_5_305 VPWR VGND VPWR VGND sky130_ef_sc_hd__decap_12
XFILLER_135_553 VGND VGND VPWR VPWR sky130_fd_sc_hd__decap_6
XFILLER_107_233 VGND VGND VPWR VPWR sky130_fd_sc_hd__fill_2
XFILLER_107_222 VGND VGND VPWR VPWR sky130_fd_sc_hd__fill_2
XFILLER_5_349 VPWR VGND VPWR VGND sky130_ef_sc_hd__decap_12
X_12170_ net541 net302 VGND VGND VPWR VPWR _05148_ sky130_fd_sc_hd__nand2_1
XFILLER_135_597 VPWR VGND VPWR VGND sky130_ef_sc_hd__decap_12
XFILLER_107_277 VGND VGND VPWR VPWR sky130_fd_sc_hd__decap_3
X_11121_ _03695_ _03847_ _03846_ VGND VGND VPWR VPWR _04008_ sky130_fd_sc_hd__a21boi_2
XFILLER_107_83 VGND VGND VPWR VPWR sky130_fd_sc_hd__decap_8
XFILLER_107_61 VGND VGND VPWR VPWR sky130_fd_sc_hd__fill_1
XFILLER_89_673 VPWR VGND VPWR VGND sky130_ef_sc_hd__decap_12
X_11052_ _03928_ _03931_ VGND VGND VPWR VPWR _03932_ sky130_fd_sc_hd__and2b_1
XFILLER_130_280 VGND VGND VPWR VPWR sky130_fd_sc_hd__decap_6
XFILLER_107_94 VPWR VGND VPWR VGND sky130_ef_sc_hd__decap_12
XFILLER_76_334 VGND VGND VPWR VPWR sky130_fd_sc_hd__decap_4
X_10003_ _02784_ _02785_ _02786_ VGND VGND VPWR VPWR _02788_ sky130_fd_sc_hd__o21ai_1
XFILLER_91_315 VGND VGND VPWR VPWR sky130_fd_sc_hd__fill_1
XFILLER_45_721 VGND VGND VPWR VPWR sky130_fd_sc_hd__fill_1
XFILLER_29_272 VGND VGND VPWR VPWR sky130_fd_sc_hd__fill_1
XFILLER_91_337 VGND VGND VPWR VPWR sky130_fd_sc_hd__decap_8
XFILLER_83_53 VGND VGND VPWR VPWR sky130_fd_sc_hd__decap_3
XFILLER_57_592 VPWR VGND VPWR VGND sky130_ef_sc_hd__decap_12
X_11954_ net463 net585 net583 net471 VGND VGND VPWR VPWR _04913_ sky130_fd_sc_hd__a22oi_1
XFILLER_83_86 VGND VGND VPWR VPWR sky130_fd_sc_hd__decap_6
XFILLER_72_573 VGND VGND VPWR VPWR sky130_fd_sc_hd__decap_6
X_11885_ _04837_ _04836_ _04834_ VGND VGND VPWR VPWR _04838_ sky130_fd_sc_hd__and3_4
XFILLER_44_253 VGND VGND VPWR VPWR sky130_fd_sc_hd__fill_2
XTAP_TAPCELL_ROW_43_900 VGND VPWR sky130_fd_sc_hd__tapvpwrvgnd_1
XFILLER_17_478 VGND VGND VPWR VPWR sky130_fd_sc_hd__decap_8
X_10905_ _03583_ _03593_ _03592_ VGND VGND VPWR VPWR _03771_ sky130_fd_sc_hd__a21oi_1
XFILLER_60_757 VPWR VGND VPWR VGND sky130_ef_sc_hd__decap_12
X_10836_ _03516_ _03694_ VGND VGND VPWR VPWR _03695_ sky130_fd_sc_hd__xor2_2
XFILLER_13_662 VGND VGND VPWR VPWR sky130_fd_sc_hd__fill_1
XFILLER_12_172 VPWR VGND VPWR VGND sky130_ef_sc_hd__decap_12
XFILLER_13_673 VPWR VGND VPWR VGND sky130_ef_sc_hd__decap_12
X_10767_ _03604_ _03618_ _03619_ VGND VGND VPWR VPWR _03621_ sky130_fd_sc_hd__and3_1
XFILLER_118_509 VGND VGND VPWR VPWR sky130_fd_sc_hd__fill_1
X_10698_ net539 _03542_ _03544_ net279 net566 VGND VGND VPWR VPWR _03545_ sky130_fd_sc_hd__a32o_1
X_12506_ _05514_ VGND VGND VPWR VPWR _05515_ sky130_fd_sc_hd__inv_2
X_12437_ _05437_ _05438_ _05439_ VGND VGND VPWR VPWR _05441_ sky130_fd_sc_hd__nand3_1
XFILLER_126_531 VGND VGND VPWR VPWR sky130_fd_sc_hd__fill_1
XFILLER_126_564 VGND VGND VPWR VPWR sky130_fd_sc_hd__decap_4
X_12368_ _05215_ _05217_ VGND VGND VPWR VPWR _05365_ sky130_fd_sc_hd__nand2_1
XFILLER_113_225 VPWR VGND VPWR VGND sky130_ef_sc_hd__decap_12
X_12299_ _05286_ _05288_ VGND VGND VPWR VPWR _05290_ sky130_fd_sc_hd__xor2_1
X_11319_ _04216_ _04222_ VGND VGND VPWR VPWR _04224_ sky130_fd_sc_hd__xor2_1
XFILLER_86_109 VGND VGND VPWR VPWR sky130_fd_sc_hd__decap_8
XFILLER_122_781 VGND VGND VPWR VPWR sky130_fd_sc_hd__decap_8
XFILLER_95_610 VGND VGND VPWR VPWR sky130_fd_sc_hd__fill_1
X_06860_ net611 net453 net610 net460 VGND VGND VPWR VPWR _04003_ sky130_fd_sc_hd__a22oi_1
XFILLER_79_194 VGND VGND VPWR VPWR sky130_fd_sc_hd__fill_2
XTAP_TAPCELL_ROW_2_319 VGND VPWR sky130_fd_sc_hd__tapvpwrvgnd_1
X_06791_ net532 net527 net685 net682 VGND VGND VPWR VPWR _03248_ sky130_fd_sc_hd__and4_1
XFILLER_82_304 VGND VGND VPWR VPWR sky130_fd_sc_hd__decap_4
XFILLER_67_389 VGND VGND VPWR VPWR sky130_fd_sc_hd__decap_3
X_08530_ net794 net340 net339 net735 VGND VGND VPWR VPWR _01259_ sky130_fd_sc_hd__a22oi_2
X_08461_ _01185_ _01188_ _01184_ VGND VGND VPWR VPWR _01190_ sky130_fd_sc_hd__o21a_1
XFILLER_51_713 VPWR VGND VPWR VGND sky130_ef_sc_hd__decap_12
XFILLER_36_798 VGND VGND VPWR VPWR sky130_fd_sc_hd__decap_4
X_07412_ _00149_ _00151_ VGND VGND VPWR VPWR _00153_ sky130_fd_sc_hd__xor2_1
XTAP_TAPCELL_ROW_102_1722 VGND VPWR sky130_fd_sc_hd__tapvpwrvgnd_1
XFILLER_90_381 VGND VGND VPWR VPWR sky130_fd_sc_hd__fill_2
XFILLER_63_584 VGND VGND VPWR VPWR sky130_fd_sc_hd__fill_1
XFILLER_51_757 VGND VGND VPWR VPWR sky130_fd_sc_hd__fill_1
X_08392_ _01121_ _01122_ VGND VGND VPWR VPWR _00010_ sky130_fd_sc_hd__nor2_1
XFILLER_50_245 VGND VGND VPWR VPWR sky130_fd_sc_hd__decap_6
X_07343_ _06458_ _06476_ _06475_ VGND VGND VPWR VPWR _06634_ sky130_fd_sc_hd__a21boi_1
XFILLER_109_509 VGND VGND VPWR VPWR sky130_fd_sc_hd__fill_1
X_07274_ _06562_ _06563_ VGND VGND VPWR VPWR _06565_ sky130_fd_sc_hd__xnor2_1
XFILLER_12_27 VGND VGND VPWR VPWR sky130_fd_sc_hd__fill_1
XFILLER_31_492 VPWR VGND VPWR VGND sky130_ef_sc_hd__decap_12
XFILLER_136_328 VGND VGND VPWR VPWR sky130_fd_sc_hd__decap_4
XFILLER_128_27 VGND VGND VPWR VPWR sky130_fd_sc_hd__fill_1
X_09013_ _01737_ _01738_ VGND VGND VPWR VPWR _01739_ sky130_fd_sc_hd__or2_1
XTAP_TAPCELL_ROW_131_2129 VGND VPWR sky130_fd_sc_hd__tapvpwrvgnd_1
XFILLER_3_809 VGND VGND VPWR VPWR sky130_fd_sc_hd__fill_2
XFILLER_132_501 VPWR VGND VPWR VGND sky130_ef_sc_hd__decap_12
XFILLER_105_726 VGND VGND VPWR VPWR sky130_fd_sc_hd__fill_2
XFILLER_132_545 VPWR VGND VPWR VGND sky130_ef_sc_hd__decap_12
XFILLER_104_225 VGND VGND VPWR VPWR sky130_fd_sc_hd__decap_8
XFILLER_132_589 VPWR VGND VPWR VGND sky130_ef_sc_hd__decap_12
Xfanout623 net13 VGND VGND VPWR VPWR net623 sky130_fd_sc_hd__clkbuf_8
XTAP_TAPCELL_ROW_113_1873 VGND VPWR sky130_fd_sc_hd__tapvpwrvgnd_1
X_09915_ _02333_ _02550_ _02693_ VGND VGND VPWR VPWR _02695_ sky130_fd_sc_hd__or3b_1
Xfanout612 net131 VGND VGND VPWR VPWR net612 sky130_fd_sc_hd__buf_2
Xfanout601 net138 VGND VGND VPWR VPWR net601 sky130_fd_sc_hd__buf_2
Xfanout667 net668 VGND VGND VPWR VPWR net667 sky130_fd_sc_hd__buf_2
Xfanout645 net646 VGND VGND VPWR VPWR net645 sky130_fd_sc_hd__buf_1
X_09846_ _02376_ _02488_ _02487_ VGND VGND VPWR VPWR _02620_ sky130_fd_sc_hd__o21ba_1
Xfanout634 net122 VGND VGND VPWR VPWR net634 sky130_fd_sc_hd__clkbuf_4
Xfanout656 net114 VGND VGND VPWR VPWR net656 sky130_fd_sc_hd__buf_1
XPHY_EDGE_ROW_13_Left_150 VGND VGND VPWR VPWR sky130_fd_sc_hd__decap_3
Xfanout689 net10 VGND VGND VPWR VPWR net689 sky130_fd_sc_hd__buf_2
Xfanout678 net104 VGND VGND VPWR VPWR net678 sky130_fd_sc_hd__buf_2
XFILLER_74_805 VGND VGND VPWR VPWR sky130_fd_sc_hd__fill_2
X_06989_ net522 net685 net506 net683 VGND VGND VPWR VPWR _05407_ sky130_fd_sc_hd__and4_1
X_09777_ net626 net625 net479 VGND VGND VPWR VPWR _02545_ sky130_fd_sc_hd__o21ai_1
XFILLER_27_710 VGND VGND VPWR VPWR sky130_fd_sc_hd__fill_1
XTAP_TAPCELL_ROW_29_705 VGND VPWR sky130_fd_sc_hd__tapvpwrvgnd_1
XFILLER_37_57 VPWR VGND VPWR VGND sky130_ef_sc_hd__decap_12
X_08728_ net669 net644 net259 net257 VGND VGND VPWR VPWR _01455_ sky130_fd_sc_hd__and4_1
X_08659_ _01386_ _01366_ VGND VGND VPWR VPWR _01387_ sky130_fd_sc_hd__and2b_1
XFILLER_26_297 VGND VGND VPWR VPWR sky130_fd_sc_hd__fill_1
XFILLER_42_724 VPWR VGND VPWR VGND sky130_ef_sc_hd__decap_12
X_11670_ _04577_ _04602_ VGND VGND VPWR VPWR _04604_ sky130_fd_sc_hd__nand2b_1
XFILLER_41_245 VGND VGND VPWR VPWR sky130_fd_sc_hd__decap_3
XFILLER_42_757 VPWR VGND VPWR VGND sky130_ef_sc_hd__decap_12
X_10621_ net311 net350 _03459_ _03460_ VGND VGND VPWR VPWR _03461_ sky130_fd_sc_hd__o2bb2a_1
X_13340_ net398 VGND VGND VPWR VPWR _00114_ sky130_fd_sc_hd__inv_2
X_10552_ _02874_ _02931_ _03102_ _03245_ _03249_ VGND VGND VPWR VPWR _03385_ sky130_fd_sc_hd__o41a_1
XFILLER_10_643 VGND VGND VPWR VPWR sky130_fd_sc_hd__fill_1
XFILLER_22_481 VGND VGND VPWR VPWR sky130_fd_sc_hd__fill_1
XFILLER_108_520 VPWR VGND VPWR VGND sky130_ef_sc_hd__decap_12
Xrebuffer240 _04352_ VGND VGND VPWR VPWR net940 sky130_fd_sc_hd__dlymetal6s2s_1
XFILLER_6_625 VPWR VGND VPWR VGND sky130_ef_sc_hd__decap_12
XFILLER_5_113 VPWR VGND VPWR VGND sky130_ef_sc_hd__decap_12
X_13271_ _05525_ _06011_ VGND VGND VPWR VPWR _06350_ sky130_fd_sc_hd__xnor2_1
X_10483_ _03307_ _03308_ _03277_ VGND VGND VPWR VPWR _03310_ sky130_fd_sc_hd__a21o_1
XFILLER_6_669 VPWR VGND VPWR VGND sky130_ef_sc_hd__decap_12
X_12222_ net437 net141 net586 net446 VGND VGND VPWR VPWR _05205_ sky130_fd_sc_hd__a22o_1
XFILLER_135_361 VPWR VGND VPWR VGND sky130_ef_sc_hd__decap_12
XFILLER_108_586 VGND VGND VPWR VPWR sky130_fd_sc_hd__fill_2
XTAP_TAPCELL_ROW_75_1345 VGND VPWR sky130_fd_sc_hd__tapvpwrvgnd_1
XFILLER_118_93 VPWR VGND VPWR VGND sky130_ef_sc_hd__decap_12
X_12153_ _04980_ _04853_ _04979_ _04847_ _05129_ VGND VGND VPWR VPWR _05130_ sky130_fd_sc_hd__a41o_1
XFILLER_111_729 VPWR VGND VPWR VGND sky130_ef_sc_hd__decap_12
X_12084_ _04915_ _04924_ _04923_ VGND VGND VPWR VPWR _05055_ sky130_fd_sc_hd__o21ba_1
X_11104_ _03972_ _03988_ VGND VGND VPWR VPWR _03989_ sky130_fd_sc_hd__nor2_1
XFILLER_104_792 VPWR VGND VPWR VGND sky130_ef_sc_hd__decap_12
XFILLER_104_770 VGND VGND VPWR VPWR sky130_fd_sc_hd__decap_8
XFILLER_78_97 VGND VGND VPWR VPWR sky130_fd_sc_hd__fill_2
X_11035_ net503 net121 VGND VGND VPWR VPWR _03913_ sky130_fd_sc_hd__and2b_1
XFILLER_91_123 VGND VGND VPWR VPWR sky130_fd_sc_hd__decap_8
XFILLER_76_197 VGND VGND VPWR VPWR sky130_fd_sc_hd__decap_8
X_12986_ _05906_ _05937_ _05936_ VGND VGND VPWR VPWR _06040_ sky130_fd_sc_hd__a21o_1
XFILLER_91_167 VGND VGND VPWR VPWR sky130_fd_sc_hd__fill_1
XFILLER_17_264 VPWR VGND VPWR VGND sky130_ef_sc_hd__decap_12
XFILLER_18_765 VGND VGND VPWR VPWR sky130_fd_sc_hd__decap_4
XFILLER_33_702 VGND VGND VPWR VPWR sky130_fd_sc_hd__fill_1
XFILLER_91_189 VGND VGND VPWR VPWR sky130_fd_sc_hd__fill_2
XTAP_TAPCELL_ROW_86_1496 VGND VPWR sky130_fd_sc_hd__tapvpwrvgnd_1
X_11937_ _04714_ _04716_ _04715_ VGND VGND VPWR VPWR _04895_ sky130_fd_sc_hd__o21bai_1
XFILLER_32_212 VGND VGND VPWR VPWR sky130_fd_sc_hd__decap_4
X_11868_ _04811_ _04817_ _04819_ VGND VGND VPWR VPWR _04820_ sky130_fd_sc_hd__and3_4
X_11799_ net463 net454 net598 net589 VGND VGND VPWR VPWR _04744_ sky130_fd_sc_hd__and4_1
X_10819_ _03674_ _03673_ _03490_ _03492_ VGND VGND VPWR VPWR _03678_ sky130_fd_sc_hd__a211o_1
XFILLER_9_452 VPWR VGND VPWR VGND sky130_ef_sc_hd__decap_12
XTAP_TAPCELL_ROW_15_498 VGND VPWR sky130_fd_sc_hd__tapvpwrvgnd_1
XFILLER_118_339 VGND VGND VPWR VPWR sky130_fd_sc_hd__fill_2
XFILLER_118_328 VGND VGND VPWR VPWR sky130_fd_sc_hd__fill_1
XFILLER_9_485 VGND VGND VPWR VPWR sky130_fd_sc_hd__decap_8
Xoutput215 net215 VGND VGND VPWR VPWR out3[14] sky130_fd_sc_hd__buf_2
Xoutput204 net204 VGND VGND VPWR VPWR out2[4] sky130_fd_sc_hd__buf_2
X_07961_ _00697_ _00698_ VGND VGND VPWR VPWR _00699_ sky130_fd_sc_hd__nor2_1
XFILLER_114_567 VPWR VGND VPWR VGND sky130_ef_sc_hd__decap_12
X_09700_ _02247_ _02255_ _02460_ VGND VGND VPWR VPWR _02461_ sky130_fd_sc_hd__a21o_1
XFILLER_114_589 VPWR VGND VPWR VGND sky130_ef_sc_hd__decap_12
X_06912_ _04526_ _04145_ _04548_ VGND VGND VPWR VPWR _04570_ sky130_fd_sc_hd__or3_4
XFILLER_4_83 VGND VGND VPWR VPWR sky130_fd_sc_hd__fill_1
XFILLER_114_29 VPWR VGND VPWR VGND sky130_ef_sc_hd__decap_12
X_07892_ _00627_ _00628_ VGND VGND VPWR VPWR _00630_ sky130_fd_sc_hd__xnor2_1
XFILLER_56_805 VGND VGND VPWR VPWR sky130_fd_sc_hd__fill_2
XTAP_TAPCELL_ROW_128_2080 VGND VPWR sky130_fd_sc_hd__tapvpwrvgnd_1
X_06843_ net99 net497 VGND VGND VPWR VPWR _03817_ sky130_fd_sc_hd__nand2_2
XFILLER_95_473 VGND VGND VPWR VPWR sky130_fd_sc_hd__fill_2
XFILLER_83_602 VPWR VGND VPWR VGND sky130_ef_sc_hd__decap_12
X_09631_ net314 net325 _02208_ net336 VGND VGND VPWR VPWR _02386_ sky130_fd_sc_hd__o2bb2a_1
XFILLER_67_153 VGND VGND VPWR VPWR sky130_fd_sc_hd__decap_3
XTAP_TAPCELL_ROW_128_2091 VGND VPWR sky130_fd_sc_hd__tapvpwrvgnd_1
X_06774_ net687 net321 net667 net323 VGND VGND VPWR VPWR _03063_ sky130_fd_sc_hd__a22o_1
X_09562_ net415 _02310_ _02309_ VGND VGND VPWR VPWR _02311_ sky130_fd_sc_hd__a21oi_2
XFILLER_83_635 VGND VGND VPWR VPWR sky130_fd_sc_hd__fill_1
X_08513_ _01241_ _01237_ VGND VGND VPWR VPWR _01242_ sky130_fd_sc_hd__and2b_1
X_09493_ _02124_ _02126_ _02235_ VGND VGND VPWR VPWR _02236_ sky130_fd_sc_hd__a21oi_1
XFILLER_70_329 VPWR VGND VPWR VGND sky130_ef_sc_hd__decap_12
X_08444_ _01171_ _01172_ VGND VGND VPWR VPWR _01173_ sky130_fd_sc_hd__xor2_1
XFILLER_24_757 VGND VGND VPWR VPWR sky130_fd_sc_hd__decap_4
X_08375_ net530 net122 VGND VGND VPWR VPWR _01106_ sky130_fd_sc_hd__nand2_1
XFILLER_51_587 VGND VGND VPWR VPWR sky130_fd_sc_hd__fill_2
XTAP_TAPCELL_ROW_34_774 VGND VPWR sky130_fd_sc_hd__tapvpwrvgnd_1
X_07326_ net391 net287 net137 VGND VGND VPWR VPWR _06617_ sky130_fd_sc_hd__a21oi_1
XFILLER_109_306 VGND VGND VPWR VPWR sky130_fd_sc_hd__decap_3
XFILLER_99_19 VPWR VGND VPWR VGND sky130_ef_sc_hd__decap_12
XFILLER_136_125 VPWR VGND VPWR VGND sky130_ef_sc_hd__decap_12
XTAP_TAPCELL_ROW_115_1902 VGND VPWR sky130_fd_sc_hd__tapvpwrvgnd_1
X_07257_ _06506_ _06546_ VGND VGND VPWR VPWR _06548_ sky130_fd_sc_hd__xnor2_1
XFILLER_136_169 VPWR VGND VPWR VGND sky130_ef_sc_hd__decap_12
XFILLER_124_309 VPWR VGND VPWR VGND sky130_ef_sc_hd__decap_12
X_07188_ _06477_ _06478_ _06019_ _06052_ VGND VGND VPWR VPWR _06480_ sky130_fd_sc_hd__o211ai_2
XFILLER_3_617 VPWR VGND VPWR VGND sky130_ef_sc_hd__decap_12
XFILLER_78_418 VGND VGND VPWR VPWR sky130_fd_sc_hd__fill_2
XTAP_TAPCELL_ROW_57_1097 VGND VPWR sky130_fd_sc_hd__tapvpwrvgnd_1
XTAP_TAPCELL_ROW_57_1086 VGND VPWR sky130_fd_sc_hd__tapvpwrvgnd_1
Xfanout431 net432 VGND VGND VPWR VPWR net431 sky130_fd_sc_hd__buf_8
Xfanout420 net421 VGND VGND VPWR VPWR net420 sky130_fd_sc_hd__buf_2
Xfanout464 net465 VGND VGND VPWR VPWR net464 sky130_fd_sc_hd__buf_2
XTAP_TAPCELL_ROW_70_1275 VGND VPWR sky130_fd_sc_hd__tapvpwrvgnd_1
Xfanout453 net27 VGND VGND VPWR VPWR net453 sky130_fd_sc_hd__buf_2
XFILLER_58_131 VGND VGND VPWR VPWR sky130_fd_sc_hd__decap_8
XFILLER_58_120 VGND VGND VPWR VPWR sky130_fd_sc_hd__decap_4
Xfanout442 net443 VGND VGND VPWR VPWR net442 sky130_fd_sc_hd__buf_2
XFILLER_48_56 VGND VGND VPWR VPWR sky130_fd_sc_hd__decap_6
Xfanout475 net481 VGND VGND VPWR VPWR net475 sky130_fd_sc_hd__clkbuf_4
X_09829_ _02600_ _02601_ VGND VGND VPWR VPWR _02602_ sky130_fd_sc_hd__nand2b_1
Xfanout497 net498 VGND VGND VPWR VPWR net497 sky130_fd_sc_hd__clkbuf_4
Xfanout486 net488 VGND VGND VPWR VPWR net486 sky130_fd_sc_hd__buf_2
XFILLER_100_272 VGND VGND VPWR VPWR sky130_fd_sc_hd__fill_1
XFILLER_58_197 VGND VGND VPWR VPWR sky130_fd_sc_hd__decap_8
X_12840_ _05874_ _05880_ VGND VGND VPWR VPWR _05881_ sky130_fd_sc_hd__and2_1
XFILLER_74_668 VPWR VGND VPWR VGND sky130_ef_sc_hd__decap_12
XFILLER_64_66 VPWR VGND VPWR VGND sky130_ef_sc_hd__decap_12
XFILLER_61_329 VGND VGND VPWR VPWR sky130_fd_sc_hd__decap_6
XFILLER_15_746 VPWR VGND VPWR VGND sky130_ef_sc_hd__decap_12
X_12771_ _05665_ _05805_ VGND VGND VPWR VPWR _05806_ sky130_fd_sc_hd__xnor2_1
X_11722_ _04658_ _04659_ VGND VGND VPWR VPWR _04660_ sky130_fd_sc_hd__nand2_1
XFILLER_42_565 VGND VGND VPWR VPWR sky130_fd_sc_hd__fill_1
XFILLER_120_83 VGND VGND VPWR VPWR sky130_fd_sc_hd__fill_1
X_11653_ _04584_ VGND VGND VPWR VPWR _04585_ sky130_fd_sc_hd__inv_2
XFILLER_9_39 VGND VGND VPWR VPWR sky130_fd_sc_hd__fill_1
X_10604_ _03431_ _03440_ _03441_ VGND VGND VPWR VPWR _03442_ sky130_fd_sc_hd__nand3_2
X_13323_ net392 VGND VGND VPWR VPWR _00097_ sky130_fd_sc_hd__inv_2
XTAP_TAPCELL_ROW_12_457 VGND VPWR sky130_fd_sc_hd__tapvpwrvgnd_1
XTAP_TAPCELL_ROW_12_468 VGND VPWR sky130_fd_sc_hd__tapvpwrvgnd_1
X_11584_ _04512_ _04511_ VGND VGND VPWR VPWR _04513_ sky130_fd_sc_hd__nand2b_1
XFILLER_127_136 VPWR VGND VPWR VGND sky130_ef_sc_hd__decap_12
XFILLER_127_125 VGND VGND VPWR VPWR sky130_fd_sc_hd__decap_8
X_10535_ net520 net503 net118 net648 VGND VGND VPWR VPWR _03366_ sky130_fd_sc_hd__and4_1
XFILLER_6_433 VGND VGND VPWR VPWR sky130_fd_sc_hd__decap_8
XFILLER_129_81 VPWR VGND VPWR VGND sky130_ef_sc_hd__decap_12
XFILLER_127_169 VGND VGND VPWR VPWR sky130_fd_sc_hd__fill_2
XFILLER_108_361 VGND VGND VPWR VPWR sky130_fd_sc_hd__decap_3
X_10466_ net332 net309 net352 net350 VGND VGND VPWR VPWR _03291_ sky130_fd_sc_hd__and4_1
X_13254_ _06224_ _06227_ VGND VGND VPWR VPWR _06331_ sky130_fd_sc_hd__and2b_1
XFILLER_108_372 VGND VGND VPWR VPWR sky130_fd_sc_hd__decap_4
X_12205_ net488 net675 _04901_ VGND VGND VPWR VPWR _05186_ sky130_fd_sc_hd__and3_1
X_13185_ _06255_ _06256_ VGND VGND VPWR VPWR _06257_ sky130_fd_sc_hd__xor2_1
XFILLER_123_353 VGND VGND VPWR VPWR sky130_fd_sc_hd__decap_8
X_10397_ _02927_ _03077_ _02904_ VGND VGND VPWR VPWR _03217_ sky130_fd_sc_hd__o21a_1
X_12136_ _05109_ _05108_ _04957_ net234 VGND VGND VPWR VPWR _05111_ sky130_fd_sc_hd__a211o_1
XFILLER_96_215 VGND VGND VPWR VPWR sky130_fd_sc_hd__fill_2
X_12067_ _05034_ _05035_ VGND VGND VPWR VPWR _05037_ sky130_fd_sc_hd__and2_1
XFILLER_49_120 VGND VGND VPWR VPWR sky130_fd_sc_hd__decap_8
XFILLER_1_193 VPWR VGND VPWR VGND sky130_ef_sc_hd__decap_12
XTAP_TAPCELL_ROW_88_1525 VGND VPWR sky130_fd_sc_hd__tapvpwrvgnd_1
XFILLER_77_473 VPWR VGND VPWR VGND sky130_ef_sc_hd__decap_12
XFILLER_65_613 VGND VGND VPWR VPWR sky130_fd_sc_hd__decap_3
X_11018_ _03889_ _03894_ VGND VGND VPWR VPWR _03895_ sky130_fd_sc_hd__xnor2_1
XFILLER_37_315 VGND VGND VPWR VPWR sky130_fd_sc_hd__decap_3
XFILLER_37_337 VPWR VGND VPWR VGND sky130_ef_sc_hd__decap_12
XFILLER_92_454 VGND VGND VPWR VPWR sky130_fd_sc_hd__decap_8
XFILLER_18_551 VPWR VGND VPWR VGND sky130_ef_sc_hd__decap_12
X_12969_ _06017_ _06021_ VGND VGND VPWR VPWR _06022_ sky130_fd_sc_hd__xor2_1
XFILLER_60_362 VGND VGND VPWR VPWR sky130_fd_sc_hd__fill_2
XFILLER_21_727 VGND VGND VPWR VPWR sky130_fd_sc_hd__fill_1
X_08160_ _00894_ _00895_ _00893_ VGND VGND VPWR VPWR _00896_ sky130_fd_sc_hd__or3b_1
XTAP_TAPCELL_ROW_31_722 VGND VPWR sky130_fd_sc_hd__tapvpwrvgnd_1
XTAP_TAPCELL_ROW_31_733 VGND VPWR sky130_fd_sc_hd__tapvpwrvgnd_1
XFILLER_119_615 VGND VGND VPWR VPWR sky130_fd_sc_hd__fill_1
X_07111_ _03281_ _05549_ _05571_ VGND VGND VPWR VPWR _06403_ sky130_fd_sc_hd__a21oi_1
X_08091_ _00827_ VGND VGND VPWR VPWR _00828_ sky130_fd_sc_hd__inv_2
XFILLER_118_125 VGND VGND VPWR VPWR sky130_fd_sc_hd__decap_8
XTAP_TAPCELL_ROW_99_1687 VGND VPWR sky130_fd_sc_hd__tapvpwrvgnd_1
XTAP_TAPCELL_ROW_99_1676 VGND VPWR sky130_fd_sc_hd__tapvpwrvgnd_1
XFILLER_118_158 VPWR VGND VPWR VGND sky130_ef_sc_hd__decap_12
XFILLER_106_309 VGND VGND VPWR VPWR sky130_fd_sc_hd__decap_8
X_07042_ _05954_ _05964_ _05877_ VGND VGND VPWR VPWR _05986_ sky130_fd_sc_hd__a21o_1
XFILLER_126_180 VGND VGND VPWR VPWR sky130_fd_sc_hd__decap_3
XFILLER_125_39 VPWR VGND VPWR VGND sky130_ef_sc_hd__decap_12
XTAP_TAPCELL_ROW_110_1832 VGND VPWR sky130_fd_sc_hd__tapvpwrvgnd_1
X_08993_ _01717_ _01718_ VGND VGND VPWR VPWR _01719_ sky130_fd_sc_hd__nor2_1
X_07944_ _00680_ _00681_ VGND VGND VPWR VPWR _00682_ sky130_fd_sc_hd__or2_1
XFILLER_29_805 VGND VGND VPWR VPWR sky130_fd_sc_hd__decap_3
X_07875_ _00580_ _00611_ VGND VGND VPWR VPWR _00613_ sky130_fd_sc_hd__xnor2_1
X_09614_ _02083_ _02367_ VGND VGND VPWR VPWR _02368_ sky130_fd_sc_hd__xnor2_2
XFILLER_110_581 VGND VGND VPWR VPWR sky130_fd_sc_hd__decap_6
X_06826_ _03379_ _03620_ VGND VGND VPWR VPWR _03631_ sky130_fd_sc_hd__nand2b_1
XFILLER_95_281 VGND VGND VPWR VPWR sky130_fd_sc_hd__decap_8
XFILLER_83_432 VPWR VGND VPWR VGND sky130_ef_sc_hd__decap_12
XTAP_TAPCELL_ROW_39_844 VGND VPWR sky130_fd_sc_hd__tapvpwrvgnd_1
X_06757_ _02834_ _02867_ VGND VGND VPWR VPWR _02877_ sky130_fd_sc_hd__xnor2_1
XFILLER_71_649 VGND VGND VPWR VPWR sky130_fd_sc_hd__decap_3
XFILLER_71_638 VGND VGND VPWR VPWR sky130_fd_sc_hd__fill_1
XFILLER_71_627 VGND VGND VPWR VPWR sky130_fd_sc_hd__fill_2
XFILLER_70_115 VPWR VGND VPWR VGND sky130_ef_sc_hd__decap_12
X_09545_ net357 net324 VGND VGND VPWR VPWR _02293_ sky130_fd_sc_hd__and2b_1
X_06688_ net73 VGND VGND VPWR VPWR _02131_ sky130_fd_sc_hd__inv_2
X_09476_ _02215_ _02216_ VGND VGND VPWR VPWR _02218_ sky130_fd_sc_hd__xnor2_1
X_08427_ _01118_ _01156_ VGND VGND VPWR VPWR _01157_ sky130_fd_sc_hd__xnor2_1
XTAP_TAPCELL_ROW_121_1994 VGND VPWR sky130_fd_sc_hd__tapvpwrvgnd_1
XTAP_TAPCELL_ROW_121_1983 VGND VPWR sky130_fd_sc_hd__tapvpwrvgnd_1
XFILLER_12_749 VGND VGND VPWR VPWR sky130_fd_sc_hd__decap_6
Xclkload2 clknet_3_2__leaf_clk VGND VGND VPWR VPWR clkload2/Y sky130_fd_sc_hd__bufinv_16
X_08358_ _01086_ _01087_ _01088_ VGND VGND VPWR VPWR _01090_ sky130_fd_sc_hd__or3_1
X_08289_ _01022_ _01023_ VGND VGND VPWR VPWR _01024_ sky130_fd_sc_hd__and2b_1
XFILLER_109_136 VGND VGND VPWR VPWR sky130_fd_sc_hd__fill_1
X_07309_ _06597_ _06598_ _06599_ VGND VGND VPWR VPWR _06600_ sky130_fd_sc_hd__nand3_2
XTAP_TAPCELL_ROW_59_1115 VGND VPWR sky130_fd_sc_hd__tapvpwrvgnd_1
XFILLER_20_793 VPWR VGND VPWR VGND sky130_ef_sc_hd__decap_12
XFILLER_109_169 VPWR VGND VPWR VGND sky130_ef_sc_hd__decap_12
XTAP_TAPCELL_ROW_59_1126 VGND VPWR sky130_fd_sc_hd__tapvpwrvgnd_1
X_10320_ net694 net344 VGND VGND VPWR VPWR _03133_ sky130_fd_sc_hd__nand2_1
X_10251_ _02916_ _02919_ _02914_ VGND VGND VPWR VPWR _03057_ sky130_fd_sc_hd__a21oi_1
XFILLER_79_716 VGND VGND VPWR VPWR sky130_fd_sc_hd__decap_4
XTAP_TAPCELL_ROW_72_1304 VGND VPWR sky130_fd_sc_hd__tapvpwrvgnd_1
XFILLER_3_447 VGND VGND VPWR VPWR sky130_fd_sc_hd__fill_1
XFILLER_133_673 VPWR VGND VPWR VGND sky130_ef_sc_hd__decap_12
X_10182_ _02974_ _02975_ _02981_ VGND VGND VPWR VPWR _02982_ sky130_fd_sc_hd__nand3_1
XFILLER_120_345 VGND VGND VPWR VPWR sky130_fd_sc_hd__fill_2
XFILLER_78_248 VGND VGND VPWR VPWR sky130_fd_sc_hd__decap_4
Xfanout250 _02120_ VGND VGND VPWR VPWR net250 sky130_fd_sc_hd__clkbuf_8
Xfanout261 net92 VGND VGND VPWR VPWR net261 sky130_fd_sc_hd__clkbuf_1
XFILLER_87_782 VGND VGND VPWR VPWR sky130_fd_sc_hd__fill_2
Xfanout272 net88 VGND VGND VPWR VPWR net272 sky130_fd_sc_hd__buf_2
Xfanout283 net82 VGND VGND VPWR VPWR net283 sky130_fd_sc_hd__buf_2
XFILLER_101_592 VGND VGND VPWR VPWR sky130_fd_sc_hd__fill_2
XFILLER_47_635 VGND VGND VPWR VPWR sky130_fd_sc_hd__fill_1
Xfanout294 net78 VGND VGND VPWR VPWR net294 sky130_fd_sc_hd__clkbuf_2
XFILLER_62_638 VGND VGND VPWR VPWR sky130_fd_sc_hd__fill_2
XTAP_TAPCELL_ROW_17_527 VGND VPWR sky130_fd_sc_hd__tapvpwrvgnd_1
X_12823_ _05821_ _05860_ VGND VGND VPWR VPWR _05862_ sky130_fd_sc_hd__xnor2_1
XFILLER_131_93 VPWR VGND VPWR VGND sky130_ef_sc_hd__decap_12
XTAP_TAPCELL_ROW_83_1455 VGND VPWR sky130_fd_sc_hd__tapvpwrvgnd_1
XFILLER_15_543 VGND VGND VPWR VPWR sky130_fd_sc_hd__decap_3
XTAP_TAPCELL_ROW_17_538 VGND VPWR sky130_fd_sc_hd__tapvpwrvgnd_1
X_12754_ _05785_ _05786_ VGND VGND VPWR VPWR _05787_ sky130_fd_sc_hd__nor2_1
XFILLER_91_53 VGND VGND VPWR VPWR sky130_fd_sc_hd__decap_3
X_11705_ net536 net674 VGND VGND VPWR VPWR _04641_ sky130_fd_sc_hd__nand2_1
XFILLER_70_693 VGND VGND VPWR VPWR sky130_fd_sc_hd__decap_6
X_12685_ net492 net660 net658 net499 VGND VGND VPWR VPWR _05711_ sky130_fd_sc_hd__a22o_1
X_11636_ _04566_ _04568_ VGND VGND VPWR VPWR _04569_ sky130_fd_sc_hd__xnor2_1
XFILLER_30_579 VGND VGND VPWR VPWR sky130_fd_sc_hd__fill_1
XFILLER_128_445 VPWR VGND VPWR VGND sky130_ef_sc_hd__decap_12
X_11567_ _04492_ _04493_ VGND VGND VPWR VPWR _04495_ sky130_fd_sc_hd__nand2_1
XFILLER_128_489 VPWR VGND VPWR VGND sky130_ef_sc_hd__decap_12
X_10518_ _03187_ _03347_ VGND VGND VPWR VPWR _03348_ sky130_fd_sc_hd__xnor2_1
X_13306_ net396 VGND VGND VPWR VPWR _00080_ sky130_fd_sc_hd__inv_2
XFILLER_7_753 VPWR VGND VPWR VGND sky130_ef_sc_hd__decap_12
X_11498_ _03426_ _04305_ _04304_ VGND VGND VPWR VPWR _04419_ sky130_fd_sc_hd__a21oi_1
XFILLER_7_797 VPWR VGND VPWR VGND sky130_ef_sc_hd__decap_12
X_13237_ _05962_ _06213_ _06212_ VGND VGND VPWR VPWR _06314_ sky130_fd_sc_hd__a21bo_1
X_10449_ _03269_ _03271_ _03261_ VGND VGND VPWR VPWR _03273_ sky130_fd_sc_hd__a21o_1
XFILLER_130_109 VPWR VGND VPWR VGND sky130_ef_sc_hd__decap_12
X_13168_ _06238_ VGND VGND VPWR VPWR _06239_ sky130_fd_sc_hd__inv_2
XFILLER_111_334 VGND VGND VPWR VPWR sky130_fd_sc_hd__fill_2
XFILLER_97_557 VGND VGND VPWR VPWR sky130_fd_sc_hd__decap_3
XFILLER_69_237 VPWR VGND VPWR VGND sky130_ef_sc_hd__decap_12
X_12119_ _05089_ _05091_ _05092_ VGND VGND VPWR VPWR _05093_ sky130_fd_sc_hd__or3_1
X_13099_ _06055_ _06069_ _06068_ VGND VGND VPWR VPWR _06164_ sky130_fd_sc_hd__o21ai_1
XFILLER_27_3 VGND VGND VPWR VPWR sky130_fd_sc_hd__fill_2
XFILLER_77_270 VGND VGND VPWR VPWR sky130_fd_sc_hd__fill_1
XTAP_TAPCELL_ROW_125_2050 VGND VPWR sky130_fd_sc_hd__tapvpwrvgnd_1
XFILLER_92_240 VGND VGND VPWR VPWR sky130_fd_sc_hd__fill_1
X_07660_ _00397_ _00398_ VGND VGND VPWR VPWR _00400_ sky130_fd_sc_hd__xnor2_1
XFILLER_1_51 VGND VGND VPWR VPWR sky130_fd_sc_hd__decap_4
XTAP_TAPCELL_ROW_36_803 VGND VPWR sky130_fd_sc_hd__tapvpwrvgnd_1
XFILLER_38_657 VGND VGND VPWR VPWR sky130_fd_sc_hd__fill_2
XFILLER_38_679 VGND VGND VPWR VPWR sky130_fd_sc_hd__decap_8
X_07591_ net521 _02153_ VGND VGND VPWR VPWR _00331_ sky130_fd_sc_hd__nor2_1
XFILLER_53_649 VGND VGND VPWR VPWR sky130_fd_sc_hd__fill_1
X_09330_ _01999_ _02057_ _02058_ VGND VGND VPWR VPWR _02059_ sky130_fd_sc_hd__nand3_2
X_09261_ net456 net538 _01840_ _01839_ VGND VGND VPWR VPWR _01985_ sky130_fd_sc_hd__a31o_1
X_08212_ _00833_ _00943_ _00945_ _00946_ VGND VGND VPWR VPWR _00947_ sky130_fd_sc_hd__o211a_1
XFILLER_61_693 VGND VGND VPWR VPWR sky130_fd_sc_hd__decap_8
XFILLER_119_412 VPWR VGND VPWR VGND sky130_ef_sc_hd__decap_12
XFILLER_119_401 VGND VGND VPWR VPWR sky130_fd_sc_hd__decap_3
X_09192_ _01749_ _01748_ _01747_ VGND VGND VPWR VPWR _01917_ sky130_fd_sc_hd__a21oi_4
X_08143_ _00877_ _00878_ VGND VGND VPWR VPWR _00879_ sky130_fd_sc_hd__nor2_1
XFILLER_119_467 VGND VGND VPWR VPWR sky130_fd_sc_hd__fill_1
X_08074_ _00778_ _00809_ VGND VGND VPWR VPWR _00811_ sky130_fd_sc_hd__xnor2_1
X_07025_ net613 net418 _04166_ VGND VGND VPWR VPWR _05801_ sky130_fd_sc_hd__and3_1
XFILLER_136_27 VGND VGND VPWR VPWR sky130_fd_sc_hd__fill_1
XFILLER_115_673 VGND VGND VPWR VPWR sky130_fd_sc_hd__decap_4
XFILLER_102_301 VGND VGND VPWR VPWR sky130_fd_sc_hd__fill_2
XTAP_TAPCELL_ROW_54_1045 VGND VPWR sky130_fd_sc_hd__tapvpwrvgnd_1
XFILLER_0_406 VGND VGND VPWR VPWR sky130_fd_sc_hd__decap_3
XFILLER_130_643 VGND VGND VPWR VPWR sky130_fd_sc_hd__fill_1
XFILLER_102_323 VGND VGND VPWR VPWR sky130_fd_sc_hd__decap_4
XFILLER_76_708 VPWR VGND VPWR VGND sky130_ef_sc_hd__decap_12
XTAP_TAPCELL_ROW_54_1056 VGND VPWR sky130_fd_sc_hd__tapvpwrvgnd_1
X_08976_ _01697_ _01700_ _01701_ VGND VGND VPWR VPWR _01702_ sky130_fd_sc_hd__and3_1
X_07927_ _00662_ _00663_ VGND VGND VPWR VPWR _00665_ sky130_fd_sc_hd__xnor2_1
XFILLER_56_421 VPWR VGND VPWR VGND sky130_ef_sc_hd__decap_12
X_07858_ _00593_ _00594_ VGND VGND VPWR VPWR _00596_ sky130_fd_sc_hd__xnor2_1
XFILLER_29_679 VGND VGND VPWR VPWR sky130_fd_sc_hd__fill_1
X_06809_ net323 net321 net667 net642 VGND VGND VPWR VPWR _03445_ sky130_fd_sc_hd__and4_1
XFILLER_71_424 VGND VGND VPWR VPWR sky130_fd_sc_hd__decap_3
X_07789_ _00520_ _00525_ VGND VGND VPWR VPWR _00528_ sky130_fd_sc_hd__xor2_1
XFILLER_44_627 VGND VGND VPWR VPWR sky130_fd_sc_hd__fill_2
XFILLER_44_616 VGND VGND VPWR VPWR sky130_fd_sc_hd__fill_1
X_09528_ _02270_ _02271_ VGND VGND VPWR VPWR _02275_ sky130_fd_sc_hd__xor2_1
XFILLER_71_435 VPWR VGND VPWR VGND sky130_ef_sc_hd__decap_12
XFILLER_45_57 VPWR VGND VPWR VGND sky130_ef_sc_hd__decap_12
XFILLER_43_126 VGND VGND VPWR VPWR sky130_fd_sc_hd__fill_1
XFILLER_101_41 VGND VGND VPWR VPWR sky130_fd_sc_hd__fill_1
XFILLER_101_30 VGND VGND VPWR VPWR sky130_fd_sc_hd__decap_3
XFILLER_71_479 VGND VGND VPWR VPWR sky130_fd_sc_hd__fill_1
XFILLER_24_351 VGND VGND VPWR VPWR sky130_fd_sc_hd__fill_1
X_09459_ net407 net552 VGND VGND VPWR VPWR _02200_ sky130_fd_sc_hd__nand2_1
XFILLER_61_34 VGND VGND VPWR VPWR sky130_fd_sc_hd__fill_1
XFILLER_51_181 VGND VGND VPWR VPWR sky130_fd_sc_hd__decap_4
XFILLER_12_524 VGND VGND VPWR VPWR sky130_fd_sc_hd__fill_1
XFILLER_24_373 VPWR VGND VPWR VGND sky130_ef_sc_hd__decap_12
XFILLER_131_3 VPWR VGND VPWR VGND sky130_ef_sc_hd__decap_12
X_12470_ _05474_ _05472_ _05289_ _05291_ VGND VGND VPWR VPWR _05477_ sky130_fd_sc_hd__a211o_1
XFILLER_8_528 VGND VGND VPWR VPWR sky130_fd_sc_hd__decap_4
XFILLER_61_89 VGND VGND VPWR VPWR sky130_fd_sc_hd__decap_4
X_11421_ _04211_ _04334_ VGND VGND VPWR VPWR _04335_ sky130_fd_sc_hd__nor2_1
XFILLER_6_29 VPWR VGND VPWR VGND sky130_ef_sc_hd__decap_12
XFILLER_4_701 VPWR VGND VPWR VGND sky130_ef_sc_hd__decap_12
XTAP_TAPCELL_ROW_22_596 VGND VPWR sky130_fd_sc_hd__tapvpwrvgnd_1
X_11352_ _04119_ _04122_ _04259_ VGND VGND VPWR VPWR _04260_ sky130_fd_sc_hd__o21ai_1
X_10303_ net467 net458 net564 net561 VGND VGND VPWR VPWR _03114_ sky130_fd_sc_hd__and4_1
X_11283_ _04171_ _04182_ VGND VGND VPWR VPWR _04184_ sky130_fd_sc_hd__xor2_1
XFILLER_121_610 VGND VGND VPWR VPWR sky130_fd_sc_hd__fill_2
XFILLER_106_662 VGND VGND VPWR VPWR sky130_fd_sc_hd__fill_1
X_10234_ _02908_ _02917_ _02884_ VGND VGND VPWR VPWR _03039_ sky130_fd_sc_hd__o21a_1
XFILLER_10_82 VGND VGND VPWR VPWR sky130_fd_sc_hd__fill_2
XPHY_EDGE_ROW_5_Left_142 VGND VGND VPWR VPWR sky130_fd_sc_hd__decap_3
X_13022_ _05963_ _06079_ VGND VGND VPWR VPWR _06080_ sky130_fd_sc_hd__xnor2_1
XFILLER_120_120 VPWR VGND VPWR VGND sky130_ef_sc_hd__decap_12
X_10165_ _02962_ VGND VGND VPWR VPWR _02963_ sky130_fd_sc_hd__inv_2
XFILLER_120_153 VPWR VGND VPWR VGND sky130_ef_sc_hd__decap_12
XFILLER_94_527 VGND VGND VPWR VPWR sky130_fd_sc_hd__decap_4
XFILLER_120_197 VPWR VGND VPWR VGND sky130_ef_sc_hd__decap_12
XFILLER_86_97 VPWR VGND VPWR VGND sky130_ef_sc_hd__decap_12
X_10096_ _02884_ _02885_ VGND VGND VPWR VPWR _02887_ sky130_fd_sc_hd__or2_1
XFILLER_59_281 VGND VGND VPWR VPWR sky130_fd_sc_hd__decap_3
XFILLER_59_270 VGND VGND VPWR VPWR sky130_fd_sc_hd__decap_8
XFILLER_19_101 VGND VGND VPWR VPWR sky130_fd_sc_hd__fill_1
XFILLER_19_145 VGND VGND VPWR VPWR sky130_fd_sc_hd__decap_8
XFILLER_75_785 VPWR VGND VPWR VGND sky130_ef_sc_hd__decap_12
XFILLER_62_413 VGND VGND VPWR VPWR sky130_fd_sc_hd__decap_6
XFILLER_90_755 VGND VGND VPWR VPWR sky130_fd_sc_hd__fill_1
XFILLER_62_457 VGND VGND VPWR VPWR sky130_fd_sc_hd__fill_1
X_12806_ _05525_ _05690_ _05693_ VGND VGND VPWR VPWR _05843_ sky130_fd_sc_hd__o21ai_1
XFILLER_34_148 VPWR VGND VPWR VGND sky130_ef_sc_hd__decap_12
X_10998_ net590 net274 VGND VGND VPWR VPWR _03873_ sky130_fd_sc_hd__nand2_1
XFILLER_96_6 VPWR VGND VPWR VGND sky130_ef_sc_hd__decap_12
X_12737_ _05620_ _05631_ _05619_ VGND VGND VPWR VPWR _05769_ sky130_fd_sc_hd__a21bo_1
XFILLER_42_181 VPWR VGND VPWR VGND sky130_ef_sc_hd__decap_12
XFILLER_129_721 VGND VGND VPWR VPWR sky130_fd_sc_hd__decap_6
X_12668_ _05688_ _05692_ VGND VGND VPWR VPWR _05693_ sky130_fd_sc_hd__or2_1
X_11619_ _03985_ _04317_ _04321_ _04432_ VGND VGND VPWR VPWR _04551_ sky130_fd_sc_hd__a22o_1
XTAP_TAPCELL_ROW_41_872 VGND VPWR sky130_fd_sc_hd__tapvpwrvgnd_1
XFILLER_129_765 VPWR VGND VPWR VGND sky130_ef_sc_hd__decap_12
XFILLER_128_253 VGND VGND VPWR VPWR sky130_fd_sc_hd__decap_6
XTAP_TAPCELL_ROW_96_1635 VGND VPWR sky130_fd_sc_hd__tapvpwrvgnd_1
X_12599_ _05442_ _05447_ _05441_ VGND VGND VPWR VPWR _05618_ sky130_fd_sc_hd__a21bo_1
XFILLER_7_561 VPWR VGND VPWR VGND sky130_ef_sc_hd__decap_12
Xmax_cap236 _03661_ VGND VGND VPWR VPWR net236 sky130_fd_sc_hd__clkbuf_2
XFILLER_97_310 VGND VGND VPWR VPWR sky130_fd_sc_hd__fill_2
XFILLER_106_19 VGND VGND VPWR VPWR sky130_fd_sc_hd__decap_8
X_08830_ _01554_ _01555_ _01556_ VGND VGND VPWR VPWR _01557_ sky130_fd_sc_hd__nand3_1
XFILLER_85_505 VPWR VGND VPWR VGND sky130_ef_sc_hd__decap_12
X_08761_ _01487_ _01452_ VGND VGND VPWR VPWR _01488_ sky130_fd_sc_hd__and2b_1
XFILLER_57_229 VGND VGND VPWR VPWR sky130_fd_sc_hd__fill_2
XFILLER_38_421 VPWR VGND VPWR VGND sky130_ef_sc_hd__decap_12
X_07712_ _00447_ _00450_ VGND VGND VPWR VPWR _00451_ sky130_fd_sc_hd__xnor2_1
XFILLER_122_29 VPWR VGND VPWR VGND sky130_ef_sc_hd__decap_12
X_08692_ _01417_ _01416_ _01418_ VGND VGND VPWR VPWR _01420_ sky130_fd_sc_hd__a21o_1
XFILLER_38_465 VGND VGND VPWR VPWR sky130_fd_sc_hd__fill_2
XFILLER_81_733 VGND VGND VPWR VPWR sky130_fd_sc_hd__fill_1
X_07643_ net387 net288 VGND VGND VPWR VPWR _00383_ sky130_fd_sc_hd__and2_1
XTAP_TAPCELL_ROW_49_983 VGND VPWR sky130_fd_sc_hd__tapvpwrvgnd_1
XFILLER_38_487 VGND VGND VPWR VPWR sky130_fd_sc_hd__fill_2
XFILLER_53_446 VGND VGND VPWR VPWR sky130_fd_sc_hd__fill_2
XFILLER_25_126 VGND VGND VPWR VPWR sky130_fd_sc_hd__decap_8
X_07574_ _00306_ _00313_ VGND VGND VPWR VPWR _00314_ sky130_fd_sc_hd__nor2_1
XTAP_TAPCELL_ROW_105_1764 VGND VPWR sky130_fd_sc_hd__tapvpwrvgnd_1
XFILLER_80_265 VPWR VGND VPWR VGND sky130_ef_sc_hd__decap_12
X_09313_ _01875_ _01877_ _01874_ VGND VGND VPWR VPWR _02040_ sky130_fd_sc_hd__o21ba_1
XFILLER_15_49 VGND VGND VPWR VPWR sky130_fd_sc_hd__decap_6
XFILLER_34_693 VGND VGND VPWR VPWR sky130_fd_sc_hd__decap_6
X_09244_ net501 net510 net626 net128 VGND VGND VPWR VPWR _01968_ sky130_fd_sc_hd__and4_1
XFILLER_21_332 VGND VGND VPWR VPWR sky130_fd_sc_hd__decap_4
XFILLER_33_192 VGND VGND VPWR VPWR sky130_fd_sc_hd__fill_1
X_09175_ _01802_ _01897_ _01899_ VGND VGND VPWR VPWR _01900_ sky130_fd_sc_hd__and3_1
X_08126_ _00732_ _00740_ _00742_ VGND VGND VPWR VPWR _00862_ sky130_fd_sc_hd__a21bo_1
XFILLER_119_297 VGND VGND VPWR VPWR sky130_fd_sc_hd__decap_6
XFILLER_134_245 VGND VGND VPWR VPWR sky130_fd_sc_hd__decap_6
X_08057_ _00665_ _00671_ _00668_ VGND VGND VPWR VPWR _00794_ sky130_fd_sc_hd__a21o_1
XPHY_EDGE_ROW_1_Right_1 VGND VGND VPWR VPWR sky130_fd_sc_hd__decap_3
XFILLER_134_289 VPWR VGND VPWR VGND sky130_ef_sc_hd__decap_12
X_07008_ _05374_ _05593_ VGND VGND VPWR VPWR _05615_ sky130_fd_sc_hd__and2b_1
XFILLER_0_225 VPWR VGND VPWR VGND sky130_ef_sc_hd__decap_12
Xinput126 w23[4] VGND VGND VPWR VPWR net126 sky130_fd_sc_hd__clkbuf_2
Xinput104 w20[6] VGND VGND VPWR VPWR net104 sky130_fd_sc_hd__clkbuf_2
XFILLER_102_153 VGND VGND VPWR VPWR sky130_fd_sc_hd__decap_8
XFILLER_76_516 VPWR VGND VPWR VGND sky130_ef_sc_hd__decap_12
Xinput115 w22[1] VGND VGND VPWR VPWR net115 sky130_fd_sc_hd__buf_1
XFILLER_0_258 VGND VGND VPWR VPWR sky130_fd_sc_hd__decap_4
Xinput137 w30[7] VGND VGND VPWR VPWR net137 sky130_fd_sc_hd__buf_2
Xinput159 w33[5] VGND VGND VPWR VPWR net159 sky130_fd_sc_hd__buf_1
X_08959_ net430 net63 net64 net517 VGND VGND VPWR VPWR _01685_ sky130_fd_sc_hd__a22o_1
Xinput148 w32[2] VGND VGND VPWR VPWR net148 sky130_fd_sc_hd__buf_1
X_11970_ net424 net600 _04761_ VGND VGND VPWR VPWR _04931_ sky130_fd_sc_hd__a21oi_1
XFILLER_57_785 VGND VGND VPWR VPWR sky130_fd_sc_hd__decap_6
XFILLER_56_273 VPWR VGND VPWR VGND sky130_ef_sc_hd__decap_12
XFILLER_17_638 VGND VGND VPWR VPWR sky130_fd_sc_hd__decap_4
XFILLER_29_476 VPWR VGND VPWR VGND sky130_ef_sc_hd__decap_12
X_10921_ net577 net575 net400 VGND VGND VPWR VPWR _03789_ sky130_fd_sc_hd__o21ai_4
XFILLER_72_755 VGND VGND VPWR VPWR sky130_fd_sc_hd__fill_1
XTAP_TAPCELL_ROW_67_1236 VGND VPWR sky130_fd_sc_hd__tapvpwrvgnd_1
XFILLER_16_137 VGND VGND VPWR VPWR sky130_fd_sc_hd__decap_3
XFILLER_17_649 VPWR VGND VPWR VGND sky130_ef_sc_hd__decap_12
XFILLER_71_243 VGND VGND VPWR VPWR sky130_fd_sc_hd__fill_1
X_10852_ _03528_ _03530_ _03712_ VGND VGND VPWR VPWR _03713_ sky130_fd_sc_hd__a21oi_1
XTAP_TAPCELL_ROW_27_666 VGND VPWR sky130_fd_sc_hd__tapvpwrvgnd_1
XTAP_TAPCELL_ROW_27_677 VGND VPWR sky130_fd_sc_hd__tapvpwrvgnd_1
XTAP_TAPCELL_ROW_80_1414 VGND VPWR sky130_fd_sc_hd__tapvpwrvgnd_1
X_10783_ _03635_ _03636_ _03637_ VGND VGND VPWR VPWR _03638_ sky130_fd_sc_hd__a21o_1
XFILLER_40_630 VGND VGND VPWR VPWR sky130_fd_sc_hd__fill_2
X_12522_ _05337_ _05354_ _05353_ VGND VGND VPWR VPWR _05533_ sky130_fd_sc_hd__o21ai_2
XFILLER_24_192 VGND VGND VPWR VPWR sky130_fd_sc_hd__decap_4
XFILLER_12_365 VGND VGND VPWR VPWR sky130_fd_sc_hd__fill_2
X_12453_ _05272_ _05274_ _05456_ _05457_ VGND VGND VPWR VPWR _05458_ sky130_fd_sc_hd__o211a_1
XFILLER_126_713 VPWR VGND VPWR VGND sky130_ef_sc_hd__decap_12
XFILLER_125_212 VGND VGND VPWR VPWR sky130_fd_sc_hd__fill_1
X_11404_ net400 net559 _04192_ VGND VGND VPWR VPWR _04316_ sky130_fd_sc_hd__a21oi_1
X_12384_ _05204_ _05207_ VGND VGND VPWR VPWR _05382_ sky130_fd_sc_hd__nand2_1
XFILLER_126_757 VPWR VGND VPWR VGND sky130_ef_sc_hd__decap_12
XFILLER_125_223 VGND VGND VPWR VPWR sky130_fd_sc_hd__fill_1
XTAP_TAPCELL_ROW_78_1387 VGND VPWR sky130_fd_sc_hd__tapvpwrvgnd_1
XFILLER_4_531 VGND VGND VPWR VPWR sky130_fd_sc_hd__fill_1
X_11335_ net565 net272 _02230_ net590 VGND VGND VPWR VPWR _04241_ sky130_fd_sc_hd__o2bb2a_1
X_11266_ net286 net344 _04066_ VGND VGND VPWR VPWR _04165_ sky130_fd_sc_hd__a21oi_1
XTAP_TAPCELL_ROW_91_1565 VGND VPWR sky130_fd_sc_hd__tapvpwrvgnd_1
X_10217_ _02942_ _03019_ _03018_ VGND VGND VPWR VPWR _03021_ sky130_fd_sc_hd__nor3_4
X_13005_ _05689_ _06060_ VGND VGND VPWR VPWR _06061_ sky130_fd_sc_hd__xnor2_1
XFILLER_94_302 VGND VGND VPWR VPWR sky130_fd_sc_hd__decap_3
XFILLER_67_505 VGND VGND VPWR VPWR sky130_fd_sc_hd__fill_2
X_11197_ _03978_ _03986_ _03985_ VGND VGND VPWR VPWR _04091_ sky130_fd_sc_hd__o21ba_1
XFILLER_79_398 VGND VGND VPWR VPWR sky130_fd_sc_hd__decap_6
X_10148_ net459 net574 VGND VGND VPWR VPWR _02945_ sky130_fd_sc_hd__nand2_1
XTAP_TAPCELL_ROW_7_391 VGND VPWR sky130_fd_sc_hd__tapvpwrvgnd_1
XFILLER_0_781 VGND VGND VPWR VPWR sky130_fd_sc_hd__decap_3
XFILLER_94_346 VGND VGND VPWR VPWR sky130_fd_sc_hd__fill_1
X_10079_ _02866_ _02868_ _02819_ VGND VGND VPWR VPWR _02870_ sky130_fd_sc_hd__o21bai_1
XFILLER_47_240 VGND VGND VPWR VPWR sky130_fd_sc_hd__fill_1
XFILLER_47_251 VPWR VGND VPWR VGND sky130_ef_sc_hd__decap_12
XFILLER_63_755 VGND VGND VPWR VPWR sky130_fd_sc_hd__fill_2
XTAP_TAPCELL_ROW_46_942 VGND VPWR sky130_fd_sc_hd__tapvpwrvgnd_1
XFILLER_35_424 VGND VGND VPWR VPWR sky130_fd_sc_hd__decap_8
XFILLER_62_265 VGND VGND VPWR VPWR sky130_fd_sc_hd__decap_4
XFILLER_62_298 VGND VGND VPWR VPWR sky130_fd_sc_hd__decap_8
X_07290_ _06578_ _06579_ _06566_ VGND VGND VPWR VPWR _06581_ sky130_fd_sc_hd__a21o_1
XFILLER_94_3 VPWR VGND VPWR VGND sky130_ef_sc_hd__decap_12
XTAP_TAPCELL_ROW_100_1694 VGND VPWR sky130_fd_sc_hd__tapvpwrvgnd_1
XFILLER_129_573 VPWR VGND VPWR VGND sky130_ef_sc_hd__decap_12
XPHY_EDGE_ROW_68_Left_205 VGND VGND VPWR VPWR sky130_fd_sc_hd__decap_3
XTAP_TAPCELL_ROW_133_2160 VGND VPWR sky130_fd_sc_hd__tapvpwrvgnd_1
XFILLER_117_768 VPWR VGND VPWR VGND sky130_ef_sc_hd__decap_12
XFILLER_7_391 VGND VGND VPWR VPWR sky130_fd_sc_hd__fill_1
XFILLER_7_94 VGND VGND VPWR VPWR sky130_fd_sc_hd__decap_8
XFILLER_116_278 VGND VGND VPWR VPWR sky130_fd_sc_hd__fill_2
X_09931_ _02576_ _02604_ _02605_ _02608_ VGND VGND VPWR VPWR _02713_ sky130_fd_sc_hd__a31o_1
XFILLER_132_749 VGND VGND VPWR VPWR sky130_fd_sc_hd__decap_6
X_09862_ _02629_ _02636_ VGND VGND VPWR VPWR _02637_ sky130_fd_sc_hd__xnor2_1
XTAP_TAPCELL_ROW_51_1015 VGND VPWR sky130_fd_sc_hd__tapvpwrvgnd_1
XTAP_TAPCELL_ROW_51_1004 VGND VPWR sky130_fd_sc_hd__tapvpwrvgnd_1
XFILLER_133_39 VPWR VGND VPWR VGND sky130_ef_sc_hd__decap_12
XFILLER_112_473 VGND VGND VPWR VPWR sky130_fd_sc_hd__decap_3
X_09793_ _02560_ _02561_ VGND VGND VPWR VPWR _02562_ sky130_fd_sc_hd__nand2_1
X_08813_ _01408_ _01410_ _01409_ VGND VGND VPWR VPWR _01540_ sky130_fd_sc_hd__o21ba_1
X_08744_ net597 net573 net264 net262 VGND VGND VPWR VPWR _01471_ sky130_fd_sc_hd__and4_1
XFILLER_39_763 VGND VGND VPWR VPWR sky130_fd_sc_hd__fill_1
XPHY_EDGE_ROW_77_Left_214 VGND VGND VPWR VPWR sky130_fd_sc_hd__decap_3
XFILLER_38_251 VGND VGND VPWR VPWR sky130_fd_sc_hd__fill_1
XFILLER_39_774 VGND VGND VPWR VPWR sky130_fd_sc_hd__decap_8
XFILLER_39_785 VGND VGND VPWR VPWR sky130_fd_sc_hd__decap_6
X_08675_ _01242_ _01244_ _01402_ VGND VGND VPWR VPWR _01403_ sky130_fd_sc_hd__o21a_1
XFILLER_26_48 VGND VGND VPWR VPWR sky130_fd_sc_hd__decap_4
X_07626_ _00364_ _00365_ VGND VGND VPWR VPWR _00366_ sky130_fd_sc_hd__or2_1
XFILLER_14_608 VPWR VGND VPWR VGND sky130_ef_sc_hd__decap_12
X_07557_ net642 net304 _02131_ net668 VGND VGND VPWR VPWR _00297_ sky130_fd_sc_hd__o2bb2a_1
XFILLER_13_107 VGND VGND VPWR VPWR sky130_fd_sc_hd__decap_4
XTAP_TAPCELL_ROW_24_625 VGND VPWR sky130_fd_sc_hd__tapvpwrvgnd_1
XTAP_TAPCELL_ROW_24_636 VGND VPWR sky130_fd_sc_hd__tapvpwrvgnd_1
XFILLER_41_427 VGND VGND VPWR VPWR sky130_fd_sc_hd__decap_8
XFILLER_41_449 VGND VGND VPWR VPWR sky130_fd_sc_hd__decap_8
XFILLER_42_25 VGND VGND VPWR VPWR sky130_fd_sc_hd__decap_3
X_07488_ net288 net389 net391 VGND VGND VPWR VPWR _00229_ sky130_fd_sc_hd__and3_1
XTAP_TAPCELL_ROW_62_1166 VGND VPWR sky130_fd_sc_hd__tapvpwrvgnd_1
XFILLER_21_162 VGND VGND VPWR VPWR sky130_fd_sc_hd__decap_6
XFILLER_22_696 VGND VGND VPWR VPWR sky130_fd_sc_hd__decap_4
X_09227_ _01946_ _01950_ VGND VGND VPWR VPWR _01951_ sky130_fd_sc_hd__xnor2_2
XPHY_EDGE_ROW_86_Left_223 VGND VGND VPWR VPWR sky130_fd_sc_hd__decap_3
XTAP_TAPCELL_ROW_118_1944 VGND VPWR sky130_fd_sc_hd__tapvpwrvgnd_1
XFILLER_108_713 VPWR VGND VPWR VGND sky130_ef_sc_hd__decap_12
X_09158_ _01882_ VGND VGND VPWR VPWR _01883_ sky130_fd_sc_hd__inv_2
XFILLER_5_317 VPWR VGND VPWR VGND sky130_ef_sc_hd__decap_12
XFILLER_108_757 VPWR VGND VPWR VGND sky130_ef_sc_hd__decap_12
X_09089_ _01812_ _01813_ VGND VGND VPWR VPWR _01814_ sky130_fd_sc_hd__xnor2_1
X_08109_ _00842_ _00843_ VGND VGND VPWR VPWR _00845_ sky130_fd_sc_hd__nand2b_1
XFILLER_123_727 VGND VGND VPWR VPWR sky130_fd_sc_hd__fill_1
XFILLER_107_267 VGND VGND VPWR VPWR sky130_fd_sc_hd__decap_6
X_11120_ _03865_ _04006_ VGND VGND VPWR VPWR _04007_ sky130_fd_sc_hd__xnor2_2
XFILLER_123_749 VPWR VGND VPWR VGND sky130_ef_sc_hd__decap_12
XFILLER_122_215 VGND VGND VPWR VPWR sky130_fd_sc_hd__decap_6
XFILLER_88_151 VPWR VGND VPWR VGND sky130_ef_sc_hd__decap_12
XFILLER_49_505 VGND VGND VPWR VPWR sky130_fd_sc_hd__decap_8
X_11051_ _03590_ _03930_ VGND VGND VPWR VPWR _03931_ sky130_fd_sc_hd__xnor2_1
XPHY_EDGE_ROW_95_Left_232 VGND VGND VPWR VPWR sky130_fd_sc_hd__decap_3
XFILLER_89_685 VPWR VGND VPWR VGND sky130_ef_sc_hd__decap_12
X_10002_ _02784_ _02785_ _02786_ VGND VGND VPWR VPWR _02787_ sky130_fd_sc_hd__or3_1
XFILLER_88_195 VGND VGND VPWR VPWR sky130_fd_sc_hd__fill_1
XFILLER_76_368 VPWR VGND VPWR VGND sky130_ef_sc_hd__decap_12
XTAP_TAPCELL_ROW_4_350 VGND VPWR sky130_fd_sc_hd__tapvpwrvgnd_1
XFILLER_91_349 VGND VGND VPWR VPWR sky130_fd_sc_hd__decap_8
XFILLER_72_541 VGND VGND VPWR VPWR sky130_fd_sc_hd__decap_3
X_11953_ _04910_ _04911_ VGND VGND VPWR VPWR _04912_ sky130_fd_sc_hd__or2_1
XFILLER_17_424 VGND VGND VPWR VPWR sky130_fd_sc_hd__fill_1
X_11884_ _04832_ _04825_ _04833_ VGND VGND VPWR VPWR _04837_ sky130_fd_sc_hd__a21o_1
XTAP_TAPCELL_ROW_43_901 VGND VPWR sky130_fd_sc_hd__tapvpwrvgnd_1
X_10904_ _03763_ _03769_ VGND VGND VPWR VPWR _03770_ sky130_fd_sc_hd__xor2_1
X_10835_ _03691_ _03692_ VGND VGND VPWR VPWR _03694_ sky130_fd_sc_hd__xor2_2
XFILLER_32_427 VGND VGND VPWR VPWR sky130_fd_sc_hd__fill_1
XFILLER_60_769 VGND VGND VPWR VPWR sky130_fd_sc_hd__decap_4
XFILLER_9_601 VPWR VGND VPWR VGND sky130_ef_sc_hd__decap_12
XFILLER_16_92 VGND VGND VPWR VPWR sky130_fd_sc_hd__decap_8
XFILLER_13_685 VPWR VGND VPWR VGND sky130_ef_sc_hd__decap_12
X_10766_ _03616_ _03617_ _03610_ VGND VGND VPWR VPWR _03619_ sky130_fd_sc_hd__a21o_1
XFILLER_12_184 VPWR VGND VPWR VGND sky130_ef_sc_hd__decap_12
X_10697_ net283 net281 VGND VGND VPWR VPWR _03544_ sky130_fd_sc_hd__or2_1
X_12505_ _05512_ _05513_ VGND VGND VPWR VPWR _05514_ sky130_fd_sc_hd__or2_1
XFILLER_126_510 VGND VGND VPWR VPWR sky130_fd_sc_hd__decap_8
XFILLER_66_7 VPWR VGND VPWR VGND sky130_ef_sc_hd__decap_12
XFILLER_8_188 VGND VGND VPWR VPWR sky130_fd_sc_hd__fill_1
X_12436_ net657 _05264_ _05263_ VGND VGND VPWR VPWR _05439_ sky130_fd_sc_hd__a21o_1
X_12367_ _05311_ _05362_ VGND VGND VPWR VPWR _05364_ sky130_fd_sc_hd__xor2_1
XFILLER_113_237 VGND VGND VPWR VPWR sky130_fd_sc_hd__decap_6
XFILLER_99_449 VPWR VGND VPWR VGND sky130_ef_sc_hd__decap_12
X_12298_ _05286_ _05288_ VGND VGND VPWR VPWR _05289_ sky130_fd_sc_hd__and2b_1
X_11318_ _04216_ _04222_ VGND VGND VPWR VPWR _04223_ sky130_fd_sc_hd__and2b_1
X_11249_ _04064_ _04147_ VGND VGND VPWR VPWR _04148_ sky130_fd_sc_hd__xnor2_2
XFILLER_95_622 VPWR VGND VPWR VGND sky130_ef_sc_hd__decap_12
XFILLER_121_281 VGND VGND VPWR VPWR sky130_fd_sc_hd__fill_1
X_06790_ net527 net684 net682 net532 VGND VGND VPWR VPWR _03237_ sky130_fd_sc_hd__a22oi_1
XFILLER_82_349 VGND VGND VPWR VPWR sky130_fd_sc_hd__fill_1
XFILLER_48_593 VGND VGND VPWR VPWR sky130_fd_sc_hd__fill_1
XFILLER_35_221 VGND VGND VPWR VPWR sky130_fd_sc_hd__decap_3
XFILLER_36_733 VGND VGND VPWR VPWR sky130_fd_sc_hd__decap_4
XFILLER_36_744 VGND VGND VPWR VPWR sky130_fd_sc_hd__fill_2
X_08460_ _01185_ _01188_ VGND VGND VPWR VPWR _01189_ sky130_fd_sc_hd__nor2_1
XFILLER_51_703 VGND VGND VPWR VPWR sky130_fd_sc_hd__decap_6
XFILLER_23_405 VGND VGND VPWR VPWR sky130_fd_sc_hd__fill_1
X_07411_ _00149_ _00151_ VGND VGND VPWR VPWR _00152_ sky130_fd_sc_hd__nor2_1
XTAP_TAPCELL_ROW_102_1723 VGND VPWR sky130_fd_sc_hd__tapvpwrvgnd_1
XFILLER_90_360 VGND VGND VPWR VPWR sky130_fd_sc_hd__decap_4
X_08391_ _01093_ _01120_ VGND VGND VPWR VPWR _01122_ sky130_fd_sc_hd__and2_1
XFILLER_51_725 VGND VGND VPWR VPWR sky130_fd_sc_hd__decap_3
XFILLER_35_287 VGND VGND VPWR VPWR sky130_fd_sc_hd__fill_1
X_07342_ _06616_ _06631_ VGND VGND VPWR VPWR _06633_ sky130_fd_sc_hd__xor2_1
XFILLER_23_449 VGND VGND VPWR VPWR sky130_fd_sc_hd__decap_3
XFILLER_136_307 VGND VGND VPWR VPWR sky130_fd_sc_hd__fill_1
X_07273_ _06562_ _06563_ VGND VGND VPWR VPWR _06564_ sky130_fd_sc_hd__nand2_1
X_09012_ _01489_ _01575_ _01574_ VGND VGND VPWR VPWR _01738_ sky130_fd_sc_hd__a21boi_1
XFILLER_132_513 VPWR VGND VPWR VGND sky130_ef_sc_hd__decap_12
XFILLER_2_309 VPWR VGND VPWR VGND sky130_ef_sc_hd__decap_12
XFILLER_132_557 VPWR VGND VPWR VGND sky130_ef_sc_hd__decap_12
XTAP_TAPCELL_ROW_113_1874 VGND VPWR sky130_fd_sc_hd__tapvpwrvgnd_1
Xfanout624 net129 VGND VGND VPWR VPWR net624 sky130_fd_sc_hd__clkbuf_4
X_09914_ _02333_ _02550_ _02693_ VGND VGND VPWR VPWR _02694_ sky130_fd_sc_hd__o21ba_1
Xfanout602 net136 VGND VGND VPWR VPWR net602 sky130_fd_sc_hd__buf_2
Xfanout613 net614 VGND VGND VPWR VPWR net613 sky130_fd_sc_hd__buf_2
Xfanout646 net12 VGND VGND VPWR VPWR net646 sky130_fd_sc_hd__buf_4
X_09845_ _02614_ _02618_ VGND VGND VPWR VPWR _02619_ sky130_fd_sc_hd__xnor2_1
XFILLER_100_410 VGND VGND VPWR VPWR sky130_fd_sc_hd__decap_3
XFILLER_58_313 VPWR VGND VPWR VGND sky130_ef_sc_hd__decap_12
Xfanout657 net113 VGND VGND VPWR VPWR net657 sky130_fd_sc_hd__buf_2
Xfanout635 net121 VGND VGND VPWR VPWR net635 sky130_fd_sc_hd__buf_2
Xfanout668 net671 VGND VGND VPWR VPWR net668 sky130_fd_sc_hd__clkbuf_2
Xfanout679 net103 VGND VGND VPWR VPWR net679 sky130_fd_sc_hd__clkbuf_2
XFILLER_100_432 VGND VGND VPWR VPWR sky130_fd_sc_hd__decap_6
XFILLER_85_143 VGND VGND VPWR VPWR sky130_fd_sc_hd__fill_1
X_06988_ net528 net681 VGND VGND VPWR VPWR _05396_ sky130_fd_sc_hd__nand2_1
XFILLER_100_454 VPWR VGND VPWR VGND sky130_ef_sc_hd__decap_12
X_09776_ _02408_ _02410_ VGND VGND VPWR VPWR _02543_ sky130_fd_sc_hd__nand2_1
XFILLER_46_519 VGND VGND VPWR VPWR sky130_fd_sc_hd__fill_1
XTAP_TAPCELL_ROW_29_706 VGND VPWR sky130_fd_sc_hd__tapvpwrvgnd_1
XFILLER_37_36 VGND VGND VPWR VPWR sky130_fd_sc_hd__decap_3
X_08727_ net644 net257 VGND VGND VPWR VPWR _01454_ sky130_fd_sc_hd__nand2_1
XFILLER_85_198 VGND VGND VPWR VPWR sky130_fd_sc_hd__decap_6
XFILLER_26_210 VPWR VGND VPWR VGND sky130_ef_sc_hd__decap_12
XFILLER_37_69 VPWR VGND VPWR VGND sky130_ef_sc_hd__decap_12
X_08658_ _01249_ _01385_ VGND VGND VPWR VPWR _01386_ sky130_fd_sc_hd__xor2_1
XFILLER_54_552 VGND VGND VPWR VPWR sky130_fd_sc_hd__decap_8
X_07609_ _00345_ _00348_ VGND VGND VPWR VPWR _00349_ sky130_fd_sc_hd__and2_1
XFILLER_14_438 VGND VGND VPWR VPWR sky130_fd_sc_hd__fill_1
XFILLER_26_265 VGND VGND VPWR VPWR sky130_fd_sc_hd__decap_3
XFILLER_41_202 VGND VGND VPWR VPWR sky130_fd_sc_hd__decap_6
XFILLER_42_736 VPWR VGND VPWR VGND sky130_ef_sc_hd__decap_12
X_08589_ _01307_ _01310_ _01309_ VGND VGND VPWR VPWR _01318_ sky130_fd_sc_hd__o21ai_1
XFILLER_81_393 VGND VGND VPWR VPWR sky130_fd_sc_hd__decap_8
X_10620_ net286 net352 net153 VGND VGND VPWR VPWR _03460_ sky130_fd_sc_hd__and3_1
X_10551_ _03336_ _03382_ VGND VGND VPWR VPWR _03384_ sky130_fd_sc_hd__xnor2_1
XFILLER_50_791 VPWR VGND VPWR VGND sky130_ef_sc_hd__decap_12
Xrebuffer230 net932 VGND VGND VPWR VPWR net930 sky130_fd_sc_hd__clkbuf_2
X_10482_ _03277_ net710 _03308_ VGND VGND VPWR VPWR _03309_ sky130_fd_sc_hd__nand3_1
X_13270_ _05689_ _06348_ VGND VGND VPWR VPWR _06349_ sky130_fd_sc_hd__xnor2_1
XFILLER_6_637 VGND VGND VPWR VPWR sky130_fd_sc_hd__decap_6
XFILLER_5_125 VPWR VGND VPWR VGND sky130_ef_sc_hd__decap_12
X_12221_ net437 net446 net141 net586 VGND VGND VPWR VPWR _05204_ sky130_fd_sc_hd__nand4_1
XFILLER_5_169 VPWR VGND VPWR VGND sky130_ef_sc_hd__decap_12
XFILLER_135_373 VPWR VGND VPWR VGND sky130_ef_sc_hd__decap_12
XFILLER_123_546 VGND VGND VPWR VPWR sky130_fd_sc_hd__decap_3
XFILLER_118_83 VGND VGND VPWR VPWR sky130_fd_sc_hd__fill_1
XTAP_TAPCELL_ROW_75_1346 VGND VPWR sky130_fd_sc_hd__tapvpwrvgnd_1
X_12152_ _04843_ _04845_ _04975_ _04976_ VGND VGND VPWR VPWR _05129_ sky130_fd_sc_hd__and4b_1
XTAP_TAPCELL_ROW_9_420 VGND VPWR sky130_fd_sc_hd__tapvpwrvgnd_1
XFILLER_123_557 VGND VGND VPWR VPWR sky130_fd_sc_hd__decap_3
X_12083_ _05026_ _05053_ VGND VGND VPWR VPWR _05054_ sky130_fd_sc_hd__xor2_1
X_11103_ _03978_ _03987_ VGND VGND VPWR VPWR _03988_ sky130_fd_sc_hd__xnor2_2
X_11034_ _03910_ _03911_ VGND VGND VPWR VPWR _03912_ sky130_fd_sc_hd__nand2b_1
XFILLER_103_281 VGND VGND VPWR VPWR sky130_fd_sc_hd__decap_4
XFILLER_49_335 VGND VGND VPWR VPWR sky130_fd_sc_hd__fill_1
XFILLER_91_113 VGND VGND VPWR VPWR sky130_fd_sc_hd__decap_3
XFILLER_18_744 VPWR VGND VPWR VGND sky130_ef_sc_hd__decap_12
X_12985_ _05842_ _05857_ _05856_ VGND VGND VPWR VPWR _06039_ sky130_fd_sc_hd__o21a_1
X_11936_ _04890_ _04891_ _04889_ VGND VGND VPWR VPWR _04893_ sky130_fd_sc_hd__a21bo_1
XTAP_TAPCELL_ROW_86_1497 VGND VPWR sky130_fd_sc_hd__tapvpwrvgnd_1
XFILLER_17_276 VGND VGND VPWR VPWR sky130_fd_sc_hd__decap_4
XFILLER_33_714 VGND VGND VPWR VPWR sky130_fd_sc_hd__fill_1
X_11867_ _04805_ _04810_ _04809_ VGND VGND VPWR VPWR _04819_ sky130_fd_sc_hd__o21ai_1
XFILLER_32_224 VGND VGND VPWR VPWR sky130_fd_sc_hd__decap_3
X_11798_ _04738_ _04742_ VGND VGND VPWR VPWR _04743_ sky130_fd_sc_hd__xnor2_1
X_10818_ _03676_ VGND VGND VPWR VPWR _03677_ sky130_fd_sc_hd__inv_2
XTAP_TAPCELL_ROW_15_499 VGND VPWR sky130_fd_sc_hd__tapvpwrvgnd_1
X_10749_ _03567_ _03600_ VGND VGND VPWR VPWR _03601_ sky130_fd_sc_hd__and2b_1
XFILLER_118_318 VGND VGND VPWR VPWR sky130_fd_sc_hd__fill_2
XFILLER_9_464 VGND VGND VPWR VPWR sky130_fd_sc_hd__decap_8
Xoutput216 net216 VGND VGND VPWR VPWR out3[15] sky130_fd_sc_hd__buf_2
Xoutput205 net205 VGND VGND VPWR VPWR out2[5] sky130_fd_sc_hd__buf_2
X_13399_ clknet_3_1__leaf_clk _00016_ _00109_ VGND VGND VPWR VPWR net198 sky130_fd_sc_hd__dfrtp_1
X_12419_ _05417_ _05419_ _05403_ VGND VGND VPWR VPWR _05421_ sky130_fd_sc_hd__a21oi_1
X_07960_ _00437_ _00563_ _00562_ VGND VGND VPWR VPWR _00698_ sky130_fd_sc_hd__a21oi_2
XFILLER_114_579 VGND VGND VPWR VPWR sky130_fd_sc_hd__decap_8
X_06911_ _04145_ _04526_ _04548_ VGND VGND VPWR VPWR _04559_ sky130_fd_sc_hd__nor3_2
XFILLER_110_730 VPWR VGND VPWR VGND sky130_ef_sc_hd__decap_12
XFILLER_95_441 VGND VGND VPWR VPWR sky130_fd_sc_hd__decap_6
X_07891_ _00627_ _00628_ VGND VGND VPWR VPWR _00629_ sky130_fd_sc_hd__nor2_1
X_06842_ net98 net497 net506 net251 VGND VGND VPWR VPWR _03806_ sky130_fd_sc_hd__a22o_1
XFILLER_83_614 VGND VGND VPWR VPWR sky130_fd_sc_hd__fill_2
X_09630_ net314 _02283_ _02167_ VGND VGND VPWR VPWR _02385_ sky130_fd_sc_hd__a21oi_1
XFILLER_55_305 VPWR VGND VPWR VGND sky130_ef_sc_hd__decap_12
XTAP_TAPCELL_ROW_128_2092 VGND VPWR sky130_fd_sc_hd__tapvpwrvgnd_1
XTAP_TAPCELL_ROW_128_2081 VGND VPWR sky130_fd_sc_hd__tapvpwrvgnd_1
X_06773_ _03042_ VGND VGND VPWR VPWR _03053_ sky130_fd_sc_hd__inv_2
X_09561_ net406 net550 net548 VGND VGND VPWR VPWR _02310_ sky130_fd_sc_hd__and3_1
X_08512_ _01238_ _01240_ VGND VGND VPWR VPWR _01241_ sky130_fd_sc_hd__nor2_1
XFILLER_130_29 VPWR VGND VPWR VGND sky130_ef_sc_hd__decap_12
X_09492_ _01933_ _02105_ _02103_ VGND VGND VPWR VPWR _02235_ sky130_fd_sc_hd__a21oi_1
X_08443_ net535 net523 net122 _01108_ VGND VGND VPWR VPWR _01172_ sky130_fd_sc_hd__o211a_1
XFILLER_63_393 VPWR VGND VPWR VGND sky130_ef_sc_hd__decap_12
X_08374_ _01103_ _01104_ VGND VGND VPWR VPWR _01105_ sky130_fd_sc_hd__xor2_1
XFILLER_23_268 VGND VGND VPWR VPWR sky130_fd_sc_hd__decap_6
XTAP_TAPCELL_ROW_34_764 VGND VPWR sky130_fd_sc_hd__tapvpwrvgnd_1
XTAP_TAPCELL_ROW_34_775 VGND VPWR sky130_fd_sc_hd__tapvpwrvgnd_1
X_07325_ _06455_ _06615_ VGND VGND VPWR VPWR _06616_ sky130_fd_sc_hd__xnor2_1
X_07256_ _06506_ _06546_ VGND VGND VPWR VPWR _06547_ sky130_fd_sc_hd__nand2b_1
XFILLER_136_137 VGND VGND VPWR VPWR sky130_fd_sc_hd__decap_3
XTAP_TAPCELL_ROW_115_1903 VGND VPWR sky130_fd_sc_hd__tapvpwrvgnd_1
X_07187_ _06052_ _06019_ _06477_ _06478_ VGND VGND VPWR VPWR _06479_ sky130_fd_sc_hd__a211o_1
XFILLER_132_321 VPWR VGND VPWR VGND sky130_ef_sc_hd__decap_12
XFILLER_3_629 VPWR VGND VPWR VGND sky130_ef_sc_hd__decap_12
XFILLER_78_408 VGND VGND VPWR VPWR sky130_fd_sc_hd__fill_1
XTAP_TAPCELL_ROW_57_1087 VGND VPWR sky130_fd_sc_hd__tapvpwrvgnd_1
XFILLER_2_139 VGND VGND VPWR VPWR sky130_fd_sc_hd__fill_1
XFILLER_132_365 VPWR VGND VPWR VGND sky130_ef_sc_hd__decap_12
Xfanout410 net411 VGND VGND VPWR VPWR net410 sky130_fd_sc_hd__buf_2
XTAP_TAPCELL_ROW_57_1098 VGND VPWR sky130_fd_sc_hd__tapvpwrvgnd_1
Xfanout421 net424 VGND VGND VPWR VPWR net421 sky130_fd_sc_hd__clkbuf_2
Xfanout432 net3 VGND VGND VPWR VPWR net432 sky130_fd_sc_hd__buf_8
XFILLER_120_549 VGND VGND VPWR VPWR sky130_fd_sc_hd__fill_1
XFILLER_101_741 VGND VGND VPWR VPWR sky130_fd_sc_hd__decap_4
Xfanout465 net466 VGND VGND VPWR VPWR net465 sky130_fd_sc_hd__clkbuf_2
Xfanout443 net445 VGND VGND VPWR VPWR net443 sky130_fd_sc_hd__dlymetal6s2s_1
Xfanout454 net457 VGND VGND VPWR VPWR net454 sky130_fd_sc_hd__buf_2
XPHY_EDGE_ROW_122_Right_122 VGND VGND VPWR VPWR sky130_fd_sc_hd__decap_3
X_09828_ _02465_ _02473_ _02472_ VGND VGND VPWR VPWR _02601_ sky130_fd_sc_hd__a21bo_1
Xfanout498 net21 VGND VGND VPWR VPWR net498 sky130_fd_sc_hd__clkbuf_4
Xfanout476 net477 VGND VGND VPWR VPWR net476 sky130_fd_sc_hd__buf_2
XFILLER_101_785 VPWR VGND VPWR VGND sky130_ef_sc_hd__decap_12
Xfanout487 net488 VGND VGND VPWR VPWR net487 sky130_fd_sc_hd__buf_2
XFILLER_100_251 VGND VGND VPWR VPWR sky130_fd_sc_hd__fill_1
XFILLER_86_474 VGND VGND VPWR VPWR sky130_fd_sc_hd__fill_2
XFILLER_86_463 VGND VGND VPWR VPWR sky130_fd_sc_hd__decap_8
XFILLER_74_603 VPWR VGND VPWR VGND sky130_ef_sc_hd__decap_12
XTAP_TAPCELL_ROW_70_1276 VGND VPWR sky130_fd_sc_hd__tapvpwrvgnd_1
XFILLER_46_305 VGND VGND VPWR VPWR sky130_fd_sc_hd__decap_3
X_09759_ _02523_ _02524_ VGND VGND VPWR VPWR _02525_ sky130_fd_sc_hd__nor2_1
XFILLER_73_113 VPWR VGND VPWR VGND sky130_ef_sc_hd__decap_12
XFILLER_15_703 VGND VGND VPWR VPWR sky130_fd_sc_hd__fill_1
XFILLER_27_530 VGND VGND VPWR VPWR sky130_fd_sc_hd__fill_2
XFILLER_64_78 VGND VGND VPWR VPWR sky130_fd_sc_hd__decap_6
X_12770_ _05802_ _05803_ VGND VGND VPWR VPWR _05805_ sky130_fd_sc_hd__xnor2_1
X_11721_ _04648_ _04657_ VGND VGND VPWR VPWR _04659_ sky130_fd_sc_hd__nand2_1
XFILLER_42_533 VGND VGND VPWR VPWR sky130_fd_sc_hd__decap_3
XFILLER_80_11 VGND VGND VPWR VPWR sky130_fd_sc_hd__fill_1
X_11652_ net700 net516 net370 net368 VGND VGND VPWR VPWR _04584_ sky130_fd_sc_hd__and4_1
X_10603_ _03437_ _03438_ _03439_ VGND VGND VPWR VPWR _03441_ sky130_fd_sc_hd__a21o_1
XFILLER_42_599 VPWR VGND VPWR VGND sky130_ef_sc_hd__decap_12
X_13322_ net392 VGND VGND VPWR VPWR _00096_ sky130_fd_sc_hd__inv_2
XTAP_TAPCELL_ROW_12_458 VGND VPWR sky130_fd_sc_hd__tapvpwrvgnd_1
XFILLER_10_441 VPWR VGND VPWR VGND sky130_ef_sc_hd__decap_12
XFILLER_6_401 VPWR VGND VPWR VGND sky130_ef_sc_hd__decap_12
XTAP_TAPCELL_ROW_12_469 VGND VPWR sky130_fd_sc_hd__tapvpwrvgnd_1
X_11583_ _04401_ _04405_ _04400_ VGND VGND VPWR VPWR _04512_ sky130_fd_sc_hd__o21ba_1
XFILLER_127_148 VPWR VGND VPWR VGND sky130_ef_sc_hd__decap_12
X_10534_ net528 net637 _03088_ VGND VGND VPWR VPWR _03365_ sky130_fd_sc_hd__and3_1
XFILLER_136_671 VGND VGND VPWR VPWR sky130_fd_sc_hd__fill_1
XFILLER_129_93 VPWR VGND VPWR VGND sky130_ef_sc_hd__decap_12
X_10465_ net772 net52 VGND VGND VPWR VPWR _03290_ sky130_fd_sc_hd__nand2_1
X_13253_ _06097_ _06329_ VGND VGND VPWR VPWR _06330_ sky130_fd_sc_hd__xor2_1
XFILLER_135_181 VPWR VGND VPWR VGND sky130_ef_sc_hd__decap_12
X_10396_ _03076_ _03214_ VGND VGND VPWR VPWR _03215_ sky130_fd_sc_hd__xnor2_1
X_12204_ _05055_ _05074_ _05073_ VGND VGND VPWR VPWR _05185_ sky130_fd_sc_hd__o21bai_1
X_13184_ net412 _05386_ _05388_ _06142_ VGND VGND VPWR VPWR _06256_ sky130_fd_sc_hd__a2bb2o_1
XFILLER_6_489 VGND VGND VPWR VPWR sky130_fd_sc_hd__decap_3
X_12135_ net778 net779 _05108_ _05109_ VGND VGND VPWR VPWR _05110_ sky130_fd_sc_hd__o211ai_2
XFILLER_43_9 VGND VGND VPWR VPWR sky130_fd_sc_hd__fill_2
XFILLER_123_365 VGND VGND VPWR VPWR sky130_fd_sc_hd__fill_2
XFILLER_111_505 VPWR VGND VPWR VGND sky130_ef_sc_hd__decap_12
XFILLER_1_161 VGND VGND VPWR VPWR sky130_fd_sc_hd__decap_6
X_12066_ _05032_ _05033_ _05030_ VGND VGND VPWR VPWR _05035_ sky130_fd_sc_hd__a21bo_1
X_11017_ _03725_ _03891_ VGND VGND VPWR VPWR _03894_ sky130_fd_sc_hd__xor2_1
XTAP_TAPCELL_ROW_88_1526 VGND VPWR sky130_fd_sc_hd__tapvpwrvgnd_1
XFILLER_77_496 VGND VGND VPWR VPWR sky130_fd_sc_hd__decap_8
XFILLER_77_485 VGND VGND VPWR VPWR sky130_fd_sc_hd__decap_3
XFILLER_64_102 VPWR VGND VPWR VGND sky130_ef_sc_hd__decap_12
XFILLER_37_349 VGND VGND VPWR VPWR sky130_fd_sc_hd__decap_6
Xclkbuf_3_7__f_clk clknet_0_clk VGND VGND VPWR VPWR clknet_3_7__leaf_clk sky130_fd_sc_hd__clkbuf_16
X_12968_ _05389_ _06020_ VGND VGND VPWR VPWR _06021_ sky130_fd_sc_hd__xnor2_1
XFILLER_18_563 VGND VGND VPWR VPWR sky130_fd_sc_hd__fill_1
XPHY_EDGE_ROW_32_Left_169 VGND VGND VPWR VPWR sky130_fd_sc_hd__decap_3
XFILLER_72_190 VGND VGND VPWR VPWR sky130_fd_sc_hd__decap_6
X_11919_ _04870_ _04871_ VGND VGND VPWR VPWR _04875_ sky130_fd_sc_hd__xnor2_1
XFILLER_45_393 VPWR VGND VPWR VGND sky130_ef_sc_hd__decap_12
X_12899_ _05862_ _05945_ VGND VGND VPWR VPWR _05946_ sky130_fd_sc_hd__xnor2_1
XFILLER_14_791 VPWR VGND VPWR VGND sky130_ef_sc_hd__decap_12
XTAP_TAPCELL_ROW_31_723 VGND VPWR sky130_fd_sc_hd__tapvpwrvgnd_1
XTAP_TAPCELL_ROW_31_734 VGND VPWR sky130_fd_sc_hd__tapvpwrvgnd_1
X_07110_ _06323_ _06400_ VGND VGND VPWR VPWR _06402_ sky130_fd_sc_hd__xnor2_1
X_08090_ _00572_ _00705_ VGND VGND VPWR VPWR _00827_ sky130_fd_sc_hd__nand2b_1
XTAP_TAPCELL_ROW_99_1677 VGND VPWR sky130_fd_sc_hd__tapvpwrvgnd_1
X_07041_ _05877_ _05954_ net726 VGND VGND VPWR VPWR _05975_ sky130_fd_sc_hd__nand3_1
XPHY_EDGE_ROW_41_Left_178 VGND VGND VPWR VPWR sky130_fd_sc_hd__decap_3
XFILLER_88_717 VPWR VGND VPWR VGND sky130_ef_sc_hd__decap_12
XTAP_TAPCELL_ROW_110_1833 VGND VPWR sky130_fd_sc_hd__tapvpwrvgnd_1
X_08992_ _01550_ _01558_ _01557_ VGND VGND VPWR VPWR _01718_ sky130_fd_sc_hd__a21boi_2
X_07943_ _00493_ _00499_ _00498_ VGND VGND VPWR VPWR _00681_ sky130_fd_sc_hd__a21oi_1
XFILLER_68_430 VGND VGND VPWR VPWR sky130_fd_sc_hd__fill_1
X_07874_ _00580_ _00611_ VGND VGND VPWR VPWR _00612_ sky130_fd_sc_hd__and2b_1
XFILLER_56_603 VGND VGND VPWR VPWR sky130_fd_sc_hd__decap_8
X_09613_ _02364_ _02365_ VGND VGND VPWR VPWR _02367_ sky130_fd_sc_hd__xor2_2
X_06825_ _03565_ _03598_ VGND VGND VPWR VPWR _03620_ sky130_fd_sc_hd__xor2_1
XFILLER_56_636 VGND VGND VPWR VPWR sky130_fd_sc_hd__decap_8
XFILLER_18_38 VPWR VGND VPWR VGND sky130_ef_sc_hd__decap_12
XTAP_TAPCELL_ROW_39_834 VGND VPWR sky130_fd_sc_hd__tapvpwrvgnd_1
XTAP_TAPCELL_ROW_39_845 VGND VPWR sky130_fd_sc_hd__tapvpwrvgnd_1
XFILLER_83_444 VGND VGND VPWR VPWR sky130_fd_sc_hd__decap_4
XFILLER_71_617 VGND VGND VPWR VPWR sky130_fd_sc_hd__fill_1
XFILLER_55_146 VGND VGND VPWR VPWR sky130_fd_sc_hd__fill_1
XFILLER_55_135 VGND VGND VPWR VPWR sky130_fd_sc_hd__fill_1
XPHY_EDGE_ROW_50_Left_187 VGND VGND VPWR VPWR sky130_fd_sc_hd__decap_3
X_06756_ _02845_ _02856_ VGND VGND VPWR VPWR _02867_ sky130_fd_sc_hd__or2_1
XFILLER_64_680 VGND VGND VPWR VPWR sky130_fd_sc_hd__fill_1
X_09544_ net336 net325 VGND VGND VPWR VPWR _02292_ sky130_fd_sc_hd__nand2_1
XFILLER_43_319 VGND VGND VPWR VPWR sky130_fd_sc_hd__fill_1
X_09475_ _02215_ _02216_ VGND VGND VPWR VPWR _02217_ sky130_fd_sc_hd__nand2b_1
X_06687_ net483 VGND VGND VPWR VPWR _02120_ sky130_fd_sc_hd__inv_2
XFILLER_70_127 VPWR VGND VPWR VGND sky130_ef_sc_hd__decap_12
XFILLER_24_533 VPWR VGND VPWR VGND sky130_ef_sc_hd__decap_12
XFILLER_24_555 VPWR VGND VPWR VGND sky130_ef_sc_hd__decap_12
X_08426_ _01154_ _01155_ VGND VGND VPWR VPWR _01156_ sky130_fd_sc_hd__nor2_1
XTAP_TAPCELL_ROW_121_1995 VGND VPWR sky130_fd_sc_hd__tapvpwrvgnd_1
XTAP_TAPCELL_ROW_121_1984 VGND VPWR sky130_fd_sc_hd__tapvpwrvgnd_1
Xclkload3 clknet_3_3__leaf_clk VGND VGND VPWR VPWR clkload3/X sky130_fd_sc_hd__clkbuf_8
XFILLER_109_104 VGND VGND VPWR VPWR sky130_fd_sc_hd__decap_3
X_08357_ _01086_ _01087_ _01088_ VGND VGND VPWR VPWR _01089_ sky130_fd_sc_hd__nor3_1
X_08288_ _00920_ _00922_ _01021_ VGND VGND VPWR VPWR _01023_ sky130_fd_sc_hd__or3b_1
X_07308_ _06438_ _06441_ _06440_ VGND VGND VPWR VPWR _06599_ sky130_fd_sc_hd__o21bai_1
XFILLER_50_47 VGND VGND VPWR VPWR sky130_fd_sc_hd__fill_2
XFILLER_124_107 VGND VGND VPWR VPWR sky130_fd_sc_hd__fill_1
X_07239_ _06407_ _06416_ _06415_ VGND VGND VPWR VPWR _06530_ sky130_fd_sc_hd__a21o_1
XTAP_TAPCELL_ROW_59_1127 VGND VPWR sky130_fd_sc_hd__tapvpwrvgnd_1
XTAP_TAPCELL_ROW_59_1116 VGND VPWR sky130_fd_sc_hd__tapvpwrvgnd_1
X_10250_ _03050_ _03056_ VGND VGND VPWR VPWR _00019_ sky130_fd_sc_hd__xor2_1
XFILLER_133_641 VPWR VGND VPWR VGND sky130_ef_sc_hd__decap_12
XFILLER_121_803 VGND VGND VPWR VPWR sky130_fd_sc_hd__fill_1
XTAP_TAPCELL_ROW_72_1305 VGND VPWR sky130_fd_sc_hd__tapvpwrvgnd_1
XFILLER_59_23 VGND VGND VPWR VPWR sky130_fd_sc_hd__fill_1
XFILLER_133_685 VPWR VGND VPWR VGND sky130_ef_sc_hd__decap_12
XFILLER_132_173 VGND VGND VPWR VPWR sky130_fd_sc_hd__decap_3
XFILLER_120_313 VPWR VGND VPWR VGND sky130_ef_sc_hd__decap_12
X_10181_ _02978_ _02979_ _02977_ VGND VGND VPWR VPWR _02981_ sky130_fd_sc_hd__o21bai_1
Xfanout262 net91 VGND VGND VPWR VPWR net262 sky130_fd_sc_hd__buf_2
Xfanout251 net99 VGND VGND VPWR VPWR net251 sky130_fd_sc_hd__clkbuf_4
XFILLER_59_463 VGND VGND VPWR VPWR sky130_fd_sc_hd__fill_1
XFILLER_47_614 VGND VGND VPWR VPWR sky130_fd_sc_hd__fill_2
Xfanout273 net88 VGND VGND VPWR VPWR net273 sky130_fd_sc_hd__clkbuf_2
XFILLER_75_44 VPWR VGND VPWR VGND sky130_ef_sc_hd__decap_12
XFILLER_75_22 VGND VGND VPWR VPWR sky130_fd_sc_hd__decap_8
Xfanout295 net78 VGND VGND VPWR VPWR net295 sky130_fd_sc_hd__clkbuf_2
Xfanout284 net80 VGND VGND VPWR VPWR net284 sky130_fd_sc_hd__buf_2
XFILLER_75_99 VGND VGND VPWR VPWR sky130_fd_sc_hd__decap_3
XFILLER_55_680 VGND VGND VPWR VPWR sky130_fd_sc_hd__fill_2
XTAP_TAPCELL_ROW_17_528 VGND VPWR sky130_fd_sc_hd__tapvpwrvgnd_1
X_12822_ _05821_ _05860_ VGND VGND VPWR VPWR _05861_ sky130_fd_sc_hd__and2b_1
XFILLER_61_149 VGND VGND VPWR VPWR sky130_fd_sc_hd__decap_4
XTAP_TAPCELL_ROW_17_539 VGND VPWR sky130_fd_sc_hd__tapvpwrvgnd_1
X_12753_ _05780_ _05783_ _05784_ VGND VGND VPWR VPWR _05786_ sky130_fd_sc_hd__and3_1
XFILLER_27_393 VPWR VGND VPWR VGND sky130_ef_sc_hd__decap_12
XTAP_TAPCELL_ROW_83_1456 VGND VPWR sky130_fd_sc_hd__tapvpwrvgnd_1
X_11704_ _04638_ _04639_ VGND VGND VPWR VPWR _04640_ sky130_fd_sc_hd__nand2_1
XFILLER_42_363 VGND VGND VPWR VPWR sky130_fd_sc_hd__fill_1
X_12684_ net499 net492 net660 net658 VGND VGND VPWR VPWR _05710_ sky130_fd_sc_hd__and4_1
XFILLER_42_374 VGND VGND VPWR VPWR sky130_fd_sc_hd__decap_3
X_11635_ _04508_ _04567_ VGND VGND VPWR VPWR _04568_ sky130_fd_sc_hd__xnor2_1
XFILLER_24_81 VGND VGND VPWR VPWR sky130_fd_sc_hd__decap_3
XFILLER_11_783 VGND VGND VPWR VPWR sky130_fd_sc_hd__fill_1
XFILLER_7_721 VGND VGND VPWR VPWR sky130_fd_sc_hd__decap_6
X_11566_ _04383_ _04386_ _04491_ VGND VGND VPWR VPWR _04493_ sky130_fd_sc_hd__or3_1
X_13305_ net395 VGND VGND VPWR VPWR _00079_ sky130_fd_sc_hd__inv_2
XFILLER_128_457 VPWR VGND VPWR VGND sky130_ef_sc_hd__decap_12
X_10517_ _03344_ _03345_ VGND VGND VPWR VPWR _03347_ sky130_fd_sc_hd__and2b_1
XFILLER_7_765 VPWR VGND VPWR VGND sky130_ef_sc_hd__decap_12
XFILLER_6_253 VPWR VGND VPWR VGND sky130_ef_sc_hd__decap_12
XFILLER_109_671 VGND VGND VPWR VPWR sky130_fd_sc_hd__fill_1
X_11497_ _04299_ _04310_ _04298_ VGND VGND VPWR VPWR _04418_ sky130_fd_sc_hd__a21bo_1
X_13236_ _06207_ _06312_ VGND VGND VPWR VPWR _06313_ sky130_fd_sc_hd__xnor2_1
X_10448_ _03261_ _03269_ _03271_ VGND VGND VPWR VPWR _03272_ sky130_fd_sc_hd__nand3_1
XFILLER_97_525 VPWR VGND VPWR VGND sky130_ef_sc_hd__decap_12
X_10379_ net266 net272 _03196_ VGND VGND VPWR VPWR _03197_ sky130_fd_sc_hd__a21o_1
X_13167_ _06235_ _06236_ VGND VGND VPWR VPWR _06238_ sky130_fd_sc_hd__and2_1
XFILLER_97_569 VGND VGND VPWR VPWR sky130_fd_sc_hd__fill_2
XFILLER_69_249 VPWR VGND VPWR VGND sky130_ef_sc_hd__decap_12
X_12118_ net314 net370 net368 net335 VGND VGND VPWR VPWR _05092_ sky130_fd_sc_hd__a22oi_2
X_13098_ _06159_ _06160_ VGND VGND VPWR VPWR _06163_ sky130_fd_sc_hd__xnor2_1
XFILLER_111_357 VGND VGND VPWR VPWR sky130_fd_sc_hd__fill_2
X_12049_ _04720_ _04875_ _05016_ VGND VGND VPWR VPWR _05017_ sky130_fd_sc_hd__a21oi_1
XFILLER_38_603 VGND VGND VPWR VPWR sky130_fd_sc_hd__decap_8
XFILLER_78_783 VGND VGND VPWR VPWR sky130_fd_sc_hd__decap_4
XTAP_TAPCELL_ROW_125_2051 VGND VPWR sky130_fd_sc_hd__tapvpwrvgnd_1
XTAP_TAPCELL_ROW_125_2040 VGND VPWR sky130_fd_sc_hd__tapvpwrvgnd_1
X_07590_ _00328_ _00329_ VGND VGND VPWR VPWR _00330_ sky130_fd_sc_hd__nand2b_1
XTAP_TAPCELL_ROW_36_804 VGND VPWR sky130_fd_sc_hd__tapvpwrvgnd_1
XFILLER_45_190 VGND VGND VPWR VPWR sky130_fd_sc_hd__decap_3
X_09260_ net466 _01822_ _01823_ _01824_ VGND VGND VPWR VPWR _01984_ sky130_fd_sc_hd__a2bb2o_1
XFILLER_21_503 VGND VGND VPWR VPWR sky130_fd_sc_hd__fill_1
X_08211_ _06587_ _00833_ _00942_ VGND VGND VPWR VPWR _00946_ sky130_fd_sc_hd__or3_1
X_09191_ _01915_ VGND VGND VPWR VPWR _01916_ sky130_fd_sc_hd__inv_2
XFILLER_60_193 VGND VGND VPWR VPWR sky130_fd_sc_hd__decap_3
XFILLER_119_424 VPWR VGND VPWR VGND sky130_ef_sc_hd__decap_12
X_08142_ _00758_ _00764_ _00763_ VGND VGND VPWR VPWR _00878_ sky130_fd_sc_hd__a21oi_1
X_08073_ _00778_ _00809_ VGND VGND VPWR VPWR _00810_ sky130_fd_sc_hd__and2_1
XFILLER_107_608 VGND VGND VPWR VPWR sky130_fd_sc_hd__decap_8
X_07024_ _04035_ _04057_ _05768_ VGND VGND VPWR VPWR _05790_ sky130_fd_sc_hd__nor3_1
X_08975_ net795 net328 _01698_ _01699_ VGND VGND VPWR VPWR _01701_ sky130_fd_sc_hd__nand4_1
XTAP_TAPCELL_ROW_54_1057 VGND VPWR sky130_fd_sc_hd__tapvpwrvgnd_1
XTAP_TAPCELL_ROW_54_1046 VGND VPWR sky130_fd_sc_hd__tapvpwrvgnd_1
X_07926_ _00662_ _00663_ VGND VGND VPWR VPWR _00664_ sky130_fd_sc_hd__and2b_1
XFILLER_75_208 VGND VGND VPWR VPWR sky130_fd_sc_hd__fill_1
XFILLER_29_37 VGND VGND VPWR VPWR sky130_fd_sc_hd__decap_8
XFILLER_130_699 VGND VGND VPWR VPWR sky130_fd_sc_hd__fill_1
XFILLER_29_625 VGND VGND VPWR VPWR sky130_fd_sc_hd__decap_3
X_07857_ _00594_ _00593_ VGND VGND VPWR VPWR _00595_ sky130_fd_sc_hd__and2b_1
XFILLER_56_433 VGND VGND VPWR VPWR sky130_fd_sc_hd__fill_2
XFILLER_17_809 VGND VGND VPWR VPWR sky130_fd_sc_hd__fill_2
X_06808_ _03412_ _03423_ VGND VGND VPWR VPWR _03434_ sky130_fd_sc_hd__nor2_1
XFILLER_83_263 VGND VGND VPWR VPWR sky130_fd_sc_hd__fill_1
X_07788_ _00520_ _00525_ VGND VGND VPWR VPWR _00527_ sky130_fd_sc_hd__nor2_1
XFILLER_56_499 VGND VGND VPWR VPWR sky130_fd_sc_hd__fill_1
XFILLER_56_477 VGND VGND VPWR VPWR sky130_fd_sc_hd__decap_6
X_06739_ _02642_ _02675_ VGND VGND VPWR VPWR _02686_ sky130_fd_sc_hd__xnor2_1
X_09527_ _02270_ _02271_ VGND VGND VPWR VPWR _02274_ sky130_fd_sc_hd__and2_1
XFILLER_71_447 VGND VGND VPWR VPWR sky130_fd_sc_hd__fill_1
XFILLER_45_69 VGND VGND VPWR VPWR sky130_fd_sc_hd__decap_8
XFILLER_24_363 VGND VGND VPWR VPWR sky130_fd_sc_hd__fill_1
X_09458_ _02008_ _02010_ _02007_ VGND VGND VPWR VPWR _02199_ sky130_fd_sc_hd__o21ba_1
XFILLER_24_385 VPWR VGND VPWR VGND sky130_ef_sc_hd__decap_12
X_09389_ _02106_ _02122_ VGND VGND VPWR VPWR _02123_ sky130_fd_sc_hd__xor2_1
XFILLER_101_86 VGND VGND VPWR VPWR sky130_fd_sc_hd__fill_2
X_08409_ _01137_ _01138_ VGND VGND VPWR VPWR _01139_ sky130_fd_sc_hd__nor2_1
XFILLER_61_57 VGND VGND VPWR VPWR sky130_fd_sc_hd__fill_1
X_11420_ net647 net636 net481 VGND VGND VPWR VPWR _04334_ sky130_fd_sc_hd__o21ai_1
XFILLER_124_3 VPWR VGND VPWR VGND sky130_ef_sc_hd__decap_12
XTAP_TAPCELL_ROW_22_597 VGND VPWR sky130_fd_sc_hd__tapvpwrvgnd_1
X_11351_ _03889_ _04258_ VGND VGND VPWR VPWR _04259_ sky130_fd_sc_hd__xnor2_1
X_10302_ net458 net564 net561 net467 VGND VGND VPWR VPWR _03113_ sky130_fd_sc_hd__a22oi_1
XFILLER_4_713 VPWR VGND VPWR VGND sky130_ef_sc_hd__decap_12
XFILLER_125_449 VPWR VGND VPWR VGND sky130_ef_sc_hd__decap_12
XFILLER_4_757 VPWR VGND VPWR VGND sky130_ef_sc_hd__decap_12
XFILLER_3_223 VGND VGND VPWR VPWR sky130_fd_sc_hd__fill_1
X_11282_ _04171_ _04182_ VGND VGND VPWR VPWR _04183_ sky130_fd_sc_hd__nor2_1
XFILLER_105_151 VPWR VGND VPWR VGND sky130_ef_sc_hd__decap_12
X_10233_ _03030_ _03036_ _03037_ VGND VGND VPWR VPWR _03038_ sky130_fd_sc_hd__and3_4
X_13021_ _06076_ _06077_ VGND VGND VPWR VPWR _06079_ sky130_fd_sc_hd__xor2_1
X_10164_ _02958_ _02961_ VGND VGND VPWR VPWR _02962_ sky130_fd_sc_hd__and2_1
XFILLER_126_83 VGND VGND VPWR VPWR sky130_fd_sc_hd__fill_1
XFILLER_120_132 VGND VGND VPWR VPWR sky130_fd_sc_hd__decap_8
XFILLER_120_165 VPWR VGND VPWR VGND sky130_ef_sc_hd__decap_12
X_10095_ _02884_ _02885_ VGND VGND VPWR VPWR _02886_ sky130_fd_sc_hd__nor2_1
XFILLER_19_113 VPWR VGND VPWR VGND sky130_ef_sc_hd__decap_12
XFILLER_75_797 VGND VGND VPWR VPWR sky130_fd_sc_hd__decap_8
XFILLER_74_263 VPWR VGND VPWR VGND sky130_ef_sc_hd__decap_12
XFILLER_47_466 VPWR VGND VPWR VGND sky130_ef_sc_hd__decap_12
XFILLER_34_105 VGND VGND VPWR VPWR sky130_fd_sc_hd__decap_8
XFILLER_35_617 VGND VGND VPWR VPWR sky130_fd_sc_hd__fill_2
X_12805_ _05677_ _05841_ VGND VGND VPWR VPWR _05842_ sky130_fd_sc_hd__xnor2_1
XPHY_EDGE_ROW_106_Left_243 VGND VGND VPWR VPWR sky130_fd_sc_hd__decap_3
X_10997_ _03868_ _03870_ VGND VGND VPWR VPWR _03872_ sky130_fd_sc_hd__or2_1
X_12736_ _05755_ _05766_ VGND VGND VPWR VPWR _05767_ sky130_fd_sc_hd__xnor2_1
XFILLER_89_6 VGND VGND VPWR VPWR sky130_fd_sc_hd__fill_1
X_12667_ _05525_ _05690_ VGND VGND VPWR VPWR _05692_ sky130_fd_sc_hd__xnor2_1
XFILLER_42_193 VGND VGND VPWR VPWR sky130_fd_sc_hd__decap_3
X_11618_ _04422_ _04424_ VGND VGND VPWR VPWR _04550_ sky130_fd_sc_hd__nand2b_1
XTAP_TAPCELL_ROW_41_862 VGND VPWR sky130_fd_sc_hd__tapvpwrvgnd_1
XTAP_TAPCELL_ROW_41_873 VGND VPWR sky130_fd_sc_hd__tapvpwrvgnd_1
XFILLER_129_777 VGND VGND VPWR VPWR sky130_fd_sc_hd__decap_6
XFILLER_11_591 VPWR VGND VPWR VGND sky130_ef_sc_hd__decap_12
X_12598_ _05613_ _05614_ _05607_ VGND VGND VPWR VPWR _05617_ sky130_fd_sc_hd__a21o_1
XTAP_TAPCELL_ROW_96_1636 VGND VPWR sky130_fd_sc_hd__tapvpwrvgnd_1
Xmax_cap226 _03043_ VGND VGND VPWR VPWR net226 sky130_fd_sc_hd__clkbuf_2
XFILLER_7_573 VPWR VGND VPWR VGND sky130_ef_sc_hd__decap_12
X_11549_ _04365_ _04473_ VGND VGND VPWR VPWR _04475_ sky130_fd_sc_hd__and2_1
Xmax_cap248 _02030_ VGND VGND VPWR VPWR net248 sky130_fd_sc_hd__buf_1
Xmax_cap237 _03159_ VGND VGND VPWR VPWR net237 sky130_fd_sc_hd__clkbuf_2
XPHY_EDGE_ROW_115_Left_252 VGND VGND VPWR VPWR sky130_fd_sc_hd__decap_3
X_13219_ _06291_ _06293_ _06280_ VGND VGND VPWR VPWR _06295_ sky130_fd_sc_hd__o21ai_1
XFILLER_111_110 VGND VGND VPWR VPWR sky130_fd_sc_hd__fill_2
XFILLER_85_517 VPWR VGND VPWR VGND sky130_ef_sc_hd__decap_12
XFILLER_112_699 VGND VGND VPWR VPWR sky130_fd_sc_hd__fill_1
X_08760_ _01453_ _01486_ VGND VGND VPWR VPWR _01487_ sky130_fd_sc_hd__xnor2_1
X_07711_ _00448_ _00449_ VGND VGND VPWR VPWR _00450_ sky130_fd_sc_hd__nor2_1
X_08691_ _01416_ _01417_ _01418_ VGND VGND VPWR VPWR _01419_ sky130_fd_sc_hd__nand3_1
XFILLER_66_753 VGND VGND VPWR VPWR sky130_fd_sc_hd__decap_3
XFILLER_38_433 VGND VGND VPWR VPWR sky130_fd_sc_hd__fill_1
XFILLER_93_561 VPWR VGND VPWR VGND sky130_ef_sc_hd__decap_12
X_07642_ _00380_ _00381_ VGND VGND VPWR VPWR _00382_ sky130_fd_sc_hd__xnor2_1
XFILLER_66_786 VGND VGND VPWR VPWR sky130_fd_sc_hd__fill_1
XTAP_TAPCELL_ROW_49_984 VGND VPWR sky130_fd_sc_hd__tapvpwrvgnd_1
XPHY_EDGE_ROW_124_Left_261 VGND VGND VPWR VPWR sky130_fd_sc_hd__decap_3
X_07573_ _00307_ _00312_ VGND VGND VPWR VPWR _00313_ sky130_fd_sc_hd__xnor2_1
XTAP_TAPCELL_ROW_105_1765 VGND VPWR sky130_fd_sc_hd__tapvpwrvgnd_1
X_09312_ net516 _02208_ _01682_ _01861_ VGND VGND VPWR VPWR _02039_ sky130_fd_sc_hd__o31ai_2
XFILLER_22_801 VGND VGND VPWR VPWR sky130_fd_sc_hd__decap_6
XFILLER_80_277 VGND VGND VPWR VPWR sky130_fd_sc_hd__decap_8
X_09243_ _01853_ _01855_ VGND VGND VPWR VPWR _01967_ sky130_fd_sc_hd__nor2_1
XFILLER_21_322 VGND VGND VPWR VPWR sky130_fd_sc_hd__decap_3
XFILLER_119_210 VGND VGND VPWR VPWR sky130_fd_sc_hd__decap_4
X_09174_ _01895_ _01896_ _01729_ _01731_ VGND VGND VPWR VPWR _01899_ sky130_fd_sc_hd__o211ai_2
X_08125_ _00757_ _00768_ _00767_ VGND VGND VPWR VPWR _00861_ sky130_fd_sc_hd__a21o_1
XFILLER_119_265 VPWR VGND VPWR VGND sky130_ef_sc_hd__decap_12
XPHY_EDGE_ROW_133_Left_270 VGND VGND VPWR VPWR sky130_fd_sc_hd__decap_3
XFILLER_107_449 VGND VGND VPWR VPWR sky130_fd_sc_hd__decap_8
X_08056_ _00459_ _00602_ _00601_ VGND VGND VPWR VPWR _00793_ sky130_fd_sc_hd__a21bo_1
XFILLER_103_600 VGND VGND VPWR VPWR sky130_fd_sc_hd__decap_8
X_07007_ _05593_ _05374_ VGND VGND VPWR VPWR _05604_ sky130_fd_sc_hd__and2b_1
XFILLER_1_727 VGND VGND VPWR VPWR sky130_fd_sc_hd__fill_1
XFILLER_115_471 VPWR VGND VPWR VGND sky130_ef_sc_hd__decap_12
XFILLER_103_611 VGND VGND VPWR VPWR sky130_fd_sc_hd__decap_4
XFILLER_0_237 VGND VGND VPWR VPWR sky130_fd_sc_hd__decap_4
Xinput127 w23[5] VGND VGND VPWR VPWR net127 sky130_fd_sc_hd__buf_1
Xinput105 w20[7] VGND VGND VPWR VPWR net105 sky130_fd_sc_hd__buf_2
Xinput116 w22[2] VGND VGND VPWR VPWR net116 sky130_fd_sc_hd__buf_1
XFILLER_76_539 VGND VGND VPWR VPWR sky130_fd_sc_hd__fill_1
XFILLER_76_528 VGND VGND VPWR VPWR sky130_fd_sc_hd__decap_4
XFILLER_69_580 VGND VGND VPWR VPWR sky130_fd_sc_hd__decap_4
X_08958_ net517 net929 net63 net64 VGND VGND VPWR VPWR _01684_ sky130_fd_sc_hd__nand4_1
XFILLER_57_720 VGND VGND VPWR VPWR sky130_fd_sc_hd__decap_8
Xinput138 w31[0] VGND VGND VPWR VPWR net138 sky130_fd_sc_hd__buf_1
Xinput149 w32[3] VGND VGND VPWR VPWR net149 sky130_fd_sc_hd__dlymetal6s2s_1
X_08889_ _01461_ _01464_ _01613_ VGND VGND VPWR VPWR _01615_ sky130_fd_sc_hd__nand3_1
X_07909_ _00645_ _00646_ VGND VGND VPWR VPWR _00647_ sky130_fd_sc_hd__nor2_1
XFILLER_57_764 VGND VGND VPWR VPWR sky130_fd_sc_hd__decap_8
XFILLER_57_753 VGND VGND VPWR VPWR sky130_fd_sc_hd__fill_1
XFILLER_72_701 VPWR VGND VPWR VGND sky130_ef_sc_hd__decap_12
X_10920_ net400 net577 net575 VGND VGND VPWR VPWR _03788_ sky130_fd_sc_hd__and3_1
XFILLER_29_488 VGND VGND VPWR VPWR sky130_fd_sc_hd__decap_8
XFILLER_112_41 VPWR VGND VPWR VGND sky130_ef_sc_hd__decap_12
XFILLER_71_222 VGND VGND VPWR VPWR sky130_fd_sc_hd__fill_2
XTAP_TAPCELL_ROW_67_1237 VGND VPWR sky130_fd_sc_hd__tapvpwrvgnd_1
XTAP_TAPCELL_ROW_67_1226 VGND VPWR sky130_fd_sc_hd__tapvpwrvgnd_1
XFILLER_56_285 VGND VGND VPWR VPWR sky130_fd_sc_hd__decap_6
XFILLER_112_85 VPWR VGND VPWR VGND sky130_ef_sc_hd__decap_12
XTAP_TAPCELL_ROW_27_667 VGND VPWR sky130_fd_sc_hd__tapvpwrvgnd_1
XTAP_TAPCELL_ROW_27_678 VGND VPWR sky130_fd_sc_hd__tapvpwrvgnd_1
X_10851_ _03706_ _03710_ VGND VGND VPWR VPWR _03712_ sky130_fd_sc_hd__xnor2_1
XTAP_TAPCELL_ROW_80_1415 VGND VPWR sky130_fd_sc_hd__tapvpwrvgnd_1
XFILLER_12_300 VGND VGND VPWR VPWR sky130_fd_sc_hd__fill_1
X_10782_ net311 net52 VGND VGND VPWR VPWR _03637_ sky130_fd_sc_hd__and2_1
XFILLER_72_78 VGND VGND VPWR VPWR sky130_fd_sc_hd__fill_1
X_12521_ _05518_ _05531_ VGND VGND VPWR VPWR _05532_ sky130_fd_sc_hd__xor2_1
X_12452_ _05452_ _05454_ _05433_ VGND VGND VPWR VPWR _05457_ sky130_fd_sc_hd__a21o_1
X_11403_ _04094_ _04195_ _03985_ VGND VGND VPWR VPWR _04315_ sky130_fd_sc_hd__o21ba_1
XFILLER_126_725 VPWR VGND VPWR VGND sky130_ef_sc_hd__decap_12
X_12383_ _05371_ _05380_ VGND VGND VPWR VPWR _05381_ sky130_fd_sc_hd__xnor2_1
XFILLER_126_769 VPWR VGND VPWR VGND sky130_ef_sc_hd__decap_12
XFILLER_99_609 VGND VGND VPWR VPWR sky130_fd_sc_hd__decap_6
XTAP_TAPCELL_ROW_78_1388 VGND VPWR sky130_fd_sc_hd__tapvpwrvgnd_1
X_11334_ _02098_ net565 net272 net89 VGND VGND VPWR VPWR _04240_ sky130_fd_sc_hd__and4_1
XFILLER_98_119 VGND VGND VPWR VPWR sky130_fd_sc_hd__decap_3
XFILLER_97_31 VGND VGND VPWR VPWR sky130_fd_sc_hd__decap_8
X_11265_ _04161_ _04162_ VGND VGND VPWR VPWR _04164_ sky130_fd_sc_hd__xnor2_1
XTAP_TAPCELL_ROW_91_1566 VGND VPWR sky130_fd_sc_hd__tapvpwrvgnd_1
X_10216_ _03007_ _03010_ _03013_ _03017_ VGND VGND VPWR VPWR _03019_ sky130_fd_sc_hd__o211a_4
XFILLER_4_587 VGND VGND VPWR VPWR sky130_fd_sc_hd__fill_1
X_13004_ _06058_ _06059_ VGND VGND VPWR VPWR _06060_ sky130_fd_sc_hd__nand2_1
X_11196_ _04086_ _04087_ VGND VGND VPWR VPWR _04089_ sky130_fd_sc_hd__xor2_1
XFILLER_121_485 VPWR VGND VPWR VGND sky130_ef_sc_hd__decap_12
XFILLER_94_325 VGND VGND VPWR VPWR sky130_fd_sc_hd__decap_8
X_10147_ net468 net563 VGND VGND VPWR VPWR _02944_ sky130_fd_sc_hd__nand2_1
XTAP_TAPCELL_ROW_7_392 VGND VPWR sky130_fd_sc_hd__tapvpwrvgnd_1
X_10078_ _02866_ _02868_ _02819_ VGND VGND VPWR VPWR _02869_ sky130_fd_sc_hd__or3b_2
XFILLER_48_753 VGND VGND VPWR VPWR sky130_fd_sc_hd__decap_3
XFILLER_48_731 VPWR VGND VPWR VGND sky130_ef_sc_hd__decap_12
XFILLER_75_561 VGND VGND VPWR VPWR sky130_fd_sc_hd__decap_3
XFILLER_75_550 VGND VGND VPWR VPWR sky130_fd_sc_hd__decap_8
XFILLER_63_712 VPWR VGND VPWR VGND sky130_ef_sc_hd__decap_12
XFILLER_47_263 VPWR VGND VPWR VGND sky130_ef_sc_hd__decap_12
XFILLER_35_414 VGND VGND VPWR VPWR sky130_fd_sc_hd__decap_3
XFILLER_90_531 VGND VGND VPWR VPWR sky130_fd_sc_hd__fill_1
XFILLER_62_222 VGND VGND VPWR VPWR sky130_fd_sc_hd__decap_3
XTAP_TAPCELL_ROW_46_943 VGND VPWR sky130_fd_sc_hd__tapvpwrvgnd_1
XTAP_TAPCELL_ROW_46_932 VGND VPWR sky130_fd_sc_hd__tapvpwrvgnd_1
XFILLER_35_447 VGND VGND VPWR VPWR sky130_fd_sc_hd__fill_1
XFILLER_63_778 VGND VGND VPWR VPWR sky130_fd_sc_hd__decap_6
XFILLER_35_458 VPWR VGND VPWR VGND sky130_ef_sc_hd__decap_12
XFILLER_16_672 VGND VGND VPWR VPWR sky130_fd_sc_hd__fill_1
XFILLER_16_694 VGND VGND VPWR VPWR sky130_fd_sc_hd__decap_6
Xclkbuf_0_clk clk VGND VGND VPWR VPWR clknet_0_clk sky130_fd_sc_hd__clkbuf_16
X_12719_ net315 _05748_ _05747_ VGND VGND VPWR VPWR _05749_ sky130_fd_sc_hd__a21oi_1
XFILLER_129_530 VPWR VGND VPWR VGND sky130_ef_sc_hd__decap_12
XTAP_TAPCELL_ROW_100_1695 VGND VPWR sky130_fd_sc_hd__tapvpwrvgnd_1
XFILLER_129_585 VGND VGND VPWR VPWR sky130_fd_sc_hd__fill_2
XFILLER_7_51 VGND VGND VPWR VPWR sky130_fd_sc_hd__decap_4
XTAP_TAPCELL_ROW_133_2161 VGND VPWR sky130_fd_sc_hd__tapvpwrvgnd_1
XTAP_TAPCELL_ROW_133_2150 VGND VPWR sky130_fd_sc_hd__tapvpwrvgnd_1
X_09930_ _02710_ _02711_ VGND VGND VPWR VPWR _02712_ sky130_fd_sc_hd__and2b_1
XPHY_EDGE_ROW_15_Right_15 VGND VGND VPWR VPWR sky130_fd_sc_hd__decap_3
XFILLER_97_130 VGND VGND VPWR VPWR sky130_fd_sc_hd__decap_8
X_09861_ _02510_ _02635_ VGND VGND VPWR VPWR _02636_ sky130_fd_sc_hd__xnor2_1
XFILLER_58_506 VGND VGND VPWR VPWR sky130_fd_sc_hd__decap_8
XTAP_TAPCELL_ROW_51_1005 VGND VPWR sky130_fd_sc_hd__tapvpwrvgnd_1
X_09792_ _02552_ _02559_ VGND VGND VPWR VPWR _02561_ sky130_fd_sc_hd__or2_1
X_08812_ _01519_ _01538_ VGND VGND VPWR VPWR _01539_ sky130_fd_sc_hd__xnor2_1
X_08743_ net573 net262 VGND VGND VPWR VPWR _01470_ sky130_fd_sc_hd__nand2_1
XFILLER_73_509 VPWR VGND VPWR VGND sky130_ef_sc_hd__decap_12
XFILLER_54_701 VGND VGND VPWR VPWR sky130_fd_sc_hd__fill_1
X_08674_ _01392_ _01401_ VGND VGND VPWR VPWR _01402_ sky130_fd_sc_hd__xnor2_1
XFILLER_53_211 VGND VGND VPWR VPWR sky130_fd_sc_hd__decap_8
XFILLER_53_200 VGND VGND VPWR VPWR sky130_fd_sc_hd__fill_1
X_07625_ _00362_ _00363_ net444 net602 VGND VGND VPWR VPWR _00365_ sky130_fd_sc_hd__and4bb_1
XPHY_EDGE_ROW_24_Right_24 VGND VGND VPWR VPWR sky130_fd_sc_hd__decap_3
X_07556_ _02055_ net642 net304 net73 VGND VGND VPWR VPWR _00296_ sky130_fd_sc_hd__and4_1
XFILLER_13_119 VGND VGND VPWR VPWR sky130_fd_sc_hd__fill_1
XTAP_TAPCELL_ROW_24_626 VGND VPWR sky130_fd_sc_hd__tapvpwrvgnd_1
XTAP_TAPCELL_ROW_24_637 VGND VPWR sky130_fd_sc_hd__tapvpwrvgnd_1
X_09226_ _01785_ _01948_ VGND VGND VPWR VPWR _01950_ sky130_fd_sc_hd__nand2b_2
X_07487_ _00220_ _00227_ VGND VGND VPWR VPWR _00228_ sky130_fd_sc_hd__xor2_1
XTAP_TAPCELL_ROW_62_1167 VGND VPWR sky130_fd_sc_hd__tapvpwrvgnd_1
XTAP_TAPCELL_ROW_62_1156 VGND VPWR sky130_fd_sc_hd__tapvpwrvgnd_1
XTAP_TAPCELL_ROW_118_1945 VGND VPWR sky130_fd_sc_hd__tapvpwrvgnd_1
X_09157_ _01879_ _01880_ _01881_ VGND VGND VPWR VPWR _01882_ sky130_fd_sc_hd__nand3_1
XFILLER_5_329 VGND VGND VPWR VPWR sky130_fd_sc_hd__decap_6
XFILLER_108_769 VPWR VGND VPWR VGND sky130_ef_sc_hd__decap_12
X_09088_ net501 net628 VGND VGND VPWR VPWR _01813_ sky130_fd_sc_hd__nand2_1
X_08108_ _00843_ _00842_ VGND VGND VPWR VPWR _00844_ sky130_fd_sc_hd__nand2b_1
X_08039_ _00774_ _00775_ VGND VGND VPWR VPWR _00776_ sky130_fd_sc_hd__and2b_1
XPHY_EDGE_ROW_33_Right_33 VGND VGND VPWR VPWR sky130_fd_sc_hd__decap_3
XFILLER_116_791 VPWR VGND VPWR VGND sky130_ef_sc_hd__decap_12
XFILLER_89_664 VGND VGND VPWR VPWR sky130_fd_sc_hd__decap_3
XFILLER_89_642 VGND VGND VPWR VPWR sky130_fd_sc_hd__fill_1
X_11050_ _03396_ _03929_ VGND VGND VPWR VPWR _03930_ sky130_fd_sc_hd__xnor2_1
XFILLER_131_783 VGND VGND VPWR VPWR sky130_fd_sc_hd__fill_1
XFILLER_130_260 VGND VGND VPWR VPWR sky130_fd_sc_hd__decap_4
XFILLER_89_697 VPWR VGND VPWR VGND sky130_ef_sc_hd__decap_12
XFILLER_76_325 VGND VGND VPWR VPWR sky130_fd_sc_hd__decap_6
X_10001_ net266 net282 VGND VGND VPWR VPWR _02786_ sky130_fd_sc_hd__nand2_1
XFILLER_49_517 VGND VGND VPWR VPWR sky130_fd_sc_hd__decap_4
XFILLER_76_347 VGND VGND VPWR VPWR sky130_fd_sc_hd__decap_3
XTAP_TAPCELL_ROW_4_351 VGND VPWR sky130_fd_sc_hd__tapvpwrvgnd_1
XFILLER_123_51 VGND VGND VPWR VPWR sky130_fd_sc_hd__decap_4
XFILLER_29_241 VGND VGND VPWR VPWR sky130_fd_sc_hd__decap_4
X_11952_ _04887_ _04909_ VGND VGND VPWR VPWR _04911_ sky130_fd_sc_hd__and2b_1
XFILLER_44_222 VGND VGND VPWR VPWR sky130_fd_sc_hd__fill_1
XFILLER_17_436 VPWR VGND VPWR VGND sky130_ef_sc_hd__decap_12
XPHY_EDGE_ROW_42_Right_42 VGND VGND VPWR VPWR sky130_fd_sc_hd__decap_3
XFILLER_83_77 VGND VGND VPWR VPWR sky130_fd_sc_hd__decap_6
X_11883_ _04712_ _04835_ VGND VGND VPWR VPWR _04836_ sky130_fd_sc_hd__and2_1
XFILLER_45_789 VGND VGND VPWR VPWR sky130_fd_sc_hd__fill_2
XTAP_TAPCELL_ROW_43_902 VGND VPWR sky130_fd_sc_hd__tapvpwrvgnd_1
X_10903_ _03764_ _03767_ VGND VGND VPWR VPWR _03769_ sky130_fd_sc_hd__xor2_1
X_10834_ _03691_ _03692_ VGND VGND VPWR VPWR _03693_ sky130_fd_sc_hd__nor2_1
XFILLER_44_277 VGND VGND VPWR VPWR sky130_fd_sc_hd__decap_8
XFILLER_12_141 VGND VGND VPWR VPWR sky130_fd_sc_hd__decap_4
XFILLER_9_613 VGND VGND VPWR VPWR sky130_fd_sc_hd__decap_3
X_10765_ _03610_ _03616_ _03617_ VGND VGND VPWR VPWR _03618_ sky130_fd_sc_hd__nand3_1
X_12504_ _05327_ _05329_ _05511_ VGND VGND VPWR VPWR _05513_ sky130_fd_sc_hd__and3_1
XFILLER_13_697 VPWR VGND VPWR VGND sky130_ef_sc_hd__decap_12
X_10696_ net539 net283 net281 VGND VGND VPWR VPWR _03542_ sky130_fd_sc_hd__nand3_1
XPHY_EDGE_ROW_51_Right_51 VGND VGND VPWR VPWR sky130_fd_sc_hd__decap_3
X_12435_ _05434_ _05435_ _05436_ VGND VGND VPWR VPWR _05438_ sky130_fd_sc_hd__nand3_1
XFILLER_126_533 VGND VGND VPWR VPWR sky130_fd_sc_hd__decap_4
X_12366_ _05312_ _05360_ VGND VGND VPWR VPWR _05362_ sky130_fd_sc_hd__xnor2_1
XPHY_EDGE_ROW_136_Right_136 VGND VGND VPWR VPWR sky130_fd_sc_hd__decap_3
X_11317_ _04217_ _04220_ VGND VGND VPWR VPWR _04222_ sky130_fd_sc_hd__xor2_1
X_12297_ _05054_ _05111_ _05110_ VGND VGND VPWR VPWR _05288_ sky130_fd_sc_hd__a21bo_1
X_11248_ _04143_ _04144_ VGND VGND VPWR VPWR _04147_ sky130_fd_sc_hd__xnor2_2
XFILLER_95_634 VPWR VGND VPWR VGND sky130_ef_sc_hd__decap_12
X_11179_ _03944_ _04070_ VGND VGND VPWR VPWR _04071_ sky130_fd_sc_hd__xor2_1
XFILLER_95_689 VGND VGND VPWR VPWR sky130_fd_sc_hd__fill_1
XPHY_EDGE_ROW_60_Right_60 VGND VGND VPWR VPWR sky130_fd_sc_hd__decap_3
XFILLER_36_701 VGND VGND VPWR VPWR sky130_fd_sc_hd__decap_4
XFILLER_75_391 VGND VGND VPWR VPWR sky130_fd_sc_hd__fill_1
X_07410_ _06532_ _00150_ VGND VGND VPWR VPWR _00151_ sky130_fd_sc_hd__or2_1
X_08390_ _01093_ _01120_ VGND VGND VPWR VPWR _01121_ sky130_fd_sc_hd__nor2_1
XFILLER_23_439 VGND VGND VPWR VPWR sky130_fd_sc_hd__decap_8
XTAP_TAPCELL_ROW_102_1724 VGND VPWR sky130_fd_sc_hd__tapvpwrvgnd_1
X_07341_ _06616_ _06631_ VGND VGND VPWR VPWR _06632_ sky130_fd_sc_hd__nor2_2
XFILLER_31_461 VPWR VGND VPWR VGND sky130_ef_sc_hd__decap_12
X_07272_ _06410_ _06412_ VGND VGND VPWR VPWR _06563_ sky130_fd_sc_hd__nand2_1
XFILLER_31_483 VGND VGND VPWR VPWR sky130_fd_sc_hd__fill_1
X_09011_ _01638_ _01735_ VGND VGND VPWR VPWR _01737_ sky130_fd_sc_hd__xnor2_1
XFILLER_129_393 VPWR VGND VPWR VGND sky130_ef_sc_hd__decap_12
XFILLER_128_29 VPWR VGND VPWR VGND sky130_ef_sc_hd__decap_12
XFILLER_105_706 VPWR VGND VPWR VGND sky130_ef_sc_hd__decap_12
XPHY_EDGE_ROW_103_Right_103 VGND VGND VPWR VPWR sky130_fd_sc_hd__decap_3
XFILLER_132_525 VGND VGND VPWR VPWR sky130_fd_sc_hd__decap_6
XFILLER_132_569 VPWR VGND VPWR VGND sky130_ef_sc_hd__decap_12
XTAP_TAPCELL_ROW_113_1875 VGND VPWR sky130_fd_sc_hd__tapvpwrvgnd_1
X_09913_ _02111_ _02692_ VGND VGND VPWR VPWR _02693_ sky130_fd_sc_hd__xnor2_1
Xfanout603 net135 VGND VGND VPWR VPWR net603 sky130_fd_sc_hd__buf_2
Xfanout614 net130 VGND VGND VPWR VPWR net614 sky130_fd_sc_hd__buf_2
X_09844_ _02616_ _02617_ VGND VGND VPWR VPWR _02618_ sky130_fd_sc_hd__and2_1
Xfanout625 net128 VGND VGND VPWR VPWR net625 sky130_fd_sc_hd__buf_2
XFILLER_98_483 VPWR VGND VPWR VGND sky130_ef_sc_hd__decap_12
XFILLER_85_100 VPWR VGND VPWR VGND sky130_ef_sc_hd__decap_12
Xfanout636 net120 VGND VGND VPWR VPWR net636 sky130_fd_sc_hd__buf_2
Xfanout647 net119 VGND VGND VPWR VPWR net647 sky130_fd_sc_hd__buf_2
Xfanout658 net112 VGND VGND VPWR VPWR net658 sky130_fd_sc_hd__buf_2
Xfanout669 net671 VGND VGND VPWR VPWR net669 sky130_fd_sc_hd__buf_2
XFILLER_86_645 VGND VGND VPWR VPWR sky130_fd_sc_hd__decap_4
XFILLER_58_325 VGND VGND VPWR VPWR sky130_fd_sc_hd__fill_1
X_06987_ net533 net680 VGND VGND VPWR VPWR _05385_ sky130_fd_sc_hd__nand2_1
XFILLER_100_477 VPWR VGND VPWR VGND sky130_ef_sc_hd__decap_12
XFILLER_100_466 VGND VGND VPWR VPWR sky130_fd_sc_hd__decap_8
X_09775_ _02436_ _02437_ _02439_ VGND VGND VPWR VPWR _02542_ sky130_fd_sc_hd__o21ai_1
XFILLER_46_509 VGND VGND VPWR VPWR sky130_fd_sc_hd__decap_3
XTAP_TAPCELL_ROW_29_707 VGND VPWR sky130_fd_sc_hd__tapvpwrvgnd_1
X_08726_ _01250_ _01385_ _01387_ VGND VGND VPWR VPWR _01453_ sky130_fd_sc_hd__o21bai_1
XFILLER_54_531 VGND VGND VPWR VPWR sky130_fd_sc_hd__fill_1
XTAP_TAPCELL_ROW_1_310 VGND VPWR sky130_fd_sc_hd__tapvpwrvgnd_1
X_08657_ _01377_ _01384_ VGND VGND VPWR VPWR _01385_ sky130_fd_sc_hd__xnor2_2
XFILLER_81_350 VGND VGND VPWR VPWR sky130_fd_sc_hd__decap_4
XFILLER_26_233 VGND VGND VPWR VPWR sky130_fd_sc_hd__decap_3
X_07608_ _00187_ _00347_ VGND VGND VPWR VPWR _00348_ sky130_fd_sc_hd__xnor2_1
XFILLER_14_417 VGND VGND VPWR VPWR sky130_fd_sc_hd__decap_3
XFILLER_14_428 VGND VGND VPWR VPWR sky130_fd_sc_hd__fill_1
XFILLER_42_715 VGND VGND VPWR VPWR sky130_fd_sc_hd__fill_2
X_08588_ _01313_ _01314_ _01210_ VGND VGND VPWR VPWR _01317_ sky130_fd_sc_hd__a21oi_2
XFILLER_41_225 VPWR VGND VPWR VGND sky130_ef_sc_hd__decap_12
XFILLER_42_748 VGND VGND VPWR VPWR sky130_fd_sc_hd__decap_8
X_07539_ _06660_ _06659_ _06658_ VGND VGND VPWR VPWR _00280_ sky130_fd_sc_hd__a21oi_4
X_10550_ _03336_ _03382_ VGND VGND VPWR VPWR _03383_ sky130_fd_sc_hd__nand2_1
XFILLER_10_645 VGND VGND VPWR VPWR sky130_fd_sc_hd__decap_8
X_09209_ _02055_ net645 net254 net97 VGND VGND VPWR VPWR _01933_ sky130_fd_sc_hd__and4_1
Xrebuffer220 net818 VGND VGND VPWR VPWR net920 sky130_fd_sc_hd__dlygate4sd1_1
Xrebuffer231 _02997_ VGND VGND VPWR VPWR net931 sky130_fd_sc_hd__buf_1
X_10481_ _03305_ _03306_ _03152_ net748 VGND VGND VPWR VPWR _03308_ sky130_fd_sc_hd__o211ai_2
XFILLER_108_544 VGND VGND VPWR VPWR sky130_fd_sc_hd__fill_2
XFILLER_108_533 VGND VGND VPWR VPWR sky130_fd_sc_hd__decap_4
X_12220_ net471 net582 _05059_ _05057_ VGND VGND VPWR VPWR _05203_ sky130_fd_sc_hd__a31o_1
XFILLER_5_137 VPWR VGND VPWR VGND sky130_ef_sc_hd__decap_12
XFILLER_108_566 VPWR VGND VPWR VGND sky130_ef_sc_hd__decap_12
XFILLER_135_385 VGND VGND VPWR VPWR sky130_fd_sc_hd__decap_6
XFILLER_78_33 VGND VGND VPWR VPWR sky130_fd_sc_hd__fill_1
XTAP_TAPCELL_ROW_75_1347 VGND VPWR sky130_fd_sc_hd__tapvpwrvgnd_1
X_12151_ _05126_ _05127_ VGND VGND VPWR VPWR _05128_ sky130_fd_sc_hd__and2b_1
XTAP_TAPCELL_ROW_9_421 VGND VPWR sky130_fd_sc_hd__tapvpwrvgnd_1
XFILLER_123_569 VGND VGND VPWR VPWR sky130_fd_sc_hd__fill_2
XFILLER_78_44 VPWR VGND VPWR VGND sky130_ef_sc_hd__decap_12
X_12082_ _05051_ _05052_ VGND VGND VPWR VPWR _05053_ sky130_fd_sc_hd__nand2_1
X_11102_ _03985_ _03986_ VGND VGND VPWR VPWR _03987_ sky130_fd_sc_hd__or2_1
XFILLER_89_461 VPWR VGND VPWR VGND sky130_ef_sc_hd__decap_12
XFILLER_76_100 VGND VGND VPWR VPWR sky130_fd_sc_hd__decap_8
X_11033_ net489 net647 net636 net496 VGND VGND VPWR VPWR _03911_ sky130_fd_sc_hd__a22o_1
XFILLER_76_122 VGND VGND VPWR VPWR sky130_fd_sc_hd__fill_2
XFILLER_134_83 VGND VGND VPWR VPWR sky130_fd_sc_hd__fill_1
XFILLER_64_317 VPWR VGND VPWR VGND sky130_ef_sc_hd__decap_12
XFILLER_18_701 VPWR VGND VPWR VGND sky130_ef_sc_hd__decap_12
XFILLER_17_211 VGND VGND VPWR VPWR sky130_fd_sc_hd__fill_2
X_12984_ _06035_ _06036_ VGND VGND VPWR VPWR _06038_ sky130_fd_sc_hd__xnor2_1
XFILLER_57_391 VGND VGND VPWR VPWR sky130_fd_sc_hd__fill_1
X_11935_ _04889_ _04890_ _04891_ VGND VGND VPWR VPWR _04892_ sky130_fd_sc_hd__nand3b_1
XFILLER_27_81 VGND VGND VPWR VPWR sky130_fd_sc_hd__fill_1
XTAP_TAPCELL_ROW_86_1498 VGND VPWR sky130_fd_sc_hd__tapvpwrvgnd_1
XFILLER_32_203 VGND VGND VPWR VPWR sky130_fd_sc_hd__fill_2
X_11866_ _04586_ _04625_ _04626_ _04629_ VGND VGND VPWR VPWR _04817_ sky130_fd_sc_hd__o2bb2ai_1
XFILLER_60_567 VGND VGND VPWR VPWR sky130_fd_sc_hd__decap_4
X_11797_ _04739_ _04740_ VGND VGND VPWR VPWR _04742_ sky130_fd_sc_hd__and2b_1
X_10817_ _03490_ _03492_ _03673_ _03674_ VGND VGND VPWR VPWR _03676_ sky130_fd_sc_hd__o211ai_2
X_10748_ _03582_ _03599_ VGND VGND VPWR VPWR _03600_ sky130_fd_sc_hd__xnor2_1
X_12418_ _05403_ _05417_ _05419_ VGND VGND VPWR VPWR _05420_ sky130_fd_sc_hd__and3_1
X_10679_ _03522_ _03523_ VGND VGND VPWR VPWR _03524_ sky130_fd_sc_hd__and2b_1
XFILLER_126_363 VGND VGND VPWR VPWR sky130_fd_sc_hd__fill_1
Xoutput217 net217 VGND VGND VPWR VPWR out3[1] sky130_fd_sc_hd__buf_2
Xoutput206 net206 VGND VGND VPWR VPWR out2[6] sky130_fd_sc_hd__buf_2
X_13398_ clknet_3_1__leaf_clk _00015_ _00108_ VGND VGND VPWR VPWR net197 sky130_fd_sc_hd__dfrtp_1
XTAP_TAPCELL_ROW_130_2120 VGND VPWR sky130_fd_sc_hd__tapvpwrvgnd_1
XFILLER_99_225 VGND VGND VPWR VPWR sky130_fd_sc_hd__decap_3
XFILLER_5_671 VGND VGND VPWR VPWR sky130_fd_sc_hd__fill_1
X_12349_ net542 _05342_ _05343_ net298 net568 VGND VGND VPWR VPWR _05344_ sky130_fd_sc_hd__a32o_1
XFILLER_4_41 VPWR VGND VPWR VGND sky130_ef_sc_hd__decap_12
X_06910_ _04439_ _04450_ _04516_ VGND VGND VPWR VPWR _04548_ sky130_fd_sc_hd__a21oi_1
XFILLER_4_85 VPWR VGND VPWR VGND sky130_ef_sc_hd__decap_12
XFILLER_110_742 VPWR VGND VPWR VGND sky130_ef_sc_hd__decap_12
X_07890_ net816 net373 VGND VGND VPWR VPWR _00628_ sky130_fd_sc_hd__nand2b_1
XFILLER_68_645 VPWR VGND VPWR VGND sky130_ef_sc_hd__decap_12
X_06841_ _03773_ _03784_ VGND VGND VPWR VPWR _03795_ sky130_fd_sc_hd__or2_1
XFILLER_68_689 VGND VGND VPWR VPWR sky130_fd_sc_hd__fill_1
XTAP_TAPCELL_ROW_128_2093 VGND VPWR sky130_fd_sc_hd__tapvpwrvgnd_1
XTAP_TAPCELL_ROW_128_2082 VGND VPWR sky130_fd_sc_hd__tapvpwrvgnd_1
X_06772_ net323 net687 net320 net667 VGND VGND VPWR VPWR _03042_ sky130_fd_sc_hd__and4_1
X_09560_ net406 net550 net548 net414 VGND VGND VPWR VPWR _02309_ sky130_fd_sc_hd__a22oi_1
XFILLER_83_659 VGND VGND VPWR VPWR sky130_fd_sc_hd__decap_8
XFILLER_67_177 VGND VGND VPWR VPWR sky130_fd_sc_hd__fill_2
XFILLER_55_317 VGND VGND VPWR VPWR sky130_fd_sc_hd__decap_4
X_09491_ _02231_ _02233_ VGND VGND VPWR VPWR _00052_ sky130_fd_sc_hd__xnor2_1
X_08511_ _01238_ _01239_ net474 net552 VGND VGND VPWR VPWR _01240_ sky130_fd_sc_hd__and4bb_1
XFILLER_70_309 VGND VGND VPWR VPWR sky130_fd_sc_hd__decap_3
X_08442_ _01142_ _01169_ _01170_ VGND VGND VPWR VPWR _01171_ sky130_fd_sc_hd__a21o_1
XFILLER_91_681 VGND VGND VPWR VPWR sky130_fd_sc_hd__decap_8
XFILLER_24_737 VGND VGND VPWR VPWR sky130_fd_sc_hd__fill_2
XFILLER_36_575 VPWR VGND VPWR VGND sky130_ef_sc_hd__decap_12
XFILLER_90_180 VGND VGND VPWR VPWR sky130_fd_sc_hd__decap_3
X_08373_ net473 net555 VGND VGND VPWR VPWR _01104_ sky130_fd_sc_hd__nand2_1
XFILLER_23_28 VGND VGND VPWR VPWR sky130_fd_sc_hd__decap_4
XTAP_TAPCELL_ROW_34_765 VGND VPWR sky130_fd_sc_hd__tapvpwrvgnd_1
XTAP_TAPCELL_ROW_34_776 VGND VPWR sky130_fd_sc_hd__tapvpwrvgnd_1
X_07324_ _06613_ _06614_ VGND VGND VPWR VPWR _06615_ sky130_fd_sc_hd__and2b_1
X_07255_ _06529_ _06545_ VGND VGND VPWR VPWR _06546_ sky130_fd_sc_hd__xnor2_1
XFILLER_129_190 VGND VGND VPWR VPWR sky130_fd_sc_hd__fill_1
XTAP_TAPCELL_ROW_115_1904 VGND VPWR sky130_fd_sc_hd__tapvpwrvgnd_1
XFILLER_105_503 VGND VGND VPWR VPWR sky130_fd_sc_hd__fill_1
X_07186_ _06475_ _06476_ _06458_ VGND VGND VPWR VPWR _06478_ sky130_fd_sc_hd__a21oi_1
XFILLER_132_333 VPWR VGND VPWR VGND sky130_ef_sc_hd__decap_12
XTAP_TAPCELL_ROW_57_1088 VGND VPWR sky130_fd_sc_hd__tapvpwrvgnd_1
XFILLER_132_377 VPWR VGND VPWR VGND sky130_ef_sc_hd__decap_12
Xfanout411 net31 VGND VGND VPWR VPWR net411 sky130_fd_sc_hd__buf_2
Xfanout422 net423 VGND VGND VPWR VPWR net422 sky130_fd_sc_hd__buf_2
XTAP_TAPCELL_ROW_57_1099 VGND VPWR sky130_fd_sc_hd__tapvpwrvgnd_1
Xfanout400 net401 VGND VGND VPWR VPWR net400 sky130_fd_sc_hd__clkbuf_4
Xfanout444 net445 VGND VGND VPWR VPWR net444 sky130_fd_sc_hd__buf_2
Xfanout455 net456 VGND VGND VPWR VPWR net455 sky130_fd_sc_hd__buf_2
Xfanout466 net26 VGND VGND VPWR VPWR net466 sky130_fd_sc_hd__clkbuf_2
Xfanout433 net441 VGND VGND VPWR VPWR net433 sky130_fd_sc_hd__buf_2
XFILLER_48_47 VGND VGND VPWR VPWR sky130_fd_sc_hd__fill_1
X_09827_ _02590_ _02597_ VGND VGND VPWR VPWR _02600_ sky130_fd_sc_hd__xor2_1
Xfanout477 net481 VGND VGND VPWR VPWR net477 sky130_fd_sc_hd__clkbuf_4
Xfanout488 net23 VGND VGND VPWR VPWR net488 sky130_fd_sc_hd__clkbuf_4
XTAP_TAPCELL_ROW_70_1277 VGND VPWR sky130_fd_sc_hd__tapvpwrvgnd_1
Xfanout499 net21 VGND VGND VPWR VPWR net499 sky130_fd_sc_hd__buf_2
XFILLER_101_797 VGND VGND VPWR VPWR sky130_fd_sc_hd__decap_8
X_09758_ _02382_ _02395_ _02521_ VGND VGND VPWR VPWR _02524_ sky130_fd_sc_hd__nor3_1
XFILLER_73_125 VGND VGND VPWR VPWR sky130_fd_sc_hd__decap_3
X_08709_ _01435_ _01434_ _01389_ VGND VGND VPWR VPWR _01437_ sky130_fd_sc_hd__or3_4
XFILLER_74_659 VGND VGND VPWR VPWR sky130_fd_sc_hd__decap_3
XFILLER_27_542 VGND VGND VPWR VPWR sky130_fd_sc_hd__fill_1
X_09689_ _02260_ _02274_ _02272_ VGND VGND VPWR VPWR _02449_ sky130_fd_sc_hd__o21ai_1
XFILLER_73_169 VGND VGND VPWR VPWR sky130_fd_sc_hd__decap_4
X_11720_ _04648_ _04657_ VGND VGND VPWR VPWR _04658_ sky130_fd_sc_hd__or2_1
XFILLER_15_726 VGND VGND VPWR VPWR sky130_fd_sc_hd__fill_2
XFILLER_27_575 VPWR VGND VPWR VGND sky130_ef_sc_hd__decap_12
XFILLER_120_41 VPWR VGND VPWR VGND sky130_ef_sc_hd__decap_12
X_11651_ net516 net370 net368 net700 VGND VGND VPWR VPWR _04583_ sky130_fd_sc_hd__a22o_1
XFILLER_120_85 VPWR VGND VPWR VGND sky130_ef_sc_hd__decap_12
XFILLER_80_56 VGND VGND VPWR VPWR sky130_fd_sc_hd__decap_8
X_11582_ _04506_ _04510_ VGND VGND VPWR VPWR _04511_ sky130_fd_sc_hd__xor2_1
XFILLER_23_770 VPWR VGND VPWR VGND sky130_ef_sc_hd__decap_12
X_10602_ _03437_ _03438_ _03439_ VGND VGND VPWR VPWR _03440_ sky130_fd_sc_hd__nand3_1
XFILLER_127_105 VGND VGND VPWR VPWR sky130_fd_sc_hd__decap_6
X_10533_ net616 net84 _03207_ _03206_ VGND VGND VPWR VPWR _03364_ sky130_fd_sc_hd__a31o_1
XTAP_TAPCELL_ROW_12_459 VGND VPWR sky130_fd_sc_hd__tapvpwrvgnd_1
XFILLER_10_453 VGND VGND VPWR VPWR sky130_fd_sc_hd__decap_3
X_13321_ net397 VGND VGND VPWR VPWR _00095_ sky130_fd_sc_hd__inv_2
XFILLER_22_280 VPWR VGND VPWR VGND sky130_ef_sc_hd__decap_12
XFILLER_6_413 VGND VGND VPWR VPWR sky130_fd_sc_hd__decap_6
X_13252_ _06118_ _06116_ _05785_ VGND VGND VPWR VPWR _06329_ sky130_fd_sc_hd__mux2_1
X_10464_ _03285_ _03288_ VGND VGND VPWR VPWR _03289_ sky130_fd_sc_hd__xnor2_1
X_10395_ _03203_ _03213_ VGND VGND VPWR VPWR _03214_ sky130_fd_sc_hd__xor2_1
X_12203_ _04669_ _04724_ _04902_ _05045_ _05049_ VGND VGND VPWR VPWR _05184_ sky130_fd_sc_hd__o41a_1
X_13183_ _06253_ _06254_ VGND VGND VPWR VPWR _06255_ sky130_fd_sc_hd__nand2b_1
XFILLER_135_193 VPWR VGND VPWR VGND sky130_ef_sc_hd__decap_12
X_12134_ _05107_ _05106_ _05076_ VGND VGND VPWR VPWR _05109_ sky130_fd_sc_hd__a21o_1
XFILLER_111_517 VPWR VGND VPWR VGND sky130_ef_sc_hd__decap_12
XFILLER_49_111 VGND VGND VPWR VPWR sky130_fd_sc_hd__fill_1
X_12065_ _05030_ _05032_ _05033_ VGND VGND VPWR VPWR _05034_ sky130_fd_sc_hd__nand3b_1
X_11016_ _03725_ _03891_ VGND VGND VPWR VPWR _03892_ sky130_fd_sc_hd__nand2_1
XTAP_TAPCELL_ROW_88_1527 VGND VPWR sky130_fd_sc_hd__tapvpwrvgnd_1
XFILLER_65_626 VGND VGND VPWR VPWR sky130_fd_sc_hd__decap_8
XFILLER_64_114 VPWR VGND VPWR VGND sky130_ef_sc_hd__decap_12
XFILLER_49_199 VGND VGND VPWR VPWR sky130_fd_sc_hd__decap_3
XFILLER_18_531 VGND VGND VPWR VPWR sky130_fd_sc_hd__fill_1
XFILLER_92_489 VGND VGND VPWR VPWR sky130_fd_sc_hd__fill_1
XFILLER_80_618 VPWR VGND VPWR VGND sky130_ef_sc_hd__decap_12
XFILLER_73_670 VGND VGND VPWR VPWR sky130_fd_sc_hd__fill_2
XFILLER_52_309 VGND VGND VPWR VPWR sky130_fd_sc_hd__fill_2
X_12967_ net420 _05386_ _06018_ VGND VGND VPWR VPWR _06020_ sky130_fd_sc_hd__o21a_1
XFILLER_60_331 VGND VGND VPWR VPWR sky130_fd_sc_hd__fill_1
X_11918_ _04870_ _04873_ VGND VGND VPWR VPWR _04874_ sky130_fd_sc_hd__nand2_1
X_12898_ _05941_ _05942_ VGND VGND VPWR VPWR _05945_ sky130_fd_sc_hd__xnor2_1
X_11849_ _04798_ VGND VGND VPWR VPWR _04799_ sky130_fd_sc_hd__inv_2
XFILLER_21_707 VGND VGND VPWR VPWR sky130_fd_sc_hd__decap_8
XFILLER_21_729 VGND VGND VPWR VPWR sky130_fd_sc_hd__fill_1
XFILLER_33_556 VGND VGND VPWR VPWR sky130_fd_sc_hd__decap_4
XFILLER_20_217 VGND VGND VPWR VPWR sky130_fd_sc_hd__fill_1
XTAP_TAPCELL_ROW_31_724 VGND VPWR sky130_fd_sc_hd__tapvpwrvgnd_1
XTAP_TAPCELL_ROW_31_735 VGND VPWR sky130_fd_sc_hd__tapvpwrvgnd_1
XFILLER_119_617 VPWR VGND VPWR VGND sky130_ef_sc_hd__decap_12
XFILLER_118_105 VGND VGND VPWR VPWR sky130_fd_sc_hd__fill_2
XTAP_TAPCELL_ROW_99_1678 VGND VPWR sky130_fd_sc_hd__tapvpwrvgnd_1
XFILLER_118_149 VGND VGND VPWR VPWR sky130_fd_sc_hd__decap_3
X_07040_ _05932_ _05921_ _05943_ VGND VGND VPWR VPWR _05964_ sky130_fd_sc_hd__a21o_1
XFILLER_88_729 VGND VGND VPWR VPWR sky130_fd_sc_hd__decap_8
X_08991_ _01710_ _01716_ VGND VGND VPWR VPWR _01717_ sky130_fd_sc_hd__xnor2_1
XTAP_TAPCELL_ROW_110_1834 VGND VPWR sky130_fd_sc_hd__tapvpwrvgnd_1
X_07942_ _00673_ _00679_ VGND VGND VPWR VPWR _00680_ sky130_fd_sc_hd__xnor2_1
X_07873_ _00597_ _00610_ VGND VGND VPWR VPWR _00611_ sky130_fd_sc_hd__xnor2_1
X_09612_ _02364_ _02365_ VGND VGND VPWR VPWR _02366_ sky130_fd_sc_hd__nor2_1
X_06824_ _03565_ _03598_ VGND VGND VPWR VPWR _03609_ sky130_fd_sc_hd__nand2_1
XFILLER_28_317 VGND VGND VPWR VPWR sky130_fd_sc_hd__fill_1
XTAP_TAPCELL_ROW_39_835 VGND VPWR sky130_fd_sc_hd__tapvpwrvgnd_1
X_09543_ net336 net326 _02168_ _02167_ net313 VGND VGND VPWR VPWR _02291_ sky130_fd_sc_hd__a32o_1
XFILLER_55_158 VGND VGND VPWR VPWR sky130_fd_sc_hd__fill_2
XTAP_TAPCELL_ROW_39_846 VGND VPWR sky130_fd_sc_hd__tapvpwrvgnd_1
X_06755_ net470 net460 net611 net609 VGND VGND VPWR VPWR _02856_ sky130_fd_sc_hd__and4_1
XFILLER_55_169 VGND VGND VPWR VPWR sky130_fd_sc_hd__decap_8
XFILLER_36_372 VGND VGND VPWR VPWR sky130_fd_sc_hd__fill_2
X_09474_ _01999_ _02058_ _02057_ VGND VGND VPWR VPWR _02216_ sky130_fd_sc_hd__a21bo_1
XFILLER_70_139 VGND VGND VPWR VPWR sky130_fd_sc_hd__fill_1
X_06686_ net312 VGND VGND VPWR VPWR _02109_ sky130_fd_sc_hd__inv_6
XFILLER_24_545 VGND VGND VPWR VPWR sky130_fd_sc_hd__fill_2
XFILLER_34_27 VGND VGND VPWR VPWR sky130_fd_sc_hd__fill_1
XFILLER_36_383 VGND VGND VPWR VPWR sky130_fd_sc_hd__decap_8
X_08425_ net270 net261 _01152_ _01153_ VGND VGND VPWR VPWR _01155_ sky130_fd_sc_hd__a22oi_1
XFILLER_51_353 VGND VGND VPWR VPWR sky130_fd_sc_hd__fill_2
XFILLER_24_567 VGND VGND VPWR VPWR sky130_fd_sc_hd__decap_4
XTAP_TAPCELL_ROW_121_1985 VGND VPWR sky130_fd_sc_hd__tapvpwrvgnd_1
X_08356_ net535 net122 VGND VGND VPWR VPWR _01088_ sky130_fd_sc_hd__nand2_2
XFILLER_24_589 VGND VGND VPWR VPWR sky130_fd_sc_hd__decap_6
X_07307_ net695 _02142_ _06594_ _06596_ VGND VGND VPWR VPWR _06598_ sky130_fd_sc_hd__or4b_1
Xclkload4 clknet_3_5__leaf_clk VGND VGND VPWR VPWR clkload4/Y sky130_fd_sc_hd__clkinvlp_4
X_08287_ _00920_ _00922_ _01021_ VGND VGND VPWR VPWR _01022_ sky130_fd_sc_hd__o21ba_1
X_07238_ _06512_ _06528_ VGND VGND VPWR VPWR _06529_ sky130_fd_sc_hd__xnor2_1
XTAP_TAPCELL_ROW_59_1117 VGND VPWR sky130_fd_sc_hd__tapvpwrvgnd_1
XFILLER_118_683 VPWR VGND VPWR VGND sky130_ef_sc_hd__decap_12
X_07169_ net770 net386 net384 net427 VGND VGND VPWR VPWR _06461_ sky130_fd_sc_hd__a22o_1
XFILLER_3_405 VPWR VGND VPWR VGND sky130_ef_sc_hd__decap_12
XFILLER_133_653 VPWR VGND VPWR VGND sky130_ef_sc_hd__decap_12
XFILLER_117_193 VPWR VGND VPWR VGND sky130_ef_sc_hd__decap_12
XTAP_TAPCELL_ROW_72_1306 VGND VPWR sky130_fd_sc_hd__tapvpwrvgnd_1
XFILLER_3_449 VPWR VGND VPWR VGND sky130_ef_sc_hd__decap_12
XFILLER_132_141 VPWR VGND VPWR VGND sky130_ef_sc_hd__decap_12
XFILLER_120_303 VGND VGND VPWR VPWR sky130_fd_sc_hd__decap_4
XFILLER_59_57 VGND VGND VPWR VPWR sky130_fd_sc_hd__fill_2
X_10180_ _02978_ _02977_ _02979_ VGND VGND VPWR VPWR _02980_ sky130_fd_sc_hd__or3_4
XFILLER_133_697 VPWR VGND VPWR VGND sky130_ef_sc_hd__decap_12
XFILLER_120_325 VPWR VGND VPWR VGND sky130_ef_sc_hd__decap_12
Xfanout263 net91 VGND VGND VPWR VPWR net263 sky130_fd_sc_hd__dlymetal6s2s_1
Xfanout252 net98 VGND VGND VPWR VPWR net252 sky130_fd_sc_hd__clkbuf_4
Xfanout274 net87 VGND VGND VPWR VPWR net274 sky130_fd_sc_hd__clkbuf_4
XFILLER_101_561 VGND VGND VPWR VPWR sky130_fd_sc_hd__fill_1
XFILLER_46_103 VPWR VGND VPWR VGND sky130_ef_sc_hd__decap_12
Xfanout296 net77 VGND VGND VPWR VPWR net296 sky130_fd_sc_hd__clkbuf_2
Xfanout285 net80 VGND VGND VPWR VPWR net285 sky130_fd_sc_hd__clkbuf_2
X_12821_ _05823_ _05859_ VGND VGND VPWR VPWR _05860_ sky130_fd_sc_hd__xor2_1
XFILLER_131_51 VGND VGND VPWR VPWR sky130_fd_sc_hd__decap_4
XFILLER_61_106 VGND VGND VPWR VPWR sky130_fd_sc_hd__decap_6
XFILLER_34_309 VPWR VGND VPWR VGND sky130_ef_sc_hd__decap_12
XTAP_TAPCELL_ROW_17_529 VGND VPWR sky130_fd_sc_hd__tapvpwrvgnd_1
X_12752_ _05783_ _05784_ _05780_ VGND VGND VPWR VPWR _05785_ sky130_fd_sc_hd__a21oi_4
XTAP_TAPCELL_ROW_83_1457 VGND VPWR sky130_fd_sc_hd__tapvpwrvgnd_1
X_11703_ net534 net106 _04596_ _04637_ VGND VGND VPWR VPWR _04639_ sky130_fd_sc_hd__a31o_1
X_12683_ _05581_ _05600_ _05599_ VGND VGND VPWR VPWR _05709_ sky130_fd_sc_hd__a21oi_1
X_11634_ _04470_ _04501_ _04468_ VGND VGND VPWR VPWR _04567_ sky130_fd_sc_hd__a21o_1
XFILLER_30_537 VGND VGND VPWR VPWR sky130_fd_sc_hd__fill_1
X_11565_ _04383_ _04386_ _04491_ VGND VGND VPWR VPWR _04492_ sky130_fd_sc_hd__o21ai_1
X_13304_ net395 VGND VGND VPWR VPWR _00078_ sky130_fd_sc_hd__inv_2
XFILLER_128_469 VGND VGND VPWR VPWR sky130_fd_sc_hd__decap_6
X_10516_ net591 net84 net278 net616 VGND VGND VPWR VPWR _03345_ sky130_fd_sc_hd__a22o_1
XFILLER_7_777 VGND VGND VPWR VPWR sky130_fd_sc_hd__decap_6
XFILLER_6_221 VPWR VGND VPWR VGND sky130_ef_sc_hd__decap_12
X_11496_ _04416_ _04415_ VGND VGND VPWR VPWR _00016_ sky130_fd_sc_hd__xnor2_1
XFILLER_109_694 VGND VGND VPWR VPWR sky130_fd_sc_hd__fill_2
X_10447_ _03266_ _03267_ _03268_ VGND VGND VPWR VPWR _03271_ sky130_fd_sc_hd__a21o_1
XFILLER_6_265 VPWR VGND VPWR VGND sky130_ef_sc_hd__decap_12
X_13235_ _06309_ _06310_ VGND VGND VPWR VPWR _06312_ sky130_fd_sc_hd__xnor2_1
XFILLER_108_171 VGND VGND VPWR VPWR sky130_fd_sc_hd__decap_3
XFILLER_69_206 VPWR VGND VPWR VGND sky130_ef_sc_hd__decap_12
X_10378_ _03192_ _03193_ VGND VGND VPWR VPWR _03196_ sky130_fd_sc_hd__xnor2_1
X_13166_ _06105_ _06108_ _06120_ VGND VGND VPWR VPWR _06236_ sky130_fd_sc_hd__nand3_1
XFILLER_97_537 VPWR VGND VPWR VGND sky130_ef_sc_hd__decap_12
X_12117_ net335 net314 net370 net368 VGND VGND VPWR VPWR _05091_ sky130_fd_sc_hd__and4_1
X_13097_ _06160_ _06159_ VGND VGND VPWR VPWR _06162_ sky130_fd_sc_hd__nand2b_1
XFILLER_34_6 VPWR VGND VPWR VGND sky130_ef_sc_hd__decap_12
X_12048_ _04720_ _04875_ _04695_ VGND VGND VPWR VPWR _05016_ sky130_fd_sc_hd__o21a_1
XTAP_TAPCELL_ROW_125_2041 VGND VPWR sky130_fd_sc_hd__tapvpwrvgnd_1
XFILLER_92_253 VGND VGND VPWR VPWR sky130_fd_sc_hd__decap_8
XFILLER_65_489 VGND VGND VPWR VPWR sky130_fd_sc_hd__decap_8
XTAP_TAPCELL_ROW_36_805 VGND VPWR sky130_fd_sc_hd__tapvpwrvgnd_1
XFILLER_37_169 VPWR VGND VPWR VGND sky130_ef_sc_hd__decap_12
XFILLER_52_139 VGND VGND VPWR VPWR sky130_fd_sc_hd__fill_1
XFILLER_46_692 VGND VGND VPWR VPWR sky130_fd_sc_hd__decap_8
XFILLER_61_673 VGND VGND VPWR VPWR sky130_fd_sc_hd__decap_6
X_08210_ _00943_ _00944_ VGND VGND VPWR VPWR _00945_ sky130_fd_sc_hd__nand2_1
XFILLER_60_150 VGND VGND VPWR VPWR sky130_fd_sc_hd__decap_8
X_09190_ _01913_ _01914_ VGND VGND VPWR VPWR _01915_ sky130_fd_sc_hd__nor2_8
XFILLER_21_559 VGND VGND VPWR VPWR sky130_fd_sc_hd__fill_1
XFILLER_119_436 VPWR VGND VPWR VGND sky130_ef_sc_hd__decap_12
X_08141_ _00869_ _00875_ VGND VGND VPWR VPWR _00877_ sky130_fd_sc_hd__xnor2_1
X_08072_ _00779_ _00807_ VGND VGND VPWR VPWR _00809_ sky130_fd_sc_hd__xnor2_1
XTAP_TAPCELL_ROW_136_2192 VGND VPWR sky130_fd_sc_hd__tapvpwrvgnd_1
X_07023_ _04035_ _04057_ _05768_ VGND VGND VPWR VPWR _05779_ sky130_fd_sc_hd__o21a_1
XFILLER_20_29 VPWR VGND VPWR VGND sky130_ef_sc_hd__decap_12
XFILLER_136_29 VPWR VGND VPWR VGND sky130_ef_sc_hd__decap_12
XFILLER_115_653 VGND VGND VPWR VPWR sky130_fd_sc_hd__fill_1
XFILLER_130_601 VPWR VGND VPWR VGND sky130_ef_sc_hd__decap_12
XFILLER_114_141 VPWR VGND VPWR VGND sky130_ef_sc_hd__decap_12
XFILLER_0_419 VGND VGND VPWR VPWR sky130_fd_sc_hd__fill_1
XFILLER_130_645 VPWR VGND VPWR VGND sky130_ef_sc_hd__decap_12
X_08974_ net736 net328 _01698_ _01699_ VGND VGND VPWR VPWR _01700_ sky130_fd_sc_hd__a22o_1
XTAP_TAPCELL_ROW_54_1047 VGND VPWR sky130_fd_sc_hd__tapvpwrvgnd_1
X_07925_ net497 _02153_ VGND VGND VPWR VPWR _00663_ sky130_fd_sc_hd__nor2_1
XPHY_EDGE_ROW_89_Right_89 VGND VGND VPWR VPWR sky130_fd_sc_hd__decap_3
XFILLER_68_272 VGND VGND VPWR VPWR sky130_fd_sc_hd__decap_4
XFILLER_29_615 VGND VGND VPWR VPWR sky130_fd_sc_hd__fill_1
X_07856_ _00447_ _00448_ _00449_ _00446_ _00445_ VGND VGND VPWR VPWR _00594_ sky130_fd_sc_hd__o32a_1
X_06807_ net668 net319 _03390_ _03401_ VGND VGND VPWR VPWR _03423_ sky130_fd_sc_hd__o2bb2a_1
XFILLER_84_776 VPWR VGND VPWR VGND sky130_ef_sc_hd__decap_12
X_07787_ _00520_ _00525_ VGND VGND VPWR VPWR _00526_ sky130_fd_sc_hd__nand2_1
XFILLER_56_467 VGND VGND VPWR VPWR sky130_fd_sc_hd__fill_1
XFILLER_16_309 VPWR VGND VPWR VGND sky130_ef_sc_hd__decap_12
X_06738_ _02653_ _02664_ VGND VGND VPWR VPWR _02675_ sky130_fd_sc_hd__or2_1
X_09526_ _02270_ _02271_ VGND VGND VPWR VPWR _02272_ sky130_fd_sc_hd__or2_1
X_09457_ _02195_ _02196_ VGND VGND VPWR VPWR _02198_ sky130_fd_sc_hd__nor2_1
XPHY_EDGE_ROW_98_Right_98 VGND VGND VPWR VPWR sky130_fd_sc_hd__decap_3
X_08408_ _01103_ _01104_ _01101_ VGND VGND VPWR VPWR _01138_ sky130_fd_sc_hd__o21a_1
XTAP_TAPCELL_ROW_65_1198 VGND VPWR sky130_fd_sc_hd__tapvpwrvgnd_1
XFILLER_51_150 VGND VGND VPWR VPWR sky130_fd_sc_hd__fill_1
XFILLER_24_397 VGND VGND VPWR VPWR sky130_fd_sc_hd__decap_4
X_09388_ _02118_ _02119_ VGND VGND VPWR VPWR _02122_ sky130_fd_sc_hd__xnor2_1
X_08339_ _01009_ _01011_ VGND VGND VPWR VPWR _01073_ sky130_fd_sc_hd__and2b_1
XTAP_TAPCELL_ROW_22_598 VGND VPWR sky130_fd_sc_hd__tapvpwrvgnd_1
X_11350_ net247 _04256_ VGND VGND VPWR VPWR _04258_ sky130_fd_sc_hd__xnor2_1
XFILLER_117_3 VPWR VGND VPWR VGND sky130_ef_sc_hd__decap_12
X_10301_ _03110_ _03111_ VGND VGND VPWR VPWR _03112_ sky130_fd_sc_hd__or2_1
XFILLER_4_725 VPWR VGND VPWR VGND sky130_ef_sc_hd__decap_12
X_11281_ _04172_ _04180_ VGND VGND VPWR VPWR _04182_ sky130_fd_sc_hd__xnor2_1
X_13020_ _06076_ _06077_ VGND VGND VPWR VPWR _06078_ sky130_fd_sc_hd__and2b_1
XFILLER_133_461 VPWR VGND VPWR VGND sky130_ef_sc_hd__decap_12
X_10232_ _02840_ _02850_ _02839_ VGND VGND VPWR VPWR _03037_ sky130_fd_sc_hd__a21o_1
XFILLER_4_769 VPWR VGND VPWR VGND sky130_ef_sc_hd__decap_12
XFILLER_121_634 VPWR VGND VPWR VGND sky130_ef_sc_hd__decap_12
XFILLER_105_185 VGND VGND VPWR VPWR sky130_fd_sc_hd__fill_1
XFILLER_105_163 VGND VGND VPWR VPWR sky130_fd_sc_hd__decap_4
XFILLER_79_559 VGND VGND VPWR VPWR sky130_fd_sc_hd__fill_1
XFILLER_79_548 VGND VGND VPWR VPWR sky130_fd_sc_hd__fill_1
X_10163_ _02835_ _02960_ VGND VGND VPWR VPWR _02961_ sky130_fd_sc_hd__and2_1
XFILLER_3_279 VGND VGND VPWR VPWR sky130_fd_sc_hd__fill_1
XFILLER_86_55 VPWR VGND VPWR VGND sky130_ef_sc_hd__decap_12
XFILLER_120_177 VGND VGND VPWR VPWR sky130_fd_sc_hd__decap_4
X_10094_ net686 net275 VGND VGND VPWR VPWR _02885_ sky130_fd_sc_hd__nand2_1
XFILLER_87_592 VGND VGND VPWR VPWR sky130_fd_sc_hd__decap_4
XFILLER_75_743 VPWR VGND VPWR VGND sky130_ef_sc_hd__decap_12
XFILLER_19_125 VGND VGND VPWR VPWR sky130_fd_sc_hd__fill_1
XFILLER_74_275 VGND VGND VPWR VPWR sky130_fd_sc_hd__decap_8
XFILLER_19_158 VGND VGND VPWR VPWR sky130_fd_sc_hd__decap_8
XFILLER_74_286 VGND VGND VPWR VPWR sky130_fd_sc_hd__decap_8
XFILLER_28_692 VGND VGND VPWR VPWR sky130_fd_sc_hd__decap_8
X_12804_ _05838_ _05839_ VGND VGND VPWR VPWR _05841_ sky130_fd_sc_hd__xnor2_1
X_10996_ net565 net540 net277 net275 VGND VGND VPWR VPWR _03870_ sky130_fd_sc_hd__and4_1
XFILLER_43_673 VGND VGND VPWR VPWR sky130_fd_sc_hd__fill_2
X_12735_ _05756_ _05765_ VGND VGND VPWR VPWR _05766_ sky130_fd_sc_hd__xnor2_1
XFILLER_42_161 VGND VGND VPWR VPWR sky130_fd_sc_hd__decap_3
X_12666_ _05546_ _05548_ _05545_ VGND VGND VPWR VPWR _05690_ sky130_fd_sc_hd__a21oi_1
X_11617_ _04545_ _04547_ VGND VGND VPWR VPWR _04549_ sky130_fd_sc_hd__xnor2_1
X_12597_ _05607_ _05613_ _05614_ VGND VGND VPWR VPWR _05616_ sky130_fd_sc_hd__nand3_1
XTAP_TAPCELL_ROW_41_863 VGND VPWR sky130_fd_sc_hd__tapvpwrvgnd_1
XTAP_TAPCELL_ROW_41_874 VGND VPWR sky130_fd_sc_hd__tapvpwrvgnd_1
X_11548_ _04365_ _04473_ VGND VGND VPWR VPWR _04474_ sky130_fd_sc_hd__nor2_1
XTAP_TAPCELL_ROW_96_1637 VGND VPWR sky130_fd_sc_hd__tapvpwrvgnd_1
XFILLER_7_585 VPWR VGND VPWR VGND sky130_ef_sc_hd__decap_12
Xmax_cap227 _01441_ VGND VGND VPWR VPWR net227 sky130_fd_sc_hd__buf_6
Xmax_cap238 _03159_ VGND VGND VPWR VPWR net238 sky130_fd_sc_hd__buf_1
X_11479_ _04237_ _04273_ _04236_ VGND VGND VPWR VPWR _04399_ sky130_fd_sc_hd__a21bo_1
X_13218_ _06280_ _06291_ _06293_ VGND VGND VPWR VPWR _06294_ sky130_fd_sc_hd__or3_1
XFILLER_112_623 VGND VGND VPWR VPWR sky130_fd_sc_hd__fill_1
XFILLER_32_3 VGND VGND VPWR VPWR sky130_fd_sc_hd__fill_1
X_13149_ _06090_ _06093_ _06088_ VGND VGND VPWR VPWR _06219_ sky130_fd_sc_hd__o21bai_4
XFILLER_112_645 VPWR VGND VPWR VGND sky130_ef_sc_hd__decap_12
X_07710_ net620 net303 _02131_ net643 VGND VGND VPWR VPWR _00449_ sky130_fd_sc_hd__o2bb2a_1
XFILLER_85_529 VPWR VGND VPWR VGND sky130_ef_sc_hd__decap_12
XFILLER_66_710 VGND VGND VPWR VPWR sky130_fd_sc_hd__fill_2
X_08690_ _01257_ _01259_ _01258_ VGND VGND VPWR VPWR _01418_ sky130_fd_sc_hd__o21bai_1
XFILLER_93_573 VGND VGND VPWR VPWR sky130_fd_sc_hd__decap_4
XFILLER_93_551 VGND VGND VPWR VPWR sky130_fd_sc_hd__decap_8
X_07641_ net750 net381 VGND VGND VPWR VPWR _00381_ sky130_fd_sc_hd__nand2_1
XTAP_TAPCELL_ROW_49_985 VGND VPWR sky130_fd_sc_hd__tapvpwrvgnd_1
XTAP_TAPCELL_ROW_49_974 VGND VPWR sky130_fd_sc_hd__tapvpwrvgnd_1
X_07572_ _00308_ _00310_ VGND VGND VPWR VPWR _00312_ sky130_fd_sc_hd__xnor2_1
XFILLER_80_234 VPWR VGND VPWR VGND sky130_ef_sc_hd__decap_12
XTAP_TAPCELL_ROW_105_1766 VGND VPWR sky130_fd_sc_hd__tapvpwrvgnd_1
X_09311_ _02034_ _02035_ _02036_ VGND VGND VPWR VPWR _02038_ sky130_fd_sc_hd__a21o_1
XFILLER_40_109 VGND VGND VPWR VPWR sky130_fd_sc_hd__decap_8
X_09242_ _01818_ _01832_ _01831_ VGND VGND VPWR VPWR _01966_ sky130_fd_sc_hd__o21ai_1
XFILLER_21_345 VPWR VGND VPWR VGND sky130_ef_sc_hd__decap_12
XFILLER_119_200 VGND VGND VPWR VPWR sky130_fd_sc_hd__decap_3
X_09173_ net847 VGND VGND VPWR VPWR _01898_ sky130_fd_sc_hd__inv_2
XFILLER_119_222 VGND VGND VPWR VPWR sky130_fd_sc_hd__fill_2
X_08124_ _00857_ _00858_ VGND VGND VPWR VPWR _00860_ sky130_fd_sc_hd__xnor2_2
XFILLER_119_277 VGND VGND VPWR VPWR sky130_fd_sc_hd__decap_3
XFILLER_107_417 VPWR VGND VPWR VGND sky130_ef_sc_hd__decap_12
X_08055_ _00589_ _00791_ VGND VGND VPWR VPWR _00792_ sky130_fd_sc_hd__xnor2_1
X_07006_ _04112_ _05582_ VGND VGND VPWR VPWR _05593_ sky130_fd_sc_hd__xor2_1
XFILLER_115_483 VPWR VGND VPWR VGND sky130_ef_sc_hd__decap_12
XFILLER_88_323 VGND VGND VPWR VPWR sky130_fd_sc_hd__decap_3
XFILLER_102_133 VGND VGND VPWR VPWR sky130_fd_sc_hd__fill_1
Xinput117 w22[3] VGND VGND VPWR VPWR net117 sky130_fd_sc_hd__buf_1
Xinput106 w21[0] VGND VGND VPWR VPWR net106 sky130_fd_sc_hd__clkbuf_2
Xinput128 w23[6] VGND VGND VPWR VPWR net128 sky130_fd_sc_hd__clkbuf_2
XFILLER_130_475 VGND VGND VPWR VPWR sky130_fd_sc_hd__fill_1
XFILLER_102_188 VGND VGND VPWR VPWR sky130_fd_sc_hd__decap_3
XFILLER_102_177 VGND VGND VPWR VPWR sky130_fd_sc_hd__decap_8
XFILLER_88_389 VPWR VGND VPWR VGND sky130_ef_sc_hd__decap_12
X_08957_ net517 net430 net63 net64 VGND VGND VPWR VPWR _01683_ sky130_fd_sc_hd__and4_1
Xinput139 w31[1] VGND VGND VPWR VPWR net139 sky130_fd_sc_hd__buf_1
X_08888_ _01461_ _01464_ _01613_ VGND VGND VPWR VPWR _01614_ sky130_fd_sc_hd__a21o_1
X_07908_ net603 net410 net402 net605 VGND VGND VPWR VPWR _00646_ sky130_fd_sc_hd__a22oi_1
X_07839_ _00472_ _00474_ _00575_ VGND VGND VPWR VPWR _00577_ sky130_fd_sc_hd__and3_1
XFILLER_84_562 VGND VGND VPWR VPWR sky130_fd_sc_hd__fill_2
XFILLER_72_713 VPWR VGND VPWR VGND sky130_ef_sc_hd__decap_12
XFILLER_56_253 VGND VGND VPWR VPWR sky130_fd_sc_hd__fill_2
XFILLER_72_757 VPWR VGND VPWR VGND sky130_ef_sc_hd__decap_12
XTAP_TAPCELL_ROW_67_1238 VGND VPWR sky130_fd_sc_hd__tapvpwrvgnd_1
XTAP_TAPCELL_ROW_67_1227 VGND VPWR sky130_fd_sc_hd__tapvpwrvgnd_1
XFILLER_44_448 VGND VGND VPWR VPWR sky130_fd_sc_hd__decap_8
X_10850_ _03706_ _03710_ VGND VGND VPWR VPWR _03711_ sky130_fd_sc_hd__nand2_1
XFILLER_112_53 VPWR VGND VPWR VGND sky130_ef_sc_hd__decap_12
XTAP_TAPCELL_ROW_27_668 VGND VPWR sky130_fd_sc_hd__tapvpwrvgnd_1
X_09509_ _02250_ _02253_ VGND VGND VPWR VPWR _02254_ sky130_fd_sc_hd__nor2_1
XFILLER_112_97 VGND VGND VPWR VPWR sky130_fd_sc_hd__fill_1
XTAP_TAPCELL_ROW_80_1416 VGND VPWR sky130_fd_sc_hd__tapvpwrvgnd_1
XFILLER_24_161 VGND VGND VPWR VPWR sky130_fd_sc_hd__decap_4
XTAP_TAPCELL_ROW_27_679 VGND VPWR sky130_fd_sc_hd__tapvpwrvgnd_1
X_10781_ net352 net350 net289 VGND VGND VPWR VPWR _03636_ sky130_fd_sc_hd__o21a_1
XFILLER_12_345 VGND VGND VPWR VPWR sky130_fd_sc_hd__fill_1
XFILLER_24_183 VGND VGND VPWR VPWR sky130_fd_sc_hd__fill_2
X_12520_ _05519_ _05529_ VGND VGND VPWR VPWR _05531_ sky130_fd_sc_hd__xor2_1
XPHY_EDGE_ROW_117_Right_117 VGND VGND VPWR VPWR sky130_fd_sc_hd__decap_3
XFILLER_8_305 VGND VGND VPWR VPWR sky130_fd_sc_hd__decap_3
X_12451_ _05433_ _05452_ _05454_ VGND VGND VPWR VPWR _05456_ sky130_fd_sc_hd__nand3_1
X_11402_ _04312_ _04313_ VGND VGND VPWR VPWR _04314_ sky130_fd_sc_hd__nor2_1
XFILLER_126_737 VPWR VGND VPWR VGND sky130_ef_sc_hd__decap_12
X_12382_ _05377_ _05378_ VGND VGND VPWR VPWR _05380_ sky130_fd_sc_hd__xor2_1
XFILLER_4_533 VPWR VGND VPWR VGND sky130_ef_sc_hd__decap_12
X_11333_ _04108_ _04140_ _04139_ VGND VGND VPWR VPWR _04239_ sky130_fd_sc_hd__a21o_1
XTAP_TAPCELL_ROW_78_1389 VGND VPWR sky130_fd_sc_hd__tapvpwrvgnd_1
X_11264_ _04161_ _04162_ VGND VGND VPWR VPWR _04163_ sky130_fd_sc_hd__nor2_1
XFILLER_134_781 VPWR VGND VPWR VGND sky130_ef_sc_hd__decap_12
XFILLER_106_494 VPWR VGND VPWR VGND sky130_ef_sc_hd__decap_12
X_10215_ _03017_ _03013_ net239 _03010_ VGND VGND VPWR VPWR _03018_ sky130_fd_sc_hd__a211oi_4
X_13003_ _05524_ _05908_ _05913_ VGND VGND VPWR VPWR _06059_ sky130_fd_sc_hd__or3_1
XFILLER_121_431 VGND VGND VPWR VPWR sky130_fd_sc_hd__fill_1
XTAP_TAPCELL_ROW_91_1567 VGND VPWR sky130_fd_sc_hd__tapvpwrvgnd_1
X_11195_ _04086_ _04087_ VGND VGND VPWR VPWR _04088_ sky130_fd_sc_hd__nand2_1
XFILLER_121_464 VGND VGND VPWR VPWR sky130_fd_sc_hd__decap_4
XFILLER_79_389 VGND VGND VPWR VPWR sky130_fd_sc_hd__decap_3
X_10146_ _02940_ _02941_ VGND VGND VPWR VPWR _02942_ sky130_fd_sc_hd__or2_1
XTAP_TAPCELL_ROW_7_393 VGND VPWR sky130_fd_sc_hd__tapvpwrvgnd_1
XFILLER_121_497 VGND VGND VPWR VPWR sky130_fd_sc_hd__decap_4
X_10077_ _02809_ _02816_ _02865_ VGND VGND VPWR VPWR _02868_ sky130_fd_sc_hd__and3_1
XFILLER_48_743 VGND VGND VPWR VPWR sky130_fd_sc_hd__decap_4
XTAP_TAPCELL_ROW_122_2000 VGND VPWR sky130_fd_sc_hd__tapvpwrvgnd_1
XFILLER_48_776 VPWR VGND VPWR VGND sky130_ef_sc_hd__decap_12
XFILLER_63_724 VGND VGND VPWR VPWR sky130_fd_sc_hd__decap_4
XTAP_TAPCELL_ROW_46_944 VGND VPWR sky130_fd_sc_hd__tapvpwrvgnd_1
XFILLER_47_275 VGND VGND VPWR VPWR sky130_fd_sc_hd__decap_4
XTAP_TAPCELL_ROW_46_933 VGND VPWR sky130_fd_sc_hd__tapvpwrvgnd_1
XFILLER_46_91 VPWR VGND VPWR VGND sky130_ef_sc_hd__decap_12
XFILLER_50_429 VGND VGND VPWR VPWR sky130_fd_sc_hd__fill_1
XFILLER_50_418 VGND VGND VPWR VPWR sky130_fd_sc_hd__fill_2
X_10979_ _03508_ _03851_ _03852_ VGND VGND VPWR VPWR _03853_ sky130_fd_sc_hd__nand3_1
XFILLER_31_610 VGND VGND VPWR VPWR sky130_fd_sc_hd__decap_6
X_12718_ net290 net366 net364 VGND VGND VPWR VPWR _05748_ sky130_fd_sc_hd__and3_1
XFILLER_129_542 VPWR VGND VPWR VGND sky130_ef_sc_hd__decap_12
XTAP_TAPCELL_ROW_100_1696 VGND VPWR sky130_fd_sc_hd__tapvpwrvgnd_1
X_12649_ net592 net293 VGND VGND VPWR VPWR _05672_ sky130_fd_sc_hd__nand2_1
XFILLER_30_197 VGND VGND VPWR VPWR sky130_fd_sc_hd__fill_2
XTAP_TAPCELL_ROW_133_2162 VGND VPWR sky130_fd_sc_hd__tapvpwrvgnd_1
XTAP_TAPCELL_ROW_133_2151 VGND VPWR sky130_fd_sc_hd__tapvpwrvgnd_1
XFILLER_7_393 VPWR VGND VPWR VGND sky130_ef_sc_hd__decap_12
XFILLER_131_239 VGND VGND VPWR VPWR sky130_fd_sc_hd__decap_8
X_09860_ _02630_ _02634_ VGND VGND VPWR VPWR _02635_ sky130_fd_sc_hd__xnor2_1
XTAP_TAPCELL_ROW_51_1006 VGND VPWR sky130_fd_sc_hd__tapvpwrvgnd_1
XFILLER_98_698 VGND VGND VPWR VPWR sky130_fd_sc_hd__fill_2
X_09791_ _02552_ _02559_ VGND VGND VPWR VPWR _02560_ sky130_fd_sc_hd__nand2_1
XFILLER_85_304 VPWR VGND VPWR VGND sky130_ef_sc_hd__decap_12
X_08811_ _01536_ _01537_ VGND VGND VPWR VPWR _01538_ sky130_fd_sc_hd__nor2_1
X_08742_ net535 net627 _01375_ _01374_ VGND VGND VPWR VPWR _01469_ sky130_fd_sc_hd__a31o_1
XFILLER_85_337 VGND VGND VPWR VPWR sky130_fd_sc_hd__decap_6
X_08673_ _01399_ _01400_ VGND VGND VPWR VPWR _01401_ sky130_fd_sc_hd__nor2_1
XFILLER_93_381 VGND VGND VPWR VPWR sky130_fd_sc_hd__decap_8
X_07624_ net444 net602 _00362_ _00363_ VGND VGND VPWR VPWR _00364_ sky130_fd_sc_hd__o2bb2a_1
XFILLER_39_798 VGND VGND VPWR VPWR sky130_fd_sc_hd__decap_8
XFILLER_53_234 VGND VGND VPWR VPWR sky130_fd_sc_hd__decap_3
X_07555_ _00292_ _00293_ VGND VGND VPWR VPWR _00295_ sky130_fd_sc_hd__xor2_1
XTAP_TAPCELL_ROW_24_627 VGND VPWR sky130_fd_sc_hd__tapvpwrvgnd_1
X_07486_ _00221_ _00225_ VGND VGND VPWR VPWR _00227_ sky130_fd_sc_hd__xor2_1
XFILLER_22_643 VGND VGND VPWR VPWR sky130_fd_sc_hd__fill_1
X_09225_ _01785_ _01948_ VGND VGND VPWR VPWR _01949_ sky130_fd_sc_hd__and2b_2
XTAP_TAPCELL_ROW_62_1168 VGND VPWR sky130_fd_sc_hd__tapvpwrvgnd_1
XTAP_TAPCELL_ROW_62_1157 VGND VPWR sky130_fd_sc_hd__tapvpwrvgnd_1
XFILLER_10_805 VGND VGND VPWR VPWR sky130_fd_sc_hd__decap_6
XTAP_TAPCELL_ROW_118_1946 VGND VPWR sky130_fd_sc_hd__tapvpwrvgnd_1
X_09156_ _01710_ _01716_ _01715_ VGND VGND VPWR VPWR _01881_ sky130_fd_sc_hd__a21o_1
XFILLER_108_748 VGND VGND VPWR VPWR sky130_fd_sc_hd__decap_8
XFILLER_107_225 VGND VGND VPWR VPWR sky130_fd_sc_hd__decap_8
X_09087_ _01810_ _01811_ VGND VGND VPWR VPWR _01812_ sky130_fd_sc_hd__and2b_1
X_08107_ _00716_ _00726_ _00715_ VGND VGND VPWR VPWR _00843_ sky130_fd_sc_hd__a21oi_1
XFILLER_101_6 VPWR VGND VPWR VGND sky130_ef_sc_hd__decap_12
X_08038_ _00657_ _00688_ _00656_ VGND VGND VPWR VPWR _00775_ sky130_fd_sc_hd__a21bo_1
XFILLER_122_206 VGND VGND VPWR VPWR sky130_fd_sc_hd__fill_2
XFILLER_1_503 VGND VGND VPWR VPWR sky130_fd_sc_hd__fill_1
XFILLER_77_805 VGND VGND VPWR VPWR sky130_fd_sc_hd__decap_3
X_10000_ _02780_ _02782_ _02783_ VGND VGND VPWR VPWR _02785_ sky130_fd_sc_hd__o21a_1
X_09989_ _02736_ _02773_ VGND VGND VPWR VPWR _02775_ sky130_fd_sc_hd__xnor2_1
XFILLER_67_57 VGND VGND VPWR VPWR sky130_fd_sc_hd__decap_6
XFILLER_88_197 VPWR VGND VPWR VGND sky130_ef_sc_hd__decap_12
XFILLER_91_307 VGND VGND VPWR VPWR sky130_fd_sc_hd__decap_8
XFILLER_57_551 VGND VGND VPWR VPWR sky130_fd_sc_hd__decap_3
XFILLER_57_540 VGND VGND VPWR VPWR sky130_fd_sc_hd__decap_6
XFILLER_45_713 VGND VGND VPWR VPWR sky130_fd_sc_hd__decap_8
XFILLER_45_702 VGND VGND VPWR VPWR sky130_fd_sc_hd__fill_1
XTAP_TAPCELL_ROW_4_352 VGND VPWR sky130_fd_sc_hd__tapvpwrvgnd_1
X_11951_ _04909_ _04887_ VGND VGND VPWR VPWR _04910_ sky130_fd_sc_hd__and2b_1
XFILLER_45_735 VGND VGND VPWR VPWR sky130_fd_sc_hd__fill_1
X_11882_ net271 net297 _04711_ VGND VGND VPWR VPWR _04835_ sky130_fd_sc_hd__a21o_1
X_10902_ _03764_ _03767_ VGND VGND VPWR VPWR _03768_ sky130_fd_sc_hd__and2_1
XFILLER_72_587 VGND VGND VPWR VPWR sky130_fd_sc_hd__fill_1
X_10833_ _03518_ _03536_ _03535_ VGND VGND VPWR VPWR _03692_ sky130_fd_sc_hd__o21a_1
XTAP_TAPCELL_ROW_43_903 VGND VPWR sky130_fd_sc_hd__tapvpwrvgnd_1
XFILLER_16_61 VGND VGND VPWR VPWR sky130_fd_sc_hd__decap_6
XFILLER_60_749 VGND VGND VPWR VPWR sky130_fd_sc_hd__fill_1
XFILLER_16_72 VGND VGND VPWR VPWR sky130_fd_sc_hd__fill_1
XFILLER_16_83 VGND VGND VPWR VPWR sky130_fd_sc_hd__fill_1
XFILLER_25_492 VPWR VGND VPWR VGND sky130_ef_sc_hd__decap_12
X_10764_ _03613_ _03614_ _03615_ VGND VGND VPWR VPWR _03617_ sky130_fd_sc_hd__a21o_1
X_12503_ _05327_ _05329_ _05511_ VGND VGND VPWR VPWR _05512_ sky130_fd_sc_hd__a21oi_1
XFILLER_8_113 VPWR VGND VPWR VGND sky130_ef_sc_hd__decap_12
X_10695_ net539 net283 net281 VGND VGND VPWR VPWR _03541_ sky130_fd_sc_hd__and3_1
XFILLER_12_197 VPWR VGND VPWR VGND sky130_ef_sc_hd__decap_12
X_12434_ _05434_ _05435_ _05436_ VGND VGND VPWR VPWR _05437_ sky130_fd_sc_hd__a21o_1
X_12365_ _05312_ _05360_ VGND VGND VPWR VPWR _05361_ sky130_fd_sc_hd__and2b_1
X_11316_ _03590_ _04219_ VGND VGND VPWR VPWR _04220_ sky130_fd_sc_hd__xnor2_1
X_12296_ _05223_ _05284_ VGND VGND VPWR VPWR _05286_ sky130_fd_sc_hd__xnor2_1
XFILLER_4_363 VGND VGND VPWR VPWR sky130_fd_sc_hd__fill_1
XFILLER_122_740 VPWR VGND VPWR VGND sky130_ef_sc_hd__decap_12
XFILLER_79_120 VPWR VGND VPWR VGND sky130_ef_sc_hd__decap_12
X_11247_ _04144_ _04143_ VGND VGND VPWR VPWR _04146_ sky130_fd_sc_hd__nand2b_1
X_11178_ _04066_ _04067_ VGND VGND VPWR VPWR _04070_ sky130_fd_sc_hd__xor2_1
XFILLER_95_646 VPWR VGND VPWR VGND sky130_ef_sc_hd__decap_12
XFILLER_94_112 VGND VGND VPWR VPWR sky130_fd_sc_hd__fill_2
XFILLER_67_337 VPWR VGND VPWR VGND sky130_ef_sc_hd__decap_12
X_10129_ net522 net653 net651 net526 VGND VGND VPWR VPWR _02924_ sky130_fd_sc_hd__a22oi_1
XFILLER_94_145 VGND VGND VPWR VPWR sky130_fd_sc_hd__fill_1
XFILLER_94_178 VGND VGND VPWR VPWR sky130_fd_sc_hd__decap_3
XFILLER_63_521 VGND VGND VPWR VPWR sky130_fd_sc_hd__fill_2
XFILLER_36_757 VPWR VGND VPWR VGND sky130_ef_sc_hd__decap_12
XTAP_TAPCELL_ROW_102_1725 VGND VPWR sky130_fd_sc_hd__tapvpwrvgnd_1
X_07340_ _06628_ _06629_ VGND VGND VPWR VPWR _06631_ sky130_fd_sc_hd__xnor2_2
X_09010_ _01638_ _01735_ VGND VGND VPWR VPWR _01736_ sky130_fd_sc_hd__nor2_1
X_07271_ _06560_ _06561_ VGND VGND VPWR VPWR _06562_ sky130_fd_sc_hd__xnor2_1
XFILLER_31_473 VGND VGND VPWR VPWR sky130_fd_sc_hd__fill_1
XFILLER_136_309 VGND VGND VPWR VPWR sky130_fd_sc_hd__fill_2
XFILLER_129_372 VPWR VGND VPWR VGND sky130_ef_sc_hd__decap_12
XFILLER_105_718 VGND VGND VPWR VPWR sky130_fd_sc_hd__decap_8
XFILLER_105_729 VGND VGND VPWR VPWR sky130_fd_sc_hd__decap_4
XTAP_TAPCELL_ROW_113_1876 VGND VPWR sky130_fd_sc_hd__tapvpwrvgnd_1
X_09912_ _02690_ _02691_ VGND VGND VPWR VPWR _02692_ sky130_fd_sc_hd__and2_1
Xfanout604 net135 VGND VGND VPWR VPWR net604 sky130_fd_sc_hd__dlymetal6s2s_1
Xfanout615 net623 VGND VGND VPWR VPWR net615 sky130_fd_sc_hd__buf_2
X_09843_ _02480_ _02482_ _02615_ VGND VGND VPWR VPWR _02617_ sky130_fd_sc_hd__or3b_1
XFILLER_112_261 VGND VGND VPWR VPWR sky130_fd_sc_hd__fill_1
Xfanout626 net127 VGND VGND VPWR VPWR net626 sky130_fd_sc_hd__buf_2
XFILLER_86_613 VGND VGND VPWR VPWR sky130_fd_sc_hd__decap_4
Xfanout637 net120 VGND VGND VPWR VPWR net637 sky130_fd_sc_hd__buf_1
Xfanout648 net119 VGND VGND VPWR VPWR net648 sky130_fd_sc_hd__clkbuf_2
XFILLER_98_495 VPWR VGND VPWR VGND sky130_ef_sc_hd__decap_12
Xfanout659 net112 VGND VGND VPWR VPWR net659 sky130_fd_sc_hd__buf_1
X_06986_ _03839_ _03850_ _03871_ _03795_ VGND VGND VPWR VPWR _05374_ sky130_fd_sc_hd__o22ai_1
X_09774_ _02538_ _02539_ VGND VGND VPWR VPWR _02541_ sky130_fd_sc_hd__xor2_1
X_08725_ _01346_ _01347_ _01360_ _01358_ _01195_ VGND VGND VPWR VPWR _01452_ sky130_fd_sc_hd__a32o_1
XTAP_TAPCELL_ROW_1_311 VGND VPWR sky130_fd_sc_hd__tapvpwrvgnd_1
X_08656_ _01380_ _01381_ VGND VGND VPWR VPWR _01384_ sky130_fd_sc_hd__xnor2_1
X_07607_ _06561_ _00346_ VGND VGND VPWR VPWR _00347_ sky130_fd_sc_hd__xnor2_1
X_08587_ _01210_ _01313_ _01314_ VGND VGND VPWR VPWR _01316_ sky130_fd_sc_hd__nand3_2
X_07538_ _00278_ _00277_ VGND VGND VPWR VPWR _00279_ sky130_fd_sc_hd__or2_4
XFILLER_41_237 VGND VGND VPWR VPWR sky130_fd_sc_hd__decap_3
X_07469_ net607 net419 _00207_ _00208_ VGND VGND VPWR VPWR _00210_ sky130_fd_sc_hd__nand4_1
X_09208_ _01929_ _01930_ VGND VGND VPWR VPWR _01932_ sky130_fd_sc_hd__xor2_1
Xrebuffer232 _03001_ VGND VGND VPWR VPWR net932 sky130_fd_sc_hd__clkbuf_1
X_10480_ _03155_ _03152_ _03305_ _03306_ VGND VGND VPWR VPWR _03307_ sky130_fd_sc_hd__a211o_1
X_09139_ _01858_ _01862_ VGND VGND VPWR VPWR _01864_ sky130_fd_sc_hd__xor2_1
Xrebuffer243 _03002_ VGND VGND VPWR VPWR net943 sky130_fd_sc_hd__buf_6
XFILLER_5_105 VGND VGND VPWR VPWR sky130_fd_sc_hd__decap_6
XFILLER_118_41 VPWR VGND VPWR VGND sky130_ef_sc_hd__decap_12
XFILLER_108_578 VGND VGND VPWR VPWR sky130_fd_sc_hd__decap_8
X_12150_ _04841_ _04977_ _05125_ _05124_ VGND VGND VPWR VPWR _05127_ sky130_fd_sc_hd__a22o_1
XFILLER_5_149 VPWR VGND VPWR VGND sky130_ef_sc_hd__decap_12
XFILLER_108_589 VGND VGND VPWR VPWR sky130_fd_sc_hd__decap_8
XTAP_TAPCELL_ROW_75_1348 VGND VPWR sky130_fd_sc_hd__tapvpwrvgnd_1
XTAP_TAPCELL_ROW_9_422 VGND VPWR sky130_fd_sc_hd__tapvpwrvgnd_1
X_11101_ _03979_ _03983_ _03984_ VGND VGND VPWR VPWR _03986_ sky130_fd_sc_hd__and3_1
XFILLER_118_85 VGND VGND VPWR VPWR sky130_fd_sc_hd__fill_1
XFILLER_89_440 VGND VGND VPWR VPWR sky130_fd_sc_hd__decap_8
XFILLER_78_56 VGND VGND VPWR VPWR sky130_fd_sc_hd__decap_3
X_12081_ _04928_ _05050_ VGND VGND VPWR VPWR _05052_ sky130_fd_sc_hd__or2_1
XFILLER_103_250 VPWR VGND VPWR VGND sky130_ef_sc_hd__decap_12
XFILLER_89_473 VPWR VGND VPWR VGND sky130_ef_sc_hd__decap_12
X_11032_ net496 net489 net647 net636 VGND VGND VPWR VPWR _03910_ sky130_fd_sc_hd__and4_1
XFILLER_49_337 VPWR VGND VPWR VGND sky130_ef_sc_hd__decap_12
XFILLER_76_145 VGND VGND VPWR VPWR sky130_fd_sc_hd__fill_1
XFILLER_64_307 VGND VGND VPWR VPWR sky130_fd_sc_hd__fill_1
XFILLER_49_359 VPWR VGND VPWR VGND sky130_ef_sc_hd__decap_12
XFILLER_94_66 VPWR VGND VPWR VGND sky130_ef_sc_hd__decap_12
XFILLER_64_329 VPWR VGND VPWR VGND sky130_ef_sc_hd__decap_12
XFILLER_57_381 VGND VGND VPWR VPWR sky130_fd_sc_hd__fill_1
XFILLER_18_713 VPWR VGND VPWR VGND sky130_ef_sc_hd__decap_12
X_12983_ _06036_ _06035_ VGND VGND VPWR VPWR _06037_ sky130_fd_sc_hd__nand2b_1
X_11934_ net508 net675 net673 net524 VGND VGND VPWR VPWR _04891_ sky130_fd_sc_hd__a22o_1
XFILLER_18_757 VGND VGND VPWR VPWR sky130_fd_sc_hd__fill_1
XFILLER_45_565 VGND VGND VPWR VPWR sky130_fd_sc_hd__fill_1
XFILLER_33_727 VGND VGND VPWR VPWR sky130_fd_sc_hd__fill_1
XTAP_TAPCELL_ROW_86_1499 VGND VPWR sky130_fd_sc_hd__tapvpwrvgnd_1
X_11865_ net717 _04813_ _04736_ VGND VGND VPWR VPWR _04816_ sky130_fd_sc_hd__o21ai_4
X_11796_ net446 net598 net588 net454 VGND VGND VPWR VPWR _04740_ sky130_fd_sc_hd__a22o_1
X_10816_ _03669_ _03671_ _03564_ VGND VGND VPWR VPWR _03674_ sky130_fd_sc_hd__a21o_1
X_10747_ _03594_ _03595_ VGND VGND VPWR VPWR _03599_ sky130_fd_sc_hd__xnor2_1
XFILLER_41_782 VGND VGND VPWR VPWR sky130_fd_sc_hd__fill_2
XFILLER_71_7 VGND VGND VPWR VPWR sky130_fd_sc_hd__decap_6
XFILLER_40_281 VGND VGND VPWR VPWR sky130_fd_sc_hd__decap_3
X_10678_ net590 net277 net275 net615 VGND VGND VPWR VPWR _03523_ sky130_fd_sc_hd__a22o_1
X_12417_ _05415_ _05416_ _05409_ VGND VGND VPWR VPWR _05419_ sky130_fd_sc_hd__a21o_1
XTAP_TAPCELL_ROW_130_2110 VGND VPWR sky130_fd_sc_hd__tapvpwrvgnd_1
XFILLER_126_342 VPWR VGND VPWR VGND sky130_ef_sc_hd__decap_12
Xoutput207 net207 VGND VGND VPWR VPWR out2[7] sky130_fd_sc_hd__buf_2
X_13397_ clknet_3_1__leaf_clk _00014_ _00107_ VGND VGND VPWR VPWR net196 sky130_fd_sc_hd__dfrtp_1
Xclone91 net380 VGND VGND VPWR VPWR net791 sky130_fd_sc_hd__clkbuf_1
XTAP_TAPCELL_ROW_130_2121 VGND VPWR sky130_fd_sc_hd__tapvpwrvgnd_1
Xoutput218 net218 VGND VGND VPWR VPWR out3[2] sky130_fd_sc_hd__buf_2
X_12348_ net301 net299 VGND VGND VPWR VPWR _05343_ sky130_fd_sc_hd__or2_1
X_12279_ _05266_ _05267_ VGND VGND VPWR VPWR _05268_ sky130_fd_sc_hd__and2b_1
XFILLER_101_209 VGND VGND VPWR VPWR sky130_fd_sc_hd__decap_6
XFILLER_4_53 VPWR VGND VPWR VGND sky130_ef_sc_hd__decap_12
X_06840_ _03248_ _03762_ VGND VGND VPWR VPWR _03784_ sky130_fd_sc_hd__nor2_1
XFILLER_68_657 VPWR VGND VPWR VGND sky130_ef_sc_hd__decap_12
XFILLER_4_97 VPWR VGND VPWR VGND sky130_ef_sc_hd__decap_12
XFILLER_110_754 VGND VGND VPWR VPWR sky130_fd_sc_hd__fill_2
XFILLER_67_167 VGND VGND VPWR VPWR sky130_fd_sc_hd__fill_1
XTAP_TAPCELL_ROW_128_2083 VGND VPWR sky130_fd_sc_hd__tapvpwrvgnd_1
X_06771_ _02599_ _03020_ VGND VGND VPWR VPWR _03031_ sky130_fd_sc_hd__xor2_1
XFILLER_95_498 VGND VGND VPWR VPWR sky130_fd_sc_hd__decap_6
XFILLER_95_487 VGND VGND VPWR VPWR sky130_fd_sc_hd__decap_4
X_09490_ _02233_ _02231_ VGND VGND VPWR VPWR _02234_ sky130_fd_sc_hd__and2b_1
X_08510_ net455 net556 net554 net465 VGND VGND VPWR VPWR _01239_ sky130_fd_sc_hd__a22oi_1
X_08441_ net509 net633 _01141_ VGND VGND VPWR VPWR _01170_ sky130_fd_sc_hd__and3_1
XFILLER_91_671 VGND VGND VPWR VPWR sky130_fd_sc_hd__fill_1
XFILLER_23_204 VPWR VGND VPWR VGND sky130_ef_sc_hd__decap_12
XFILLER_36_587 VGND VGND VPWR VPWR sky130_fd_sc_hd__fill_1
XFILLER_51_535 VGND VGND VPWR VPWR sky130_fd_sc_hd__decap_3
XFILLER_24_749 VGND VGND VPWR VPWR sky130_fd_sc_hd__decap_6
X_08372_ _01101_ _01102_ VGND VGND VPWR VPWR _01103_ sky130_fd_sc_hd__nand2_1
XFILLER_51_557 VGND VGND VPWR VPWR sky130_fd_sc_hd__decap_3
XTAP_TAPCELL_ROW_34_766 VGND VPWR sky130_fd_sc_hd__tapvpwrvgnd_1
XTAP_TAPCELL_ROW_34_777 VGND VPWR sky130_fd_sc_hd__tapvpwrvgnd_1
X_07323_ _06611_ _06612_ _06608_ VGND VGND VPWR VPWR _06614_ sky130_fd_sc_hd__a21o_1
X_07254_ _06541_ _06542_ VGND VGND VPWR VPWR _06545_ sky130_fd_sc_hd__xor2_1
XTAP_TAPCELL_ROW_14_490 VGND VPWR sky130_fd_sc_hd__tapvpwrvgnd_1
XFILLER_31_281 VGND VGND VPWR VPWR sky130_fd_sc_hd__decap_8
XFILLER_117_342 VGND VGND VPWR VPWR sky130_fd_sc_hd__decap_4
XTAP_TAPCELL_ROW_115_1905 VGND VPWR sky130_fd_sc_hd__tapvpwrvgnd_1
X_07185_ _06458_ _06475_ _06476_ VGND VGND VPWR VPWR _06477_ sky130_fd_sc_hd__and3_1
XFILLER_3_609 VGND VGND VPWR VPWR sky130_fd_sc_hd__decap_6
XFILLER_132_345 VPWR VGND VPWR VGND sky130_ef_sc_hd__decap_12
XFILLER_120_529 VGND VGND VPWR VPWR sky130_fd_sc_hd__decap_3
Xfanout423 net424 VGND VGND VPWR VPWR net423 sky130_fd_sc_hd__clkbuf_2
XFILLER_59_613 VGND VGND VPWR VPWR sky130_fd_sc_hd__decap_3
XTAP_TAPCELL_ROW_57_1089 VGND VPWR sky130_fd_sc_hd__tapvpwrvgnd_1
Xfanout412 net413 VGND VGND VPWR VPWR net412 sky130_fd_sc_hd__buf_2
Xfanout401 net32 VGND VGND VPWR VPWR net401 sky130_fd_sc_hd__buf_2
XFILLER_113_581 VPWR VGND VPWR VGND sky130_ef_sc_hd__decap_12
Xfanout445 net28 VGND VGND VPWR VPWR net445 sky130_fd_sc_hd__buf_2
XFILLER_86_421 VGND VGND VPWR VPWR sky130_fd_sc_hd__fill_1
Xfanout456 net457 VGND VGND VPWR VPWR net456 sky130_fd_sc_hd__buf_2
XFILLER_59_635 VPWR VGND VPWR VGND sky130_ef_sc_hd__decap_12
Xfanout434 net441 VGND VGND VPWR VPWR net434 sky130_fd_sc_hd__clkbuf_2
X_09826_ _02597_ _02590_ VGND VGND VPWR VPWR _02598_ sky130_fd_sc_hd__nand2b_1
XFILLER_101_765 VPWR VGND VPWR VGND sky130_ef_sc_hd__decap_12
XTAP_TAPCELL_ROW_70_1278 VGND VPWR sky130_fd_sc_hd__tapvpwrvgnd_1
Xfanout489 net491 VGND VGND VPWR VPWR net489 sky130_fd_sc_hd__buf_2
Xfanout478 net480 VGND VGND VPWR VPWR net478 sky130_fd_sc_hd__buf_2
Xfanout467 net468 VGND VGND VPWR VPWR net467 sky130_fd_sc_hd__buf_2
X_06969_ net321 net619 net595 net322 VGND VGND VPWR VPWR _05188_ sky130_fd_sc_hd__a22o_1
X_09757_ _02382_ _02395_ _02521_ VGND VGND VPWR VPWR _02523_ sky130_fd_sc_hd__o21a_1
XFILLER_46_329 VGND VGND VPWR VPWR sky130_fd_sc_hd__fill_2
X_08708_ _01389_ _01434_ net722 VGND VGND VPWR VPWR _01436_ sky130_fd_sc_hd__nor3_2
X_09688_ _02444_ _02445_ VGND VGND VPWR VPWR _02448_ sky130_fd_sc_hd__xnor2_1
XFILLER_82_660 VPWR VGND VPWR VGND sky130_ef_sc_hd__decap_12
XFILLER_54_362 VGND VGND VPWR VPWR sky130_fd_sc_hd__fill_2
XFILLER_14_204 VPWR VGND VPWR VGND sky130_ef_sc_hd__decap_12
XFILLER_27_587 VPWR VGND VPWR VGND sky130_ef_sc_hd__decap_12
X_08639_ net535 net626 VGND VGND VPWR VPWR _01367_ sky130_fd_sc_hd__nand2_1
XFILLER_54_395 VGND VGND VPWR VPWR sky130_fd_sc_hd__fill_1
XFILLER_120_53 VPWR VGND VPWR VGND sky130_ef_sc_hd__decap_12
X_11650_ _04581_ _04582_ VGND VGND VPWR VPWR _00003_ sky130_fd_sc_hd__and2_1
XFILLER_30_708 VGND VGND VPWR VPWR sky130_fd_sc_hd__decap_3
XFILLER_120_97 VGND VGND VPWR VPWR sky130_fd_sc_hd__decap_4
X_11581_ _04508_ _04509_ VGND VGND VPWR VPWR _04510_ sky130_fd_sc_hd__and2b_1
XFILLER_23_782 VGND VGND VPWR VPWR sky130_fd_sc_hd__fill_2
X_10601_ _03262_ _03265_ _03264_ VGND VGND VPWR VPWR _03439_ sky130_fd_sc_hd__o21bai_1
X_10532_ _03229_ _03239_ _03238_ _03236_ VGND VGND VPWR VPWR _03363_ sky130_fd_sc_hd__a2bb2o_1
X_13320_ net397 VGND VGND VPWR VPWR _00094_ sky130_fd_sc_hd__inv_2
XFILLER_22_292 VPWR VGND VPWR VGND sky130_ef_sc_hd__decap_12
XFILLER_129_51 VGND VGND VPWR VPWR sky130_fd_sc_hd__decap_4
XFILLER_136_651 VGND VGND VPWR VPWR sky130_fd_sc_hd__decap_3
XFILLER_108_331 VGND VGND VPWR VPWR sky130_fd_sc_hd__decap_6
X_13251_ _05388_ _06251_ _06327_ VGND VGND VPWR VPWR _06328_ sky130_fd_sc_hd__a21boi_1
XFILLER_13_95 VPWR VGND VPWR VGND sky130_ef_sc_hd__decap_12
X_10463_ _03286_ _03287_ VGND VGND VPWR VPWR _03288_ sky130_fd_sc_hd__and2b_1
XFILLER_136_695 VGND VGND VPWR VPWR sky130_fd_sc_hd__decap_4
XFILLER_136_673 VGND VGND VPWR VPWR sky130_fd_sc_hd__fill_2
XFILLER_135_161 VGND VGND VPWR VPWR sky130_fd_sc_hd__decap_6
X_10394_ _03210_ _03211_ VGND VGND VPWR VPWR _03213_ sky130_fd_sc_hd__xor2_1
X_12202_ _05135_ _05181_ VGND VGND VPWR VPWR _05183_ sky130_fd_sc_hd__xnor2_1
X_13182_ _05894_ _05994_ _06252_ VGND VGND VPWR VPWR _06254_ sky130_fd_sc_hd__o21ai_1
XFILLER_89_99 VPWR VGND VPWR VGND sky130_ef_sc_hd__decap_12
X_12133_ _05076_ net719 _05107_ VGND VGND VPWR VPWR _05108_ sky130_fd_sc_hd__nand3_2
XFILLER_111_529 VGND VGND VPWR VPWR sky130_fd_sc_hd__fill_1
X_12064_ net500 net675 net673 net508 VGND VGND VPWR VPWR _05033_ sky130_fd_sc_hd__a22o_1
XFILLER_89_281 VPWR VGND VPWR VGND sky130_ef_sc_hd__decap_12
X_11015_ _02044_ net635 _03746_ _03745_ VGND VGND VPWR VPWR _03891_ sky130_fd_sc_hd__a31o_1
XTAP_TAPCELL_ROW_88_1528 VGND VPWR sky130_fd_sc_hd__tapvpwrvgnd_1
XFILLER_49_189 VGND VGND VPWR VPWR sky130_fd_sc_hd__decap_3
XFILLER_64_126 VGND VGND VPWR VPWR sky130_fd_sc_hd__fill_2
X_12966_ net420 _02295_ _05195_ VGND VGND VPWR VPWR _06018_ sky130_fd_sc_hd__o21ai_1
X_11917_ _04689_ _04691_ VGND VGND VPWR VPWR _04873_ sky130_fd_sc_hd__or2_1
X_12897_ _05942_ _05941_ VGND VGND VPWR VPWR _05944_ sky130_fd_sc_hd__nand2b_1
XFILLER_33_524 VGND VGND VPWR VPWR sky130_fd_sc_hd__fill_1
X_11848_ _04789_ _04797_ _04790_ VGND VGND VPWR VPWR _04798_ sky130_fd_sc_hd__and3_4
XFILLER_33_568 VPWR VGND VPWR VGND sky130_ef_sc_hd__decap_12
XFILLER_20_229 VGND VGND VPWR VPWR sky130_fd_sc_hd__decap_3
XTAP_TAPCELL_ROW_31_725 VGND VPWR sky130_fd_sc_hd__tapvpwrvgnd_1
XFILLER_119_629 VGND VGND VPWR VPWR sky130_fd_sc_hd__fill_2
X_11779_ _04720_ _04721_ VGND VGND VPWR VPWR _04722_ sky130_fd_sc_hd__or2_1
XFILLER_13_281 VPWR VGND VPWR VGND sky130_ef_sc_hd__decap_12
XTAP_TAPCELL_ROW_99_1679 VGND VPWR sky130_fd_sc_hd__tapvpwrvgnd_1
XFILLER_9_274 VGND VGND VPWR VPWR sky130_fd_sc_hd__decap_6
XFILLER_127_673 VPWR VGND VPWR VGND sky130_ef_sc_hd__decap_12
XFILLER_114_323 VPWR VGND VPWR VGND sky130_ef_sc_hd__decap_12
XFILLER_130_805 VGND VGND VPWR VPWR sky130_fd_sc_hd__decap_6
X_08990_ _01713_ _01714_ VGND VGND VPWR VPWR _01716_ sky130_fd_sc_hd__xnor2_1
XTAP_TAPCELL_ROW_110_1835 VGND VPWR sky130_fd_sc_hd__tapvpwrvgnd_1
XFILLER_96_741 VGND VGND VPWR VPWR sky130_fd_sc_hd__decap_4
X_07941_ _00674_ _00677_ VGND VGND VPWR VPWR _00679_ sky130_fd_sc_hd__xnor2_1
XFILLER_68_421 VGND VGND VPWR VPWR sky130_fd_sc_hd__fill_1
X_07872_ _00606_ _00607_ VGND VGND VPWR VPWR _00610_ sky130_fd_sc_hd__xor2_1
X_09611_ _02085_ _02223_ _02222_ VGND VGND VPWR VPWR _02365_ sky130_fd_sc_hd__a21oi_2
X_06823_ _03107_ _03587_ VGND VGND VPWR VPWR _03598_ sky130_fd_sc_hd__nor2_1
XFILLER_96_785 VPWR VGND VPWR VGND sky130_ef_sc_hd__decap_12
XFILLER_95_273 VGND VGND VPWR VPWR sky130_fd_sc_hd__decap_6
XFILLER_18_29 VGND VGND VPWR VPWR sky130_fd_sc_hd__fill_2
XFILLER_28_307 VGND VGND VPWR VPWR sky130_fd_sc_hd__fill_1
XTAP_TAPCELL_ROW_39_836 VGND VPWR sky130_fd_sc_hd__tapvpwrvgnd_1
X_06754_ net460 net611 net609 net469 VGND VGND VPWR VPWR _02845_ sky130_fd_sc_hd__a22oi_1
X_09542_ net786 _02208_ _02178_ _02181_ VGND VGND VPWR VPWR _02290_ sky130_fd_sc_hd__o31ai_2
XTAP_TAPCELL_ROW_39_847 VGND VPWR sky130_fd_sc_hd__tapvpwrvgnd_1
X_09473_ _02162_ _02214_ VGND VGND VPWR VPWR _02215_ sky130_fd_sc_hd__xnor2_1
XTAP_TAPCELL_ROW_19_560 VGND VPWR sky130_fd_sc_hd__tapvpwrvgnd_1
X_06685_ net590 VGND VGND VPWR VPWR _02098_ sky130_fd_sc_hd__inv_4
X_08424_ net270 net260 _01152_ _01153_ VGND VGND VPWR VPWR _01154_ sky130_fd_sc_hd__and4_1
XFILLER_51_365 VGND VGND VPWR VPWR sky130_fd_sc_hd__decap_4
XTAP_TAPCELL_ROW_121_1986 VGND VPWR sky130_fd_sc_hd__tapvpwrvgnd_1
X_08355_ net699 net473 net341 net557 VGND VGND VPWR VPWR _01087_ sky130_fd_sc_hd__and4_1
XFILLER_11_218 VGND VGND VPWR VPWR sky130_fd_sc_hd__decap_6
Xclkload5 clknet_3_6__leaf_clk VGND VGND VPWR VPWR clkload5/Y sky130_fd_sc_hd__clkinvlp_4
X_07306_ _02011_ net373 _06595_ _06596_ VGND VGND VPWR VPWR _06597_ sky130_fd_sc_hd__a22o_1
X_08286_ _00780_ _00902_ _00901_ VGND VGND VPWR VPWR _01021_ sky130_fd_sc_hd__a21oi_1
X_07237_ _06526_ _06527_ VGND VGND VPWR VPWR _06528_ sky130_fd_sc_hd__nand2_1
XTAP_TAPCELL_ROW_59_1118 VGND VPWR sky130_fd_sc_hd__tapvpwrvgnd_1
X_07168_ net427 net769 net386 net384 VGND VGND VPWR VPWR _06460_ sky130_fd_sc_hd__and4_1
XFILLER_3_417 VPWR VGND VPWR VGND sky130_ef_sc_hd__decap_12
XFILLER_118_695 VGND VGND VPWR VPWR sky130_fd_sc_hd__fill_1
XFILLER_105_334 VGND VGND VPWR VPWR sky130_fd_sc_hd__fill_2
XTAP_TAPCELL_ROW_72_1307 VGND VPWR sky130_fd_sc_hd__tapvpwrvgnd_1
XFILLER_133_665 VGND VGND VPWR VPWR sky130_fd_sc_hd__decap_6
XFILLER_132_153 VPWR VGND VPWR VGND sky130_ef_sc_hd__decap_12
X_07099_ _06388_ _06389_ VGND VGND VPWR VPWR _06391_ sky130_fd_sc_hd__xor2_1
XFILLER_120_337 VGND VGND VPWR VPWR sky130_fd_sc_hd__decap_8
XFILLER_59_421 VPWR VGND VPWR VGND sky130_ef_sc_hd__decap_12
Xfanout253 net96 VGND VGND VPWR VPWR net253 sky130_fd_sc_hd__buf_2
Xfanout264 net90 VGND VGND VPWR VPWR net264 sky130_fd_sc_hd__buf_2
X_09809_ net545 net253 _02197_ net573 VGND VGND VPWR VPWR _02580_ sky130_fd_sc_hd__o2bb2a_1
XFILLER_86_284 VPWR VGND VPWR VGND sky130_ef_sc_hd__decap_12
Xfanout297 net77 VGND VGND VPWR VPWR net297 sky130_fd_sc_hd__clkbuf_2
XFILLER_47_627 VGND VGND VPWR VPWR sky130_fd_sc_hd__decap_8
XFILLER_46_115 VPWR VGND VPWR VGND sky130_ef_sc_hd__decap_12
Xfanout275 net86 VGND VGND VPWR VPWR net275 sky130_fd_sc_hd__buf_2
Xfanout286 net289 VGND VGND VPWR VPWR net286 sky130_fd_sc_hd__clkbuf_4
XFILLER_75_57 VGND VGND VPWR VPWR sky130_fd_sc_hd__fill_2
XFILLER_74_435 VGND VGND VPWR VPWR sky130_fd_sc_hd__fill_1
X_12820_ _05842_ _05858_ VGND VGND VPWR VPWR _05859_ sky130_fd_sc_hd__xnor2_1
XFILLER_61_129 VGND VGND VPWR VPWR sky130_fd_sc_hd__fill_1
XFILLER_15_535 VGND VGND VPWR VPWR sky130_fd_sc_hd__decap_8
X_12751_ _05589_ _05590_ _05781_ VGND VGND VPWR VPWR _05784_ sky130_fd_sc_hd__or3_1
XTAP_TAPCELL_ROW_83_1458 VGND VPWR sky130_fd_sc_hd__tapvpwrvgnd_1
X_11702_ _04576_ _04596_ _04637_ VGND VGND VPWR VPWR _04638_ sky130_fd_sc_hd__nand3b_1
X_12682_ _05562_ _05574_ _05573_ VGND VGND VPWR VPWR _05708_ sky130_fd_sc_hd__o21ai_1
XFILLER_91_89 VPWR VGND VPWR VGND sky130_ef_sc_hd__decap_12
X_11633_ _04543_ _04565_ VGND VGND VPWR VPWR _04566_ sky130_fd_sc_hd__xnor2_1
XFILLER_30_505 VGND VGND VPWR VPWR sky130_fd_sc_hd__fill_1
XFILLER_42_365 VGND VGND VPWR VPWR sky130_fd_sc_hd__fill_1
XFILLER_11_741 VPWR VGND VPWR VGND sky130_ef_sc_hd__decap_12
XFILLER_24_61 VPWR VGND VPWR VGND sky130_ef_sc_hd__decap_12
XFILLER_11_785 VPWR VGND VPWR VGND sky130_ef_sc_hd__decap_12
XFILLER_10_251 VGND VGND VPWR VPWR sky130_fd_sc_hd__fill_1
X_11564_ _04481_ _04490_ VGND VGND VPWR VPWR _04491_ sky130_fd_sc_hd__xnor2_1
X_13303_ net394 VGND VGND VPWR VPWR _00077_ sky130_fd_sc_hd__inv_2
X_10515_ net616 net591 net84 net278 VGND VGND VPWR VPWR _03344_ sky130_fd_sc_hd__and4_1
XFILLER_6_233 VPWR VGND VPWR VGND sky130_ef_sc_hd__decap_12
X_11495_ _04286_ _04295_ VGND VGND VPWR VPWR _04416_ sky130_fd_sc_hd__nor2_4
X_10446_ _03266_ _03267_ _03268_ VGND VGND VPWR VPWR _03269_ sky130_fd_sc_hd__nand3_1
XFILLER_6_277 VPWR VGND VPWR VGND sky130_ef_sc_hd__decap_12
X_13234_ _06310_ _06309_ VGND VGND VPWR VPWR _06311_ sky130_fd_sc_hd__nand2b_1
XFILLER_123_120 VGND VGND VPWR VPWR sky130_fd_sc_hd__fill_1
XFILLER_112_805 VGND VGND VPWR VPWR sky130_fd_sc_hd__decap_6
X_10377_ _03193_ _03192_ VGND VGND VPWR VPWR _03195_ sky130_fd_sc_hd__nand2b_1
X_13165_ _06105_ _06108_ _06120_ VGND VGND VPWR VPWR _06235_ sky130_fd_sc_hd__a21o_1
XFILLER_111_337 VPWR VGND VPWR VGND sky130_ef_sc_hd__decap_12
XFILLER_97_549 VGND VGND VPWR VPWR sky130_fd_sc_hd__decap_8
XFILLER_69_218 VGND VGND VPWR VPWR sky130_fd_sc_hd__decap_6
X_12116_ net357 net44 VGND VGND VPWR VPWR _05089_ sky130_fd_sc_hd__nand2_1
X_13096_ _06005_ _06034_ _06004_ VGND VGND VPWR VPWR _06160_ sky130_fd_sc_hd__a21oi_1
X_12047_ _04874_ _05013_ VGND VGND VPWR VPWR _05015_ sky130_fd_sc_hd__xnor2_1
XTAP_TAPCELL_ROW_125_2042 VGND VPWR sky130_fd_sc_hd__tapvpwrvgnd_1
XFILLER_92_221 VGND VGND VPWR VPWR sky130_fd_sc_hd__decap_8
XFILLER_77_295 VGND VGND VPWR VPWR sky130_fd_sc_hd__decap_3
XFILLER_93_799 VGND VGND VPWR VPWR sky130_fd_sc_hd__decap_4
X_12949_ _05989_ _05999_ VGND VGND VPWR VPWR _06000_ sky130_fd_sc_hd__nand2b_1
XFILLER_60_162 VGND VGND VPWR VPWR sky130_fd_sc_hd__decap_4
XFILLER_21_505 VPWR VGND VPWR VGND sky130_ef_sc_hd__decap_12
XFILLER_33_365 VGND VGND VPWR VPWR sky130_fd_sc_hd__fill_1
X_08140_ _00869_ _00875_ VGND VGND VPWR VPWR _00876_ sky130_fd_sc_hd__nand2_1
X_08071_ _00807_ _00779_ VGND VGND VPWR VPWR _00808_ sky130_fd_sc_hd__and2b_1
XTAP_TAPCELL_ROW_136_2193 VGND VPWR sky130_fd_sc_hd__tapvpwrvgnd_1
XFILLER_134_418 VGND VGND VPWR VPWR sky130_fd_sc_hd__fill_2
X_07022_ _05659_ _05757_ VGND VGND VPWR VPWR _05768_ sky130_fd_sc_hd__xnor2_1
XFILLER_115_632 VGND VGND VPWR VPWR sky130_fd_sc_hd__decap_3
XFILLER_114_153 VGND VGND VPWR VPWR sky130_fd_sc_hd__decap_8
XFILLER_130_613 VPWR VGND VPWR VGND sky130_ef_sc_hd__decap_12
XFILLER_115_687 VPWR VGND VPWR VGND sky130_ef_sc_hd__decap_12
X_08973_ net335 net60 net329 net358 VGND VGND VPWR VPWR _01699_ sky130_fd_sc_hd__a22o_1
XTAP_TAPCELL_ROW_54_1048 VGND VPWR sky130_fd_sc_hd__tapvpwrvgnd_1
XFILLER_130_657 VPWR VGND VPWR VGND sky130_ef_sc_hd__decap_12
X_07924_ _00660_ _00661_ VGND VGND VPWR VPWR _00662_ sky130_fd_sc_hd__or2_1
XFILLER_69_763 VGND VGND VPWR VPWR sky130_fd_sc_hd__decap_4
XFILLER_29_28 VGND VGND VPWR VPWR sky130_fd_sc_hd__fill_2
XFILLER_96_571 VPWR VGND VPWR VGND sky130_ef_sc_hd__decap_12
XFILLER_69_785 VPWR VGND VPWR VGND sky130_ef_sc_hd__decap_12
X_07855_ _00587_ _00591_ VGND VGND VPWR VPWR _00593_ sky130_fd_sc_hd__xnor2_1
XFILLER_84_755 VGND VGND VPWR VPWR sky130_fd_sc_hd__fill_1
XFILLER_28_126 VGND VGND VPWR VPWR sky130_fd_sc_hd__fill_1
X_06806_ _03390_ _03401_ net668 net319 VGND VGND VPWR VPWR _03412_ sky130_fd_sc_hd__and4bb_1
XFILLER_84_788 VPWR VGND VPWR VGND sky130_ef_sc_hd__decap_12
X_07786_ _06587_ _00524_ VGND VGND VPWR VPWR _00525_ sky130_fd_sc_hd__xnor2_1
X_06737_ net323 net267 net687 net320 VGND VGND VPWR VPWR _02664_ sky130_fd_sc_hd__and4_1
X_09525_ _02107_ _02117_ _02116_ VGND VGND VPWR VPWR _02271_ sky130_fd_sc_hd__a21oi_1
XFILLER_71_449 VGND VGND VPWR VPWR sky130_fd_sc_hd__decap_6
XFILLER_37_671 VGND VGND VPWR VPWR sky130_fd_sc_hd__fill_1
X_09456_ _02193_ _02194_ net438 net537 VGND VGND VPWR VPWR _02196_ sky130_fd_sc_hd__and4bb_1
XFILLER_101_55 VGND VGND VPWR VPWR sky130_fd_sc_hd__fill_1
X_08407_ _01133_ _01136_ VGND VGND VPWR VPWR _01137_ sky130_fd_sc_hd__xnor2_1
X_09387_ _02118_ _02119_ VGND VGND VPWR VPWR _02121_ sky130_fd_sc_hd__or2_1
XTAP_TAPCELL_ROW_65_1199 VGND VPWR sky130_fd_sc_hd__tapvpwrvgnd_1
X_08338_ _00894_ _00997_ _00994_ VGND VGND VPWR VPWR _01072_ sky130_fd_sc_hd__a21o_1
X_08269_ _00458_ _01003_ VGND VGND VPWR VPWR _01004_ sky130_fd_sc_hd__xnor2_1
XTAP_TAPCELL_ROW_22_599 VGND VPWR sky130_fd_sc_hd__tapvpwrvgnd_1
X_10300_ _03087_ _03109_ VGND VGND VPWR VPWR _03111_ sky130_fd_sc_hd__and2b_1
X_11280_ _04172_ _04180_ VGND VGND VPWR VPWR _04181_ sky130_fd_sc_hd__nand2_1
XFILLER_118_481 VGND VGND VPWR VPWR sky130_fd_sc_hd__fill_1
XFILLER_106_643 VGND VGND VPWR VPWR sky130_fd_sc_hd__fill_1
X_10231_ _03026_ _03028_ _03027_ VGND VGND VPWR VPWR _03036_ sky130_fd_sc_hd__o21ai_1
XFILLER_4_737 VPWR VGND VPWR VGND sky130_ef_sc_hd__decap_12
XFILLER_3_225 VPWR VGND VPWR VGND sky130_ef_sc_hd__decap_12
XFILLER_133_440 VGND VGND VPWR VPWR sky130_fd_sc_hd__decap_8
XFILLER_106_654 VGND VGND VPWR VPWR sky130_fd_sc_hd__decap_8
XFILLER_105_131 VPWR VGND VPWR VGND sky130_ef_sc_hd__decap_12
XFILLER_133_473 VPWR VGND VPWR VGND sky130_ef_sc_hd__decap_12
XFILLER_126_41 VPWR VGND VPWR VGND sky130_ef_sc_hd__decap_12
XFILLER_106_698 VGND VGND VPWR VPWR sky130_fd_sc_hd__fill_2
X_10162_ _02952_ _02959_ VGND VGND VPWR VPWR _02960_ sky130_fd_sc_hd__nor2_1
XFILLER_10_85 VPWR VGND VPWR VGND sky130_ef_sc_hd__decap_12
XFILLER_126_85 VPWR VGND VPWR VGND sky130_ef_sc_hd__decap_12
XFILLER_121_646 VPWR VGND VPWR VGND sky130_ef_sc_hd__decap_12
X_10093_ net266 net277 VGND VGND VPWR VPWR _02884_ sky130_fd_sc_hd__nand2_1
XFILLER_120_189 VGND VGND VPWR VPWR sky130_fd_sc_hd__decap_6
XFILLER_86_67 VGND VGND VPWR VPWR sky130_fd_sc_hd__fill_2
XFILLER_101_381 VGND VGND VPWR VPWR sky130_fd_sc_hd__fill_1
XFILLER_75_755 VPWR VGND VPWR VGND sky130_ef_sc_hd__decap_12
XFILLER_90_747 VGND VGND VPWR VPWR sky130_fd_sc_hd__fill_1
X_12803_ _05839_ _05838_ VGND VGND VPWR VPWR _05840_ sky130_fd_sc_hd__and2b_1
XFILLER_43_652 VPWR VGND VPWR VGND sky130_ef_sc_hd__decap_12
X_10995_ net539 net277 net275 VGND VGND VPWR VPWR _03869_ sky130_fd_sc_hd__and3_1
X_12734_ _05758_ _05763_ VGND VGND VPWR VPWR _05765_ sky130_fd_sc_hd__xor2_1
XFILLER_27_181 VGND VGND VPWR VPWR sky130_fd_sc_hd__decap_4
XFILLER_70_460 VPWR VGND VPWR VGND sky130_ef_sc_hd__decap_12
XFILLER_70_493 VGND VGND VPWR VPWR sky130_fd_sc_hd__fill_1
X_12665_ _05340_ _05345_ VGND VGND VPWR VPWR _05689_ sky130_fd_sc_hd__or2_2
X_11616_ _04446_ _04546_ VGND VGND VPWR VPWR _04547_ sky130_fd_sc_hd__xnor2_1
X_12596_ _05610_ _05611_ _05608_ VGND VGND VPWR VPWR _05614_ sky130_fd_sc_hd__o21ai_1
XTAP_TAPCELL_ROW_41_864 VGND VPWR sky130_fd_sc_hd__tapvpwrvgnd_1
XTAP_TAPCELL_ROW_41_875 VGND VPWR sky130_fd_sc_hd__tapvpwrvgnd_1
XFILLER_128_234 VPWR VGND VPWR VGND sky130_ef_sc_hd__decap_12
XFILLER_51_81 VGND VGND VPWR VPWR sky130_fd_sc_hd__decap_3
XFILLER_7_531 VGND VGND VPWR VPWR sky130_fd_sc_hd__decap_8
X_11547_ net89 net272 net540 VGND VGND VPWR VPWR _04473_ sky130_fd_sc_hd__mux2_1
XFILLER_116_429 VGND VGND VPWR VPWR sky130_fd_sc_hd__fill_1
XTAP_TAPCELL_ROW_96_1638 VGND VPWR sky130_fd_sc_hd__tapvpwrvgnd_1
Xmax_cap228 _06194_ VGND VGND VPWR VPWR net228 sky130_fd_sc_hd__buf_6
Xmax_cap239 _03007_ VGND VGND VPWR VPWR net239 sky130_fd_sc_hd__buf_1
XFILLER_7_597 VPWR VGND VPWR VGND sky130_ef_sc_hd__decap_12
X_11478_ _04361_ _04397_ VGND VGND VPWR VPWR _04398_ sky130_fd_sc_hd__xnor2_1
X_10429_ _03127_ _03250_ VGND VGND VPWR VPWR _03251_ sky130_fd_sc_hd__nand2_1
X_13217_ _06186_ _06188_ _06290_ VGND VGND VPWR VPWR _06293_ sky130_fd_sc_hd__nor3_1
X_13148_ _06215_ _06217_ VGND VGND VPWR VPWR _06218_ sky130_fd_sc_hd__nand2_1
XFILLER_112_657 VGND VGND VPWR VPWR sky130_fd_sc_hd__decap_6
XFILLER_97_346 VPWR VGND VPWR VGND sky130_ef_sc_hd__decap_12
XFILLER_97_335 VGND VGND VPWR VPWR sky130_fd_sc_hd__fill_1
XFILLER_111_167 VGND VGND VPWR VPWR sky130_fd_sc_hd__fill_1
X_13079_ net412 _02295_ _05195_ VGND VGND VPWR VPWR _06142_ sky130_fd_sc_hd__o21ai_1
XPHY_EDGE_ROW_29_Left_166 VGND VGND VPWR VPWR sky130_fd_sc_hd__decap_3
XFILLER_65_221 VGND VGND VPWR VPWR sky130_fd_sc_hd__decap_3
X_07640_ _00378_ _00379_ VGND VGND VPWR VPWR _00380_ sky130_fd_sc_hd__and2b_1
XFILLER_66_766 VGND VGND VPWR VPWR sky130_fd_sc_hd__fill_1
XFILLER_65_265 VPWR VGND VPWR VGND sky130_ef_sc_hd__decap_12
XTAP_TAPCELL_ROW_49_986 VGND VPWR sky130_fd_sc_hd__tapvpwrvgnd_1
XTAP_TAPCELL_ROW_49_975 VGND VPWR sky130_fd_sc_hd__tapvpwrvgnd_1
X_07571_ _00308_ net249 VGND VGND VPWR VPWR _00311_ sky130_fd_sc_hd__and2b_1
XFILLER_53_438 VGND VGND VPWR VPWR sky130_fd_sc_hd__decap_8
XFILLER_80_246 VGND VGND VPWR VPWR sky130_fd_sc_hd__decap_6
X_09310_ _02034_ _02035_ _02036_ VGND VGND VPWR VPWR _02037_ sky130_fd_sc_hd__nand3_1
XFILLER_53_449 VGND VGND VPWR VPWR sky130_fd_sc_hd__fill_2
XTAP_TAPCELL_ROW_105_1767 VGND VPWR sky130_fd_sc_hd__tapvpwrvgnd_1
XFILLER_21_302 VPWR VGND VPWR VGND sky130_ef_sc_hd__decap_12
X_09241_ _01923_ _01963_ VGND VGND VPWR VPWR _01965_ sky130_fd_sc_hd__xnor2_1
XFILLER_33_184 VGND VGND VPWR VPWR sky130_fd_sc_hd__fill_1
XPHY_EDGE_ROW_38_Left_175 VGND VGND VPWR VPWR sky130_fd_sc_hd__decap_3
X_09172_ _01731_ _01729_ _01895_ _01896_ VGND VGND VPWR VPWR _01897_ sky130_fd_sc_hd__a211o_4
XFILLER_21_357 VGND VGND VPWR VPWR sky130_fd_sc_hd__decap_8
X_08123_ _00858_ _00857_ VGND VGND VPWR VPWR _00859_ sky130_fd_sc_hd__and2b_1
XFILLER_135_727 VGND VGND VPWR VPWR sky130_fd_sc_hd__fill_1
X_08054_ _00789_ _00790_ VGND VGND VPWR VPWR _00791_ sky130_fd_sc_hd__nand2_1
XFILLER_119_256 VGND VGND VPWR VPWR sky130_fd_sc_hd__fill_2
XFILLER_107_429 VPWR VGND VPWR VGND sky130_ef_sc_hd__decap_12
XFILLER_107_407 VGND VGND VPWR VPWR sky130_fd_sc_hd__decap_3
X_07005_ _05494_ _05560_ VGND VGND VPWR VPWR _05582_ sky130_fd_sc_hd__xnor2_2
XFILLER_115_495 VGND VGND VPWR VPWR sky130_fd_sc_hd__decap_8
XFILLER_102_101 VGND VGND VPWR VPWR sky130_fd_sc_hd__decap_4
XPHY_EDGE_ROW_47_Left_184 VGND VGND VPWR VPWR sky130_fd_sc_hd__decap_3
XFILLER_1_729 VPWR VGND VPWR VGND sky130_ef_sc_hd__decap_12
XFILLER_130_421 VPWR VGND VPWR VGND sky130_ef_sc_hd__decap_12
XFILLER_88_346 VGND VGND VPWR VPWR sky130_fd_sc_hd__fill_1
XFILLER_76_508 VGND VGND VPWR VPWR sky130_fd_sc_hd__fill_2
Xinput118 w22[4] VGND VGND VPWR VPWR net118 sky130_fd_sc_hd__clkbuf_2
Xinput107 w21[1] VGND VGND VPWR VPWR net107 sky130_fd_sc_hd__clkbuf_2
Xinput129 w23[7] VGND VGND VPWR VPWR net129 sky130_fd_sc_hd__clkbuf_2
XFILLER_88_379 VGND VGND VPWR VPWR sky130_fd_sc_hd__decap_4
X_08956_ net787 net64 VGND VGND VPWR VPWR _01682_ sky130_fd_sc_hd__nand2_1
X_08887_ _01604_ _01612_ VGND VGND VPWR VPWR _01613_ sky130_fd_sc_hd__xnor2_1
X_07907_ net605 net603 net410 net402 VGND VGND VPWR VPWR _00645_ sky130_fd_sc_hd__and4_1
XFILLER_56_221 VGND VGND VPWR VPWR sky130_fd_sc_hd__fill_1
XFILLER_29_446 VGND VGND VPWR VPWR sky130_fd_sc_hd__fill_2
X_07838_ _00472_ _00474_ _00575_ VGND VGND VPWR VPWR _00576_ sky130_fd_sc_hd__a21oi_1
XFILLER_84_574 VPWR VGND VPWR VGND sky130_ef_sc_hd__decap_12
XFILLER_56_265 VGND VGND VPWR VPWR sky130_fd_sc_hd__fill_1
XFILLER_72_725 VPWR VGND VPWR VGND sky130_ef_sc_hd__decap_12
XFILLER_71_202 VGND VGND VPWR VPWR sky130_fd_sc_hd__decap_6
XTAP_TAPCELL_ROW_67_1239 VGND VPWR sky130_fd_sc_hd__tapvpwrvgnd_1
XTAP_TAPCELL_ROW_67_1228 VGND VPWR sky130_fd_sc_hd__tapvpwrvgnd_1
XFILLER_44_427 VGND VGND VPWR VPWR sky130_fd_sc_hd__fill_1
XFILLER_16_129 VGND VGND VPWR VPWR sky130_fd_sc_hd__decap_8
X_09508_ net596 net253 _02197_ net621 VGND VGND VPWR VPWR _02253_ sky130_fd_sc_hd__o2bb2a_1
XFILLER_112_65 VGND VGND VPWR VPWR sky130_fd_sc_hd__fill_2
X_07769_ _00231_ _00383_ _00387_ VGND VGND VPWR VPWR _00508_ sky130_fd_sc_hd__o21bai_2
XFILLER_72_769 VPWR VGND VPWR VGND sky130_ef_sc_hd__decap_12
XFILLER_72_25 VGND VGND VPWR VPWR sky130_fd_sc_hd__decap_3
XFILLER_25_641 VPWR VGND VPWR VGND sky130_ef_sc_hd__decap_12
XTAP_TAPCELL_ROW_27_669 VGND VPWR sky130_fd_sc_hd__tapvpwrvgnd_1
XTAP_TAPCELL_ROW_80_1417 VGND VPWR sky130_fd_sc_hd__tapvpwrvgnd_1
XPHY_EDGE_ROW_56_Left_193 VGND VGND VPWR VPWR sky130_fd_sc_hd__decap_3
X_10780_ net286 net352 net350 VGND VGND VPWR VPWR _03635_ sky130_fd_sc_hd__nand3_2
X_09439_ net357 net325 VGND VGND VPWR VPWR _02178_ sky130_fd_sc_hd__nand2_1
XFILLER_12_313 VGND VGND VPWR VPWR sky130_fd_sc_hd__fill_1
XFILLER_24_173 VGND VGND VPWR VPWR sky130_fd_sc_hd__decap_3
XFILLER_40_622 VGND VGND VPWR VPWR sky130_fd_sc_hd__decap_8
X_12450_ _05433_ _05452_ _05454_ VGND VGND VPWR VPWR _05455_ sky130_fd_sc_hd__and3_1
XFILLER_40_677 VGND VGND VPWR VPWR sky130_fd_sc_hd__fill_1
X_11401_ _04170_ _04183_ _04311_ VGND VGND VPWR VPWR _04313_ sky130_fd_sc_hd__nor3_1
XFILLER_40_699 VGND VGND VPWR VPWR sky130_fd_sc_hd__fill_1
XFILLER_4_501 VPWR VGND VPWR VGND sky130_ef_sc_hd__decap_12
X_12381_ _05377_ _05378_ VGND VGND VPWR VPWR _05379_ sky130_fd_sc_hd__and2_1
XFILLER_126_749 VGND VGND VPWR VPWR sky130_fd_sc_hd__decap_6
X_11332_ _04045_ _04059_ _04058_ VGND VGND VPWR VPWR _04238_ sky130_fd_sc_hd__o21ba_1
XFILLER_4_545 VPWR VGND VPWR VGND sky130_ef_sc_hd__decap_12
XFILLER_21_84 VGND VGND VPWR VPWR sky130_fd_sc_hd__decap_6
X_11263_ _03878_ _04044_ _04043_ VGND VGND VPWR VPWR _04162_ sky130_fd_sc_hd__a21oi_1
XFILLER_134_793 VPWR VGND VPWR VGND sky130_ef_sc_hd__decap_12
X_10214_ _03015_ _03012_ _03016_ VGND VGND VPWR VPWR _03017_ sky130_fd_sc_hd__or3_4
XFILLER_4_589 VPWR VGND VPWR VGND sky130_ef_sc_hd__decap_12
X_11194_ _03954_ _03965_ _03953_ VGND VGND VPWR VPWR _04087_ sky130_fd_sc_hd__o21ai_1
X_13002_ _05908_ _05913_ _05524_ VGND VGND VPWR VPWR _06058_ sky130_fd_sc_hd__o21ai_1
XTAP_TAPCELL_ROW_91_1568 VGND VPWR sky130_fd_sc_hd__tapvpwrvgnd_1
XFILLER_79_335 VGND VGND VPWR VPWR sky130_fd_sc_hd__fill_1
X_10145_ _02939_ _02938_ VGND VGND VPWR VPWR _02941_ sky130_fd_sc_hd__and2b_1
XFILLER_67_519 VGND VGND VPWR VPWR sky130_fd_sc_hd__fill_2
XFILLER_48_711 VGND VGND VPWR VPWR sky130_fd_sc_hd__decap_8
X_10076_ _02809_ _02816_ _02865_ VGND VGND VPWR VPWR _02866_ sky130_fd_sc_hd__a21oi_1
XTAP_TAPCELL_ROW_7_394 VGND VPWR sky130_fd_sc_hd__tapvpwrvgnd_1
XFILLER_75_574 VPWR VGND VPWR VGND sky130_ef_sc_hd__decap_12
XFILLER_75_541 VGND VGND VPWR VPWR sky130_fd_sc_hd__fill_1
XTAP_TAPCELL_ROW_122_2001 VGND VPWR sky130_fd_sc_hd__tapvpwrvgnd_1
XFILLER_90_533 VPWR VGND VPWR VGND sky130_ef_sc_hd__decap_12
XFILLER_90_511 VGND VGND VPWR VPWR sky130_fd_sc_hd__decap_4
XTAP_TAPCELL_ROW_46_934 VGND VPWR sky130_fd_sc_hd__tapvpwrvgnd_1
XFILLER_62_235 VPWR VGND VPWR VGND sky130_ef_sc_hd__decap_12
XTAP_TAPCELL_ROW_46_945 VGND VPWR sky130_fd_sc_hd__tapvpwrvgnd_1
XFILLER_35_449 VGND VGND VPWR VPWR sky130_fd_sc_hd__fill_2
X_10978_ _03848_ _03849_ _03677_ _03679_ VGND VGND VPWR VPWR _03852_ sky130_fd_sc_hd__a211o_1
X_12717_ net290 net366 net364 net312 VGND VGND VPWR VPWR _05747_ sky130_fd_sc_hd__a22oi_1
XFILLER_31_633 VPWR VGND VPWR VGND sky130_ef_sc_hd__decap_12
XFILLER_62_80 VGND VGND VPWR VPWR sky130_fd_sc_hd__decap_4
X_12648_ _05667_ _05670_ VGND VGND VPWR VPWR _05671_ sky130_fd_sc_hd__or2_1
XFILLER_129_554 VGND VGND VPWR VPWR sky130_fd_sc_hd__decap_6
XFILLER_117_727 VGND VGND VPWR VPWR sky130_fd_sc_hd__fill_1
XFILLER_117_716 VGND VGND VPWR VPWR sky130_fd_sc_hd__fill_1
XTAP_TAPCELL_ROW_100_1697 VGND VPWR sky130_fd_sc_hd__tapvpwrvgnd_1
X_12579_ _05594_ _05595_ VGND VGND VPWR VPWR _05596_ sky130_fd_sc_hd__nand2_1
XTAP_TAPCELL_ROW_133_2163 VGND VPWR sky130_fd_sc_hd__tapvpwrvgnd_1
XTAP_TAPCELL_ROW_133_2152 VGND VPWR sky130_fd_sc_hd__tapvpwrvgnd_1
XFILLER_116_226 VPWR VGND VPWR VGND sky130_ef_sc_hd__decap_12
XFILLER_7_361 VPWR VGND VPWR VGND sky130_ef_sc_hd__decap_12
XFILLER_116_259 VGND VGND VPWR VPWR sky130_fd_sc_hd__fill_1
XFILLER_124_270 VGND VGND VPWR VPWR sky130_fd_sc_hd__fill_1
XFILLER_112_432 VGND VGND VPWR VPWR sky130_fd_sc_hd__decap_6
X_08810_ _01534_ _01535_ _01405_ VGND VGND VPWR VPWR _01537_ sky130_fd_sc_hd__a21oi_1
XTAP_TAPCELL_ROW_51_1007 VGND VPWR sky130_fd_sc_hd__tapvpwrvgnd_1
XFILLER_112_465 VGND VGND VPWR VPWR sky130_fd_sc_hd__decap_8
X_09790_ _02553_ _02557_ VGND VGND VPWR VPWR _02559_ sky130_fd_sc_hd__xnor2_1
XFILLER_85_316 VPWR VGND VPWR VGND sky130_ef_sc_hd__decap_12
X_08741_ _01466_ _01467_ VGND VGND VPWR VPWR _01468_ sky130_fd_sc_hd__or2_1
X_08672_ _01396_ _01397_ _01398_ VGND VGND VPWR VPWR _01400_ sky130_fd_sc_hd__a21oi_1
XFILLER_66_552 VPWR VGND VPWR VGND sky130_ef_sc_hd__decap_12
X_07623_ net605 net418 net603 net435 VGND VGND VPWR VPWR _00363_ sky130_fd_sc_hd__a22oi_1
XFILLER_81_500 VGND VGND VPWR VPWR sky130_fd_sc_hd__fill_1
XFILLER_26_29 VPWR VGND VPWR VGND sky130_ef_sc_hd__decap_12
XFILLER_26_427 VPWR VGND VPWR VGND sky130_ef_sc_hd__decap_12
XFILLER_93_393 VPWR VGND VPWR VGND sky130_ef_sc_hd__decap_12
XPHY_EDGE_ROW_5_Right_5 VGND VGND VPWR VPWR sky130_fd_sc_hd__decap_3
X_07554_ _00292_ _00293_ VGND VGND VPWR VPWR _00294_ sky130_fd_sc_hd__and2_1
XFILLER_34_460 VPWR VGND VPWR VGND sky130_ef_sc_hd__decap_12
X_07485_ _00221_ _00225_ VGND VGND VPWR VPWR _00226_ sky130_fd_sc_hd__and2_1
XFILLER_62_780 VGND VGND VPWR VPWR sky130_fd_sc_hd__fill_1
XTAP_TAPCELL_ROW_24_628 VGND VPWR sky130_fd_sc_hd__tapvpwrvgnd_1
X_09224_ net544 _01782_ _01783_ _01947_ VGND VGND VPWR VPWR _01948_ sky130_fd_sc_hd__a31o_1
XTAP_TAPCELL_ROW_62_1169 VGND VPWR sky130_fd_sc_hd__tapvpwrvgnd_1
XTAP_TAPCELL_ROW_62_1158 VGND VPWR sky130_fd_sc_hd__tapvpwrvgnd_1
XFILLER_22_677 VGND VGND VPWR VPWR sky130_fd_sc_hd__fill_1
X_09155_ _01872_ _01873_ _01878_ VGND VGND VPWR VPWR _01880_ sky130_fd_sc_hd__nand3_1
XTAP_TAPCELL_ROW_118_1947 VGND VPWR sky130_fd_sc_hd__tapvpwrvgnd_1
XFILLER_108_738 VGND VGND VPWR VPWR sky130_fd_sc_hd__decap_3
X_09086_ net487 net631 net629 net493 VGND VGND VPWR VPWR _01811_ sky130_fd_sc_hd__a22o_1
X_08106_ _00831_ _00841_ VGND VGND VPWR VPWR _00842_ sky130_fd_sc_hd__xor2_1
XFILLER_107_248 VGND VGND VPWR VPWR sky130_fd_sc_hd__decap_4
X_08037_ _00747_ _00773_ VGND VGND VPWR VPWR _00774_ sky130_fd_sc_hd__xnor2_1
XFILLER_131_741 VPWR VGND VPWR VGND sky130_ef_sc_hd__decap_12
XFILLER_115_281 VGND VGND VPWR VPWR sky130_fd_sc_hd__decap_4
XFILLER_1_559 VGND VGND VPWR VPWR sky130_fd_sc_hd__fill_1
XFILLER_131_785 VPWR VGND VPWR VGND sky130_ef_sc_hd__decap_12
X_09988_ _02715_ _02733_ VGND VGND VPWR VPWR _02774_ sky130_fd_sc_hd__xnor2_1
X_08939_ net250 _01391_ net634 net502 _01379_ VGND VGND VPWR VPWR _01665_ sky130_fd_sc_hd__o2111a_1
X_11950_ _04756_ _04908_ VGND VGND VPWR VPWR _04909_ sky130_fd_sc_hd__xor2_1
XTAP_TAPCELL_ROW_4_353 VGND VPWR sky130_fd_sc_hd__tapvpwrvgnd_1
X_10901_ _03590_ _03766_ VGND VGND VPWR VPWR _03767_ sky130_fd_sc_hd__xnor2_1
XFILLER_83_57 VPWR VGND VPWR VGND sky130_ef_sc_hd__decap_12
XFILLER_72_533 VGND VGND VPWR VPWR sky130_fd_sc_hd__decap_8
X_11881_ _04825_ _04832_ _04833_ VGND VGND VPWR VPWR _04834_ sky130_fd_sc_hd__nand3_2
XPHY_EDGE_ROW_64_Left_201 VGND VGND VPWR VPWR sky130_fd_sc_hd__decap_3
XFILLER_45_758 VGND VGND VPWR VPWR sky130_fd_sc_hd__decap_3
XFILLER_17_449 VGND VGND VPWR VPWR sky130_fd_sc_hd__decap_6
XFILLER_60_739 VGND VGND VPWR VPWR sky130_fd_sc_hd__decap_4
X_10832_ _03512_ _03563_ _03562_ VGND VGND VPWR VPWR _03691_ sky130_fd_sc_hd__a21oi_2
X_10763_ _03613_ _03614_ _03615_ VGND VGND VPWR VPWR _03616_ sky130_fd_sc_hd__nand3_1
X_12502_ _05506_ _05509_ VGND VGND VPWR VPWR _05511_ sky130_fd_sc_hd__xnor2_1
XFILLER_40_452 VGND VGND VPWR VPWR sky130_fd_sc_hd__fill_1
X_10694_ net495 net650 _03388_ _03387_ VGND VGND VPWR VPWR _03540_ sky130_fd_sc_hd__a31o_1
XFILLER_8_125 VPWR VGND VPWR VGND sky130_ef_sc_hd__decap_12
X_12433_ net312 net44 VGND VGND VPWR VPWR _05436_ sky130_fd_sc_hd__and2_1
XFILLER_32_83 VGND VGND VPWR VPWR sky130_fd_sc_hd__fill_1
XPHY_EDGE_ROW_73_Left_210 VGND VGND VPWR VPWR sky130_fd_sc_hd__decap_3
X_12364_ _05336_ _05358_ VGND VGND VPWR VPWR _05360_ sky130_fd_sc_hd__xnor2_1
XFILLER_126_579 VGND VGND VPWR VPWR sky130_fd_sc_hd__decap_3
XFILLER_126_568 VGND VGND VPWR VPWR sky130_fd_sc_hd__fill_1
XFILLER_59_9 VGND VGND VPWR VPWR sky130_fd_sc_hd__decap_6
X_11315_ net416 _03586_ _04218_ VGND VGND VPWR VPWR _04219_ sky130_fd_sc_hd__o21a_1
XFILLER_107_771 VGND VGND VPWR VPWR sky130_fd_sc_hd__fill_1
X_12295_ _05223_ _05284_ VGND VGND VPWR VPWR _05285_ sky130_fd_sc_hd__or2_4
XFILLER_122_752 VGND VGND VPWR VPWR sky130_fd_sc_hd__decap_4
XFILLER_79_132 VPWR VGND VPWR VGND sky130_ef_sc_hd__decap_12
X_11246_ _03942_ _03996_ _03995_ VGND VGND VPWR VPWR _04144_ sky130_fd_sc_hd__a21oi_2
XFILLER_95_614 VGND VGND VPWR VPWR sky130_fd_sc_hd__fill_2
X_11177_ net344 _04066_ VGND VGND VPWR VPWR _04069_ sky130_fd_sc_hd__and2_1
XFILLER_95_658 VPWR VGND VPWR VGND sky130_ef_sc_hd__decap_12
XFILLER_67_349 VPWR VGND VPWR VGND sky130_ef_sc_hd__decap_12
X_10128_ net526 net522 net653 net650 VGND VGND VPWR VPWR _02923_ sky130_fd_sc_hd__and4_1
X_10059_ _02846_ _02847_ VGND VGND VPWR VPWR _02848_ sky130_fd_sc_hd__or2_1
XFILLER_36_714 VGND VGND VPWR VPWR sky130_fd_sc_hd__decap_8
XFILLER_75_393 VPWR VGND VPWR VGND sky130_ef_sc_hd__decap_12
XFILLER_36_769 VGND VGND VPWR VPWR sky130_fd_sc_hd__decap_3
XTAP_TAPCELL_ROW_102_1726 VGND VPWR sky130_fd_sc_hd__tapvpwrvgnd_1
XFILLER_90_396 VGND VGND VPWR VPWR sky130_fd_sc_hd__decap_4
X_07270_ net252 net477 VGND VGND VPWR VPWR _06561_ sky130_fd_sc_hd__nand2_4
XFILLER_129_351 VGND VGND VPWR VPWR sky130_fd_sc_hd__fill_1
XFILLER_129_384 VGND VGND VPWR VPWR sky130_fd_sc_hd__fill_1
XFILLER_117_557 VGND VGND VPWR VPWR sky130_fd_sc_hd__decap_3
X_09911_ _02421_ _02547_ _01949_ VGND VGND VPWR VPWR _02691_ sky130_fd_sc_hd__o21ai_1
Xfanout605 net134 VGND VGND VPWR VPWR net605 sky130_fd_sc_hd__clkbuf_2
X_09842_ _02480_ _02482_ _02615_ VGND VGND VPWR VPWR _02616_ sky130_fd_sc_hd__o21bai_1
XFILLER_113_785 VPWR VGND VPWR VGND sky130_ef_sc_hd__decap_12
XFILLER_113_752 VPWR VGND VPWR VGND sky130_ef_sc_hd__decap_12
XTAP_TAPCELL_ROW_113_1877 VGND VPWR sky130_fd_sc_hd__tapvpwrvgnd_1
Xfanout627 net127 VGND VGND VPWR VPWR net627 sky130_fd_sc_hd__dlymetal6s2s_1
XFILLER_100_402 VGND VGND VPWR VPWR sky130_fd_sc_hd__decap_8
Xfanout638 net646 VGND VGND VPWR VPWR net638 sky130_fd_sc_hd__clkbuf_4
Xfanout616 net623 VGND VGND VPWR VPWR net616 sky130_fd_sc_hd__clkbuf_2
Xfanout649 net118 VGND VGND VPWR VPWR net649 sky130_fd_sc_hd__buf_2
X_09773_ _02538_ _02539_ VGND VGND VPWR VPWR _02540_ sky130_fd_sc_hd__and2b_1
XFILLER_85_113 VGND VGND VPWR VPWR sky130_fd_sc_hd__decap_6
XFILLER_58_349 VGND VGND VPWR VPWR sky130_fd_sc_hd__fill_1
X_06985_ _03609_ _03631_ _05341_ VGND VGND VPWR VPWR _05363_ sky130_fd_sc_hd__and3_1
XFILLER_100_446 VGND VGND VPWR VPWR sky130_fd_sc_hd__fill_1
X_08724_ _01338_ _01451_ VGND VGND VPWR VPWR _00059_ sky130_fd_sc_hd__xnor2_1
XFILLER_37_28 VGND VGND VPWR VPWR sky130_fd_sc_hd__fill_1
XFILLER_54_511 VPWR VGND VPWR VGND sky130_ef_sc_hd__decap_12
XTAP_TAPCELL_ROW_1_312 VGND VPWR sky130_fd_sc_hd__tapvpwrvgnd_1
XFILLER_39_596 VPWR VGND VPWR VGND sky130_ef_sc_hd__decap_12
XFILLER_93_190 VPWR VGND VPWR VGND sky130_ef_sc_hd__decap_12
X_08655_ _01170_ _01382_ VGND VGND VPWR VPWR _01383_ sky130_fd_sc_hd__and2_1
XFILLER_54_544 VGND VGND VPWR VPWR sky130_fd_sc_hd__fill_1
X_07606_ net453 net137 VGND VGND VPWR VPWR _00346_ sky130_fd_sc_hd__and2b_1
X_08586_ _01210_ _01313_ _01314_ VGND VGND VPWR VPWR _01315_ sky130_fd_sc_hd__and3_4
XFILLER_54_577 VGND VGND VPWR VPWR sky130_fd_sc_hd__decap_4
XFILLER_26_257 VGND VGND VPWR VPWR sky130_fd_sc_hd__decap_8
XFILLER_42_706 VGND VGND VPWR VPWR sky130_fd_sc_hd__fill_2
X_07537_ _00275_ _00276_ _06656_ VGND VGND VPWR VPWR _00278_ sky130_fd_sc_hd__a21oi_1
X_07468_ net607 net419 _00207_ _00208_ VGND VGND VPWR VPWR _00209_ sky130_fd_sc_hd__a22o_1
XFILLER_10_625 VPWR VGND VPWR VGND sky130_ef_sc_hd__decap_12
XFILLER_22_474 VGND VGND VPWR VPWR sky130_fd_sc_hd__fill_2
X_09207_ _01929_ _01930_ VGND VGND VPWR VPWR _01931_ sky130_fd_sc_hd__nand2_1
X_07399_ _06531_ _06536_ _06534_ _06405_ VGND VGND VPWR VPWR _00140_ sky130_fd_sc_hd__a2bb2o_1
Xrebuffer200 net930 VGND VGND VPWR VPWR net900 sky130_fd_sc_hd__clkbuf_1
X_09138_ _01858_ _01862_ VGND VGND VPWR VPWR _01863_ sky130_fd_sc_hd__and2_1
Xrebuffer244 net426 VGND VGND VPWR VPWR net944 sky130_fd_sc_hd__buf_2
XFILLER_123_505 VGND VGND VPWR VPWR sky130_fd_sc_hd__decap_8
XFILLER_118_53 VPWR VGND VPWR VGND sky130_ef_sc_hd__decap_12
X_09069_ _01793_ _01778_ VGND VGND VPWR VPWR _01794_ sky130_fd_sc_hd__xor2_1
XTAP_TAPCELL_ROW_75_1349 VGND VPWR sky130_fd_sc_hd__tapvpwrvgnd_1
XTAP_TAPCELL_ROW_75_1338 VGND VPWR sky130_fd_sc_hd__tapvpwrvgnd_1
XTAP_TAPCELL_ROW_9_423 VGND VPWR sky130_fd_sc_hd__tapvpwrvgnd_1
X_11100_ _03983_ _03984_ _03979_ VGND VGND VPWR VPWR _03985_ sky130_fd_sc_hd__a21oi_4
X_12080_ _04928_ _05050_ VGND VGND VPWR VPWR _05051_ sky130_fd_sc_hd__nand2_1
XFILLER_77_614 VGND VGND VPWR VPWR sky130_fd_sc_hd__fill_2
X_11031_ _03780_ _03799_ _03798_ VGND VGND VPWR VPWR _03909_ sky130_fd_sc_hd__a21oi_1
XFILLER_134_41 VPWR VGND VPWR VGND sky130_ef_sc_hd__decap_12
XFILLER_103_262 VGND VGND VPWR VPWR sky130_fd_sc_hd__fill_2
XFILLER_89_485 VPWR VGND VPWR VGND sky130_ef_sc_hd__decap_12
XFILLER_134_85 VPWR VGND VPWR VGND sky130_ef_sc_hd__decap_12
XFILLER_92_606 VGND VGND VPWR VPWR sky130_fd_sc_hd__decap_4
XFILLER_49_349 VGND VGND VPWR VPWR sky130_fd_sc_hd__decap_4
XFILLER_94_78 VGND VGND VPWR VPWR sky130_fd_sc_hd__decap_3
XFILLER_18_725 VGND VGND VPWR VPWR sky130_fd_sc_hd__decap_4
X_12982_ _05903_ _05904_ _05939_ VGND VGND VPWR VPWR _06036_ sky130_fd_sc_hd__o21ba_1
XFILLER_85_691 VGND VGND VPWR VPWR sky130_fd_sc_hd__decap_6
XFILLER_57_393 VPWR VGND VPWR VGND sky130_ef_sc_hd__decap_12
X_11933_ net524 net508 net675 net673 VGND VGND VPWR VPWR _04890_ sky130_fd_sc_hd__nand4_1
XFILLER_17_235 VGND VGND VPWR VPWR sky130_fd_sc_hd__decap_4
XFILLER_17_246 VGND VGND VPWR VPWR sky130_fd_sc_hd__fill_1
XFILLER_18_769 VGND VGND VPWR VPWR sky130_fd_sc_hd__fill_1
XFILLER_72_363 VGND VGND VPWR VPWR sky130_fd_sc_hd__fill_1
X_11864_ _04736_ net717 _04813_ VGND VGND VPWR VPWR _04815_ sky130_fd_sc_hd__or3_4
XFILLER_17_257 VGND VGND VPWR VPWR sky130_fd_sc_hd__fill_2
XFILLER_33_706 VGND VGND VPWR VPWR sky130_fd_sc_hd__decap_8
X_10815_ _03564_ _03669_ _03671_ VGND VGND VPWR VPWR _03673_ sky130_fd_sc_hd__nand3_1
XFILLER_32_216 VGND VGND VPWR VPWR sky130_fd_sc_hd__fill_1
X_11795_ net454 net446 net598 net588 VGND VGND VPWR VPWR _04739_ sky130_fd_sc_hd__and4_1
XFILLER_9_434 VGND VGND VPWR VPWR sky130_fd_sc_hd__decap_6
X_10746_ _03594_ _03595_ VGND VGND VPWR VPWR _03597_ sky130_fd_sc_hd__and2b_1
X_10677_ net615 net590 net277 net275 VGND VGND VPWR VPWR _03522_ sky130_fd_sc_hd__and4_1
X_12416_ _05409_ _05415_ _05416_ VGND VGND VPWR VPWR _05417_ sky130_fd_sc_hd__nand3_1
XFILLER_126_354 VGND VGND VPWR VPWR sky130_fd_sc_hd__fill_2
X_13396_ clknet_3_1__leaf_clk _00013_ _00106_ VGND VGND VPWR VPWR net195 sky130_fd_sc_hd__dfrtp_1
Xoutput208 net208 VGND VGND VPWR VPWR out2[8] sky130_fd_sc_hd__buf_2
XTAP_TAPCELL_ROW_130_2111 VGND VPWR sky130_fd_sc_hd__tapvpwrvgnd_1
Xoutput219 net219 VGND VGND VPWR VPWR out3[3] sky130_fd_sc_hd__buf_2
XFILLER_5_673 VPWR VGND VPWR VGND sky130_ef_sc_hd__decap_12
X_12347_ net542 net301 net299 VGND VGND VPWR VPWR _05342_ sky130_fd_sc_hd__nand3_1
X_12278_ _05089_ _05092_ _05091_ VGND VGND VPWR VPWR _05267_ sky130_fd_sc_hd__o21bai_1
XFILLER_4_65 VPWR VGND VPWR VGND sky130_ef_sc_hd__decap_12
X_11229_ net442 _03586_ _03589_ _03930_ VGND VGND VPWR VPWR _04126_ sky130_fd_sc_hd__a2bb2o_1
XFILLER_95_422 VGND VGND VPWR VPWR sky130_fd_sc_hd__fill_1
XFILLER_67_102 VGND VGND VPWR VPWR sky130_fd_sc_hd__decap_3
XFILLER_68_669 VPWR VGND VPWR VGND sky130_ef_sc_hd__decap_12
XTAP_TAPCELL_ROW_128_2084 VGND VPWR sky130_fd_sc_hd__tapvpwrvgnd_1
X_06770_ _02910_ _03009_ VGND VGND VPWR VPWR _03020_ sky130_fd_sc_hd__xor2_1
XFILLER_83_617 VPWR VGND VPWR VGND sky130_ef_sc_hd__decap_12
XFILLER_63_330 VGND VGND VPWR VPWR sky130_fd_sc_hd__fill_1
XFILLER_36_533 VPWR VGND VPWR VGND sky130_ef_sc_hd__decap_12
X_08440_ net509 net634 VGND VGND VPWR VPWR _01169_ sky130_fd_sc_hd__nand2_1
XFILLER_51_525 VGND VGND VPWR VPWR sky130_fd_sc_hd__decap_4
XFILLER_23_216 VGND VGND VPWR VPWR sky130_fd_sc_hd__decap_8
X_08371_ _01087_ _01100_ VGND VGND VPWR VPWR _01102_ sky130_fd_sc_hd__or2_1
XTAP_TAPCELL_ROW_34_767 VGND VPWR sky130_fd_sc_hd__tapvpwrvgnd_1
X_07322_ _06608_ _06611_ _06612_ VGND VGND VPWR VPWR _06613_ sky130_fd_sc_hd__and3_1
XFILLER_31_260 VGND VGND VPWR VPWR sky130_fd_sc_hd__decap_8
X_07253_ _06541_ _06542_ VGND VGND VPWR VPWR _06544_ sky130_fd_sc_hd__nor2_1
XTAP_TAPCELL_ROW_14_491 VGND VPWR sky130_fd_sc_hd__tapvpwrvgnd_1
X_07184_ _06472_ _06473_ _06474_ VGND VGND VPWR VPWR _06476_ sky130_fd_sc_hd__a21o_1
XTAP_TAPCELL_ROW_115_1906 VGND VPWR sky130_fd_sc_hd__tapvpwrvgnd_1
XFILLER_132_302 VGND VGND VPWR VPWR sky130_fd_sc_hd__decap_6
XFILLER_105_505 VPWR VGND VPWR VGND sky130_ef_sc_hd__decap_12
XFILLER_2_109 VPWR VGND VPWR VGND sky130_ef_sc_hd__decap_12
XFILLER_132_357 VGND VGND VPWR VPWR sky130_fd_sc_hd__decap_6
Xfanout402 net403 VGND VGND VPWR VPWR net402 sky130_fd_sc_hd__buf_2
Xfanout413 net31 VGND VGND VPWR VPWR net413 sky130_fd_sc_hd__buf_2
XFILLER_113_593 VPWR VGND VPWR VGND sky130_ef_sc_hd__decap_12
X_09825_ _02591_ _02595_ VGND VGND VPWR VPWR _02597_ sky130_fd_sc_hd__xnor2_1
XFILLER_99_794 VPWR VGND VPWR VGND sky130_ef_sc_hd__decap_12
Xfanout424 net30 VGND VGND VPWR VPWR net424 sky130_fd_sc_hd__buf_4
Xfanout435 net441 VGND VGND VPWR VPWR net435 sky130_fd_sc_hd__buf_2
XFILLER_59_647 VPWR VGND VPWR VGND sky130_ef_sc_hd__decap_12
XFILLER_58_102 VGND VGND VPWR VPWR sky130_fd_sc_hd__fill_2
Xfanout446 net449 VGND VGND VPWR VPWR net446 sky130_fd_sc_hd__buf_2
Xfanout457 net27 VGND VGND VPWR VPWR net457 sky130_fd_sc_hd__clkbuf_2
Xfanout479 net480 VGND VGND VPWR VPWR net479 sky130_fd_sc_hd__clkbuf_4
XFILLER_100_243 VGND VGND VPWR VPWR sky130_fd_sc_hd__decap_8
XTAP_TAPCELL_ROW_70_1279 VGND VPWR sky130_fd_sc_hd__tapvpwrvgnd_1
XTAP_TAPCELL_ROW_70_1268 VGND VPWR sky130_fd_sc_hd__tapvpwrvgnd_1
Xfanout468 net470 VGND VGND VPWR VPWR net468 sky130_fd_sc_hd__buf_1
X_06968_ net322 net321 net619 net595 VGND VGND VPWR VPWR _05177_ sky130_fd_sc_hd__and4_1
XFILLER_101_777 VGND VGND VPWR VPWR sky130_fd_sc_hd__decap_6
X_09756_ _02510_ _02520_ VGND VGND VPWR VPWR _02521_ sky130_fd_sc_hd__xnor2_1
X_09687_ _02445_ _02444_ VGND VGND VPWR VPWR _02447_ sky130_fd_sc_hd__nand2b_1
XFILLER_104_77 VGND VGND VPWR VPWR sky130_fd_sc_hd__decap_6
X_08707_ net241 _01433_ _01288_ _01291_ VGND VGND VPWR VPWR _01435_ sky130_fd_sc_hd__o211a_1
XFILLER_54_330 VPWR VGND VPWR VGND sky130_ef_sc_hd__decap_12
XFILLER_39_382 VGND VGND VPWR VPWR sky130_fd_sc_hd__decap_3
XFILLER_104_99 VGND VGND VPWR VPWR sky130_fd_sc_hd__fill_2
X_08638_ _01223_ _01224_ _01226_ _01218_ VGND VGND VPWR VPWR _01366_ sky130_fd_sc_hd__o22ai_1
XFILLER_82_672 VGND VGND VPWR VPWR sky130_fd_sc_hd__fill_2
X_06899_ _04330_ _04341_ _04407_ VGND VGND VPWR VPWR _04428_ sky130_fd_sc_hd__a21o_1
XFILLER_42_503 VGND VGND VPWR VPWR sky130_fd_sc_hd__fill_1
XFILLER_120_21 VGND VGND VPWR VPWR sky130_fd_sc_hd__decap_6
XFILLER_14_216 VPWR VGND VPWR VGND sky130_ef_sc_hd__decap_12
XFILLER_27_599 VGND VGND VPWR VPWR sky130_fd_sc_hd__fill_1
XFILLER_120_65 VPWR VGND VPWR VGND sky130_ef_sc_hd__decap_12
X_08569_ _01285_ _01293_ _01131_ VGND VGND VPWR VPWR _01298_ sky130_fd_sc_hd__a21oi_1
XFILLER_14_249 VGND VGND VPWR VPWR sky130_fd_sc_hd__decap_3
X_11580_ _04393_ _04395_ _04507_ VGND VGND VPWR VPWR _04509_ sky130_fd_sc_hd__or3b_1
XFILLER_23_761 VGND VGND VPWR VPWR sky130_fd_sc_hd__fill_1
X_10600_ net694 _02240_ _03433_ _03436_ VGND VGND VPWR VPWR _03438_ sky130_fd_sc_hd__or4b_1
XFILLER_128_608 VPWR VGND VPWR VGND sky130_ef_sc_hd__decap_12
XFILLER_80_69 VPWR VGND VPWR VGND sky130_ef_sc_hd__decap_12
X_10531_ _03343_ _03361_ VGND VGND VPWR VPWR _03362_ sky130_fd_sc_hd__xnor2_2
X_13250_ net404 _05386_ _06253_ _06256_ _06254_ VGND VGND VPWR VPWR _06327_ sky130_fd_sc_hd__o221a_1
XFILLER_10_477 VGND VGND VPWR VPWR sky130_fd_sc_hd__fill_2
XFILLER_89_34 VGND VGND VPWR VPWR sky130_fd_sc_hd__decap_3
X_12201_ _05135_ _05181_ VGND VGND VPWR VPWR _05182_ sky130_fd_sc_hd__nand2_1
X_10462_ net375 net349 net347 net425 VGND VGND VPWR VPWR _03287_ sky130_fd_sc_hd__a22o_1
XFILLER_136_685 VGND VGND VPWR VPWR sky130_fd_sc_hd__decap_4
XFILLER_108_376 VGND VGND VPWR VPWR sky130_fd_sc_hd__fill_1
XFILLER_89_45 VGND VGND VPWR VPWR sky130_fd_sc_hd__decap_4
X_10393_ _03210_ _03211_ VGND VGND VPWR VPWR _03212_ sky130_fd_sc_hd__nand2_1
X_13181_ _05894_ _05994_ _06252_ VGND VGND VPWR VPWR _06253_ sky130_fd_sc_hd__nor3_1
XFILLER_108_398 VPWR VGND VPWR VGND sky130_ef_sc_hd__decap_12
X_12132_ net912 _05105_ _04952_ _04955_ VGND VGND VPWR VPWR _05107_ sky130_fd_sc_hd__o211ai_2
X_12063_ net500 net508 net675 net673 VGND VGND VPWR VPWR _05032_ sky130_fd_sc_hd__nand4_1
XFILLER_2_643 VGND VGND VPWR VPWR sky130_fd_sc_hd__fill_1
XFILLER_77_400 VPWR VGND VPWR VGND sky130_ef_sc_hd__decap_12
X_11014_ _03541_ _03546_ VGND VGND VPWR VPWR _03890_ sky130_fd_sc_hd__or2_2
XFILLER_131_390 VGND VGND VPWR VPWR sky130_fd_sc_hd__fill_2
XFILLER_89_293 VGND VGND VPWR VPWR sky130_fd_sc_hd__fill_1
XFILLER_77_444 VGND VGND VPWR VPWR sky130_fd_sc_hd__decap_4
XTAP_TAPCELL_ROW_88_1529 VGND VPWR sky130_fd_sc_hd__tapvpwrvgnd_1
X_12965_ net420 net581 _05895_ _05894_ net412 VGND VGND VPWR VPWR _06017_ sky130_fd_sc_hd__a32o_1
XFILLER_73_661 VGND VGND VPWR VPWR sky130_fd_sc_hd__fill_1
XFILLER_61_801 VGND VGND VPWR VPWR sky130_fd_sc_hd__fill_2
X_11916_ _04689_ _04691_ VGND VGND VPWR VPWR _04871_ sky130_fd_sc_hd__nor2_1
XFILLER_33_503 VGND VGND VPWR VPWR sky130_fd_sc_hd__fill_1
X_12896_ _05743_ _05796_ _05795_ VGND VGND VPWR VPWR _05942_ sky130_fd_sc_hd__o21a_1
X_11847_ _04794_ _04793_ _04792_ VGND VGND VPWR VPWR _04797_ sky130_fd_sc_hd__a21bo_1
XFILLER_33_547 VGND VGND VPWR VPWR sky130_fd_sc_hd__fill_1
X_11778_ _04667_ _04718_ VGND VGND VPWR VPWR _04721_ sky130_fd_sc_hd__nor2_1
XTAP_TAPCELL_ROW_31_726 VGND VPWR sky130_fd_sc_hd__tapvpwrvgnd_1
X_10729_ net475 net655 _03395_ _03394_ VGND VGND VPWR VPWR _03579_ sky130_fd_sc_hd__a31o_1
XTAP_TAPCELL_ROW_11_450 VGND VPWR sky130_fd_sc_hd__tapvpwrvgnd_1
XFILLER_127_685 VPWR VGND VPWR VGND sky130_ef_sc_hd__decap_12
X_13379_ clknet_3_4__leaf_clk _00037_ _00089_ VGND VGND VPWR VPWR net193 sky130_fd_sc_hd__dfrtp_1
XFILLER_55_3 VGND VGND VPWR VPWR sky130_fd_sc_hd__fill_2
XFILLER_114_335 VGND VGND VPWR VPWR sky130_fd_sc_hd__decap_8
XFILLER_114_379 VGND VGND VPWR VPWR sky130_fd_sc_hd__fill_1
XFILLER_102_519 VPWR VGND VPWR VGND sky130_ef_sc_hd__decap_12
X_07940_ _00674_ _00677_ VGND VGND VPWR VPWR _00678_ sky130_fd_sc_hd__and2b_1
XPHY_EDGE_ROW_10_Left_147 VGND VGND VPWR VPWR sky130_fd_sc_hd__decap_3
XTAP_TAPCELL_ROW_110_1836 VGND VPWR sky130_fd_sc_hd__tapvpwrvgnd_1
XFILLER_96_720 VGND VGND VPWR VPWR sky130_fd_sc_hd__decap_8
XFILLER_110_530 VGND VGND VPWR VPWR sky130_fd_sc_hd__fill_2
X_07871_ _00606_ _00607_ VGND VGND VPWR VPWR _00609_ sky130_fd_sc_hd__and2_1
XFILLER_95_230 VGND VGND VPWR VPWR sky130_fd_sc_hd__decap_8
X_09610_ _02238_ _02363_ VGND VGND VPWR VPWR _02364_ sky130_fd_sc_hd__xnor2_2
X_06822_ _03532_ _03576_ VGND VGND VPWR VPWR _03587_ sky130_fd_sc_hd__or2_1
XFILLER_96_797 VGND VGND VPWR VPWR sky130_fd_sc_hd__decap_6
XFILLER_96_775 VGND VGND VPWR VPWR sky130_fd_sc_hd__decap_3
XFILLER_68_499 VGND VGND VPWR VPWR sky130_fd_sc_hd__decap_3
XFILLER_18_19 VGND VGND VPWR VPWR sky130_fd_sc_hd__fill_2
X_06753_ _02446_ _02823_ VGND VGND VPWR VPWR _02834_ sky130_fd_sc_hd__xnor2_1
X_09541_ _02286_ _02287_ VGND VGND VPWR VPWR _02289_ sky130_fd_sc_hd__xnor2_2
XTAP_TAPCELL_ROW_39_837 VGND VPWR sky130_fd_sc_hd__tapvpwrvgnd_1
XFILLER_36_363 VGND VGND VPWR VPWR sky130_fd_sc_hd__fill_1
X_09472_ _02210_ _02211_ VGND VGND VPWR VPWR _02214_ sky130_fd_sc_hd__xnor2_1
X_06684_ net494 VGND VGND VPWR VPWR _02087_ sky130_fd_sc_hd__inv_4
XTAP_TAPCELL_ROW_19_561 VGND VPWR sky130_fd_sc_hd__tapvpwrvgnd_1
XFILLER_24_525 VGND VGND VPWR VPWR sky130_fd_sc_hd__fill_2
X_08423_ net669 net265 net263 net692 VGND VGND VPWR VPWR _01153_ sky130_fd_sc_hd__a22o_1
XFILLER_34_29 VGND VGND VPWR VPWR sky130_fd_sc_hd__fill_1
XTAP_TAPCELL_ROW_121_1987 VGND VPWR sky130_fd_sc_hd__tapvpwrvgnd_1
X_08354_ _01085_ VGND VGND VPWR VPWR _01086_ sky130_fd_sc_hd__inv_2
X_07305_ net427 net382 net40 net514 VGND VGND VPWR VPWR _06596_ sky130_fd_sc_hd__a22o_1
XFILLER_20_742 VPWR VGND VPWR VGND sky130_ef_sc_hd__decap_12
X_08285_ _01018_ _01019_ VGND VGND VPWR VPWR _01020_ sky130_fd_sc_hd__xnor2_1
Xclkload6 clknet_3_7__leaf_clk VGND VGND VPWR VPWR clkload6/X sky130_fd_sc_hd__clkbuf_8
X_07236_ _06374_ _06377_ _06525_ VGND VGND VPWR VPWR _06527_ sky130_fd_sc_hd__nand3_1
XTAP_TAPCELL_ROW_59_1119 VGND VPWR sky130_fd_sc_hd__tapvpwrvgnd_1
XFILLER_117_140 VGND VGND VPWR VPWR sky130_fd_sc_hd__decap_4
XFILLER_106_803 VGND VGND VPWR VPWR sky130_fd_sc_hd__decap_4
XFILLER_105_302 VPWR VGND VPWR VGND sky130_ef_sc_hd__decap_12
X_07167_ net514 net382 VGND VGND VPWR VPWR _06459_ sky130_fd_sc_hd__nand2_1
XFILLER_132_121 VPWR VGND VPWR VGND sky130_ef_sc_hd__decap_12
XFILLER_117_184 VGND VGND VPWR VPWR sky130_fd_sc_hd__fill_2
XTAP_TAPCELL_ROW_72_1308 VGND VPWR sky130_fd_sc_hd__tapvpwrvgnd_1
XFILLER_59_15 VGND VGND VPWR VPWR sky130_fd_sc_hd__fill_1
XFILLER_3_429 VPWR VGND VPWR VGND sky130_ef_sc_hd__decap_12
X_07098_ _06388_ _06389_ VGND VGND VPWR VPWR _06390_ sky130_fd_sc_hd__nand2_1
XFILLER_105_357 VGND VGND VPWR VPWR sky130_fd_sc_hd__fill_2
XFILLER_132_165 VGND VGND VPWR VPWR sky130_fd_sc_hd__decap_8
Xfanout254 net96 VGND VGND VPWR VPWR net254 sky130_fd_sc_hd__clkbuf_2
Xfanout265 net90 VGND VGND VPWR VPWR net265 sky130_fd_sc_hd__clkbuf_2
XFILLER_59_433 VGND VGND VPWR VPWR sky130_fd_sc_hd__fill_2
X_09808_ net573 net545 net253 net97 VGND VGND VPWR VPWR _02579_ sky130_fd_sc_hd__and4b_1
XFILLER_74_403 VGND VGND VPWR VPWR sky130_fd_sc_hd__decap_6
Xfanout287 net289 VGND VGND VPWR VPWR net287 sky130_fd_sc_hd__buf_2
Xfanout298 net76 VGND VGND VPWR VPWR net298 sky130_fd_sc_hd__buf_2
Xfanout276 net86 VGND VGND VPWR VPWR net276 sky130_fd_sc_hd__buf_1
XFILLER_47_617 VGND VGND VPWR VPWR sky130_fd_sc_hd__decap_4
XFILLER_47_606 VGND VGND VPWR VPWR sky130_fd_sc_hd__decap_8
X_09739_ _02228_ _02229_ _02368_ _02369_ VGND VGND VPWR VPWR _02504_ sky130_fd_sc_hd__o22a_1
XFILLER_86_296 VPWR VGND VPWR VGND sky130_ef_sc_hd__decap_12
XFILLER_46_127 VGND VGND VPWR VPWR sky130_fd_sc_hd__decap_6
XFILLER_43_801 VGND VGND VPWR VPWR sky130_fd_sc_hd__decap_8
XFILLER_15_514 VGND VGND VPWR VPWR sky130_fd_sc_hd__decap_4
XFILLER_15_525 VGND VGND VPWR VPWR sky130_fd_sc_hd__decap_4
X_12750_ _05589_ _05590_ _05781_ VGND VGND VPWR VPWR _05783_ sky130_fd_sc_hd__o21ai_2
XFILLER_91_57 VPWR VGND VPWR VGND sky130_ef_sc_hd__decap_12
XFILLER_91_46 VGND VGND VPWR VPWR sky130_fd_sc_hd__fill_1
XFILLER_91_35 VGND VGND VPWR VPWR sky130_fd_sc_hd__fill_2
XTAP_TAPCELL_ROW_83_1459 VGND VPWR sky130_fd_sc_hd__tapvpwrvgnd_1
XFILLER_70_664 VGND VGND VPWR VPWR sky130_fd_sc_hd__fill_1
X_11701_ _04596_ _04635_ _04636_ _04594_ VGND VGND VPWR VPWR _04637_ sky130_fd_sc_hd__o22a_1
XFILLER_15_558 VGND VGND VPWR VPWR sky130_fd_sc_hd__fill_2
XFILLER_15_569 VPWR VGND VPWR VGND sky130_ef_sc_hd__decap_12
X_12681_ _05666_ _05705_ VGND VGND VPWR VPWR _05707_ sky130_fd_sc_hd__xnor2_1
X_11632_ _04563_ _04564_ VGND VGND VPWR VPWR _04565_ sky130_fd_sc_hd__xnor2_1
XFILLER_24_73 VGND VGND VPWR VPWR sky130_fd_sc_hd__decap_4
X_13302_ net394 VGND VGND VPWR VPWR _00076_ sky130_fd_sc_hd__inv_2
XFILLER_11_753 VPWR VGND VPWR VGND sky130_ef_sc_hd__decap_12
XFILLER_10_241 VGND VGND VPWR VPWR sky130_fd_sc_hd__fill_1
X_11563_ _04488_ _04489_ VGND VGND VPWR VPWR _04490_ sky130_fd_sc_hd__nand2_1
XFILLER_109_641 VGND VGND VPWR VPWR sky130_fd_sc_hd__decap_8
X_10514_ _03342_ VGND VGND VPWR VPWR _03343_ sky130_fd_sc_hd__inv_2
XFILLER_11_797 VPWR VGND VPWR VGND sky130_ef_sc_hd__decap_12
XFILLER_10_274 VGND VGND VPWR VPWR sky130_fd_sc_hd__fill_1
X_11494_ _04412_ _04413_ VGND VGND VPWR VPWR _04415_ sky130_fd_sc_hd__nor2_1
XFILLER_124_600 VGND VGND VPWR VPWR sky130_fd_sc_hd__decap_8
X_10445_ _03116_ _03119_ _03117_ VGND VGND VPWR VPWR _03268_ sky130_fd_sc_hd__o21bai_1
XFILLER_6_245 VGND VGND VPWR VPWR sky130_fd_sc_hd__decap_6
X_13233_ _06203_ _06209_ _06202_ VGND VGND VPWR VPWR _06310_ sky130_fd_sc_hd__a21oi_1
XFILLER_108_195 VGND VGND VPWR VPWR sky130_fd_sc_hd__fill_1
X_13164_ _05785_ _06119_ VGND VGND VPWR VPWR _06234_ sky130_fd_sc_hd__nor2_1
XFILLER_6_289 VPWR VGND VPWR VGND sky130_ef_sc_hd__decap_12
XFILLER_40_83 VGND VGND VPWR VPWR sky130_fd_sc_hd__fill_1
X_10376_ net266 net274 _03061_ _03059_ VGND VGND VPWR VPWR _03193_ sky130_fd_sc_hd__a31oi_1
X_12115_ _05084_ _05087_ VGND VGND VPWR VPWR _05088_ sky130_fd_sc_hd__xnor2_1
XFILLER_124_699 VGND VGND VPWR VPWR sky130_fd_sc_hd__fill_1
X_13095_ _06130_ _06157_ VGND VGND VPWR VPWR _06159_ sky130_fd_sc_hd__xor2_1
XFILLER_111_349 VGND VGND VPWR VPWR sky130_fd_sc_hd__decap_8
X_12046_ _05002_ _05012_ VGND VGND VPWR VPWR _05013_ sky130_fd_sc_hd__xor2_1
XFILLER_93_701 VPWR VGND VPWR VGND sky130_ef_sc_hd__decap_12
XTAP_TAPCELL_ROW_125_2043 VGND VPWR sky130_fd_sc_hd__tapvpwrvgnd_1
XFILLER_77_285 VGND VGND VPWR VPWR sky130_fd_sc_hd__decap_6
XFILLER_1_55 VGND VGND VPWR VPWR sky130_fd_sc_hd__fill_1
XFILLER_37_127 VPWR VGND VPWR VGND sky130_ef_sc_hd__decap_12
XFILLER_18_352 VGND VGND VPWR VPWR sky130_fd_sc_hd__fill_1
XFILLER_34_801 VGND VGND VPWR VPWR sky130_fd_sc_hd__fill_2
XFILLER_52_108 VGND VGND VPWR VPWR sky130_fd_sc_hd__decap_3
X_12948_ _05990_ _05996_ VGND VGND VPWR VPWR _05999_ sky130_fd_sc_hd__xnor2_1
XFILLER_33_300 VGND VGND VPWR VPWR sky130_fd_sc_hd__fill_2
XTAP_TAPCELL_ROW_16_520 VGND VPWR sky130_fd_sc_hd__tapvpwrvgnd_1
X_12879_ _05774_ _05777_ VGND VGND VPWR VPWR _05924_ sky130_fd_sc_hd__nor2_1
XFILLER_60_141 VGND VGND VPWR VPWR sky130_fd_sc_hd__decap_4
XFILLER_21_517 VPWR VGND VPWR VGND sky130_ef_sc_hd__decap_12
XFILLER_14_580 VGND VGND VPWR VPWR sky130_fd_sc_hd__decap_8
XFILLER_33_399 VPWR VGND VPWR VGND sky130_ef_sc_hd__decap_12
XFILLER_119_449 VPWR VGND VPWR VGND sky130_ef_sc_hd__decap_12
X_08070_ _00792_ _00806_ VGND VGND VPWR VPWR _00807_ sky130_fd_sc_hd__xnor2_1
XTAP_TAPCELL_ROW_136_2194 VGND VPWR sky130_fd_sc_hd__tapvpwrvgnd_1
XFILLER_115_600 VPWR VGND VPWR VGND sky130_ef_sc_hd__decap_12
X_07021_ _05735_ _05746_ VGND VGND VPWR VPWR _05757_ sky130_fd_sc_hd__nor2_1
XFILLER_130_625 VPWR VGND VPWR VGND sky130_ef_sc_hd__decap_12
XFILLER_115_699 VGND VGND VPWR VPWR sky130_fd_sc_hd__decap_6
XFILLER_102_327 VGND VGND VPWR VPWR sky130_fd_sc_hd__fill_1
XFILLER_88_539 VPWR VGND VPWR VGND sky130_ef_sc_hd__decap_12
X_08972_ net358 net335 net60 net329 VGND VGND VPWR VPWR _01698_ sky130_fd_sc_hd__nand4_1
XTAP_TAPCELL_ROW_54_1049 VGND VPWR sky130_fd_sc_hd__tapvpwrvgnd_1
XFILLER_130_669 VPWR VGND VPWR VGND sky130_ef_sc_hd__decap_12
X_07923_ net679 net483 net678 net490 VGND VGND VPWR VPWR _00661_ sky130_fd_sc_hd__a22oi_1
X_07854_ _00587_ _00588_ _00590_ VGND VGND VPWR VPWR _00592_ sky130_fd_sc_hd__or3_1
XFILLER_96_583 VGND VGND VPWR VPWR sky130_fd_sc_hd__decap_4
XFILLER_69_797 VGND VGND VPWR VPWR sky130_fd_sc_hd__decap_3
XFILLER_28_105 VPWR VGND VPWR VGND sky130_ef_sc_hd__decap_12
XFILLER_29_617 VGND VGND VPWR VPWR sky130_fd_sc_hd__decap_8
X_06805_ net323 net620 net643 net321 VGND VGND VPWR VPWR _03401_ sky130_fd_sc_hd__a22oi_1
XFILLER_83_200 VPWR VGND VPWR VGND sky130_ef_sc_hd__decap_12
X_07785_ _00521_ _00522_ VGND VGND VPWR VPWR _00524_ sky130_fd_sc_hd__xnor2_1
X_06736_ net323 net687 net320 net267 VGND VGND VPWR VPWR _02653_ sky130_fd_sc_hd__a22oi_1
X_09524_ _02261_ _02269_ VGND VGND VPWR VPWR _02270_ sky130_fd_sc_hd__xnor2_1
X_09455_ net438 net537 _02193_ _02194_ VGND VGND VPWR VPWR _02195_ sky130_fd_sc_hd__o2bb2a_1
X_08406_ _01134_ _01135_ VGND VGND VPWR VPWR _01136_ sky130_fd_sc_hd__or2_1
XFILLER_24_355 VGND VGND VPWR VPWR sky130_fd_sc_hd__decap_8
X_09386_ _01943_ _01955_ _01954_ VGND VGND VPWR VPWR _02119_ sky130_fd_sc_hd__a21oi_1
X_08337_ _00963_ _00984_ _00961_ VGND VGND VPWR VPWR _01071_ sky130_fd_sc_hd__a21oi_1
X_08268_ _01001_ _01002_ VGND VGND VPWR VPWR _01003_ sky130_fd_sc_hd__and2b_1
X_07219_ net267 _02131_ VGND VGND VPWR VPWR _06510_ sky130_fd_sc_hd__nor2_1
X_08199_ _00932_ _00933_ VGND VGND VPWR VPWR _00935_ sky130_fd_sc_hd__xor2_1
X_10230_ _03032_ _03033_ _02920_ VGND VGND VPWR VPWR _03035_ sky130_fd_sc_hd__a21bo_1
XFILLER_4_749 VGND VGND VPWR VPWR sky130_fd_sc_hd__decap_6
XFILLER_106_666 VPWR VGND VPWR VGND sky130_ef_sc_hd__decap_12
XFILLER_105_143 VGND VGND VPWR VPWR sky130_fd_sc_hd__decap_4
XFILLER_105_121 VGND VGND VPWR VPWR sky130_fd_sc_hd__fill_1
XFILLER_3_237 VPWR VGND VPWR VGND sky130_ef_sc_hd__decap_12
XFILLER_133_485 VPWR VGND VPWR VGND sky130_ef_sc_hd__decap_12
XFILLER_126_53 VPWR VGND VPWR VGND sky130_ef_sc_hd__decap_12
X_10161_ net468 net574 _02950_ _02951_ VGND VGND VPWR VPWR _02959_ sky130_fd_sc_hd__o2bb2a_1
XFILLER_10_97 VGND VGND VPWR VPWR sky130_fd_sc_hd__decap_4
XFILLER_126_97 VPWR VGND VPWR VGND sky130_ef_sc_hd__decap_12
XFILLER_121_658 VPWR VGND VPWR VGND sky130_ef_sc_hd__decap_12
X_10092_ net689 net277 net275 net266 VGND VGND VPWR VPWR _02883_ sky130_fd_sc_hd__a22o_1
XFILLER_59_230 VPWR VGND VPWR VGND sky130_ef_sc_hd__decap_12
XFILLER_101_360 VGND VGND VPWR VPWR sky130_fd_sc_hd__fill_2
XFILLER_87_561 VGND VGND VPWR VPWR sky130_fd_sc_hd__decap_6
XFILLER_87_583 VGND VGND VPWR VPWR sky130_fd_sc_hd__fill_1
XFILLER_75_767 VPWR VGND VPWR VGND sky130_ef_sc_hd__decap_12
XFILLER_47_458 VGND VGND VPWR VPWR sky130_fd_sc_hd__fill_2
X_10994_ net539 net277 net275 net565 VGND VGND VPWR VPWR _03868_ sky130_fd_sc_hd__a22oi_1
XFILLER_27_160 VGND VGND VPWR VPWR sky130_fd_sc_hd__decap_8
X_12802_ _05676_ _05679_ _05675_ VGND VGND VPWR VPWR _05839_ sky130_fd_sc_hd__a21oi_1
X_12733_ _05758_ _05763_ VGND VGND VPWR VPWR _05764_ sky130_fd_sc_hd__and2_1
XFILLER_42_130 VGND VGND VPWR VPWR sky130_fd_sc_hd__decap_8
XFILLER_70_472 VGND VGND VPWR VPWR sky130_fd_sc_hd__decap_4
XFILLER_43_664 VGND VGND VPWR VPWR sky130_fd_sc_hd__fill_1
XFILLER_35_83 VPWR VGND VPWR VGND sky130_ef_sc_hd__decap_12
XFILLER_42_141 VGND VGND VPWR VPWR sky130_fd_sc_hd__decap_4
X_12664_ _05340_ _05345_ VGND VGND VPWR VPWR _05688_ sky130_fd_sc_hd__nor2_2
X_11615_ net401 _03586_ _03590_ _04449_ VGND VGND VPWR VPWR _04546_ sky130_fd_sc_hd__o22a_1
X_12595_ _05608_ _05610_ _05611_ VGND VGND VPWR VPWR _05613_ sky130_fd_sc_hd__or3_1
XTAP_TAPCELL_ROW_41_865 VGND VPWR sky130_fd_sc_hd__tapvpwrvgnd_1
XFILLER_128_246 VGND VGND VPWR VPWR sky130_fd_sc_hd__decap_6
X_11546_ _04388_ _04390_ VGND VGND VPWR VPWR _04471_ sky130_fd_sc_hd__and2b_1
XTAP_TAPCELL_ROW_96_1639 VGND VPWR sky130_fd_sc_hd__tapvpwrvgnd_1
Xmax_cap229 _04824_ VGND VGND VPWR VPWR net229 sky130_fd_sc_hd__buf_1
X_13216_ _06186_ _06188_ _06290_ VGND VGND VPWR VPWR _06291_ sky130_fd_sc_hd__o21a_1
X_11477_ _04362_ _04394_ VGND VGND VPWR VPWR _04397_ sky130_fd_sc_hd__xnor2_1
X_10428_ _03240_ _03247_ VGND VGND VPWR VPWR _03250_ sky130_fd_sc_hd__xor2_1
XFILLER_112_603 VPWR VGND VPWR VGND sky130_ef_sc_hd__decap_12
X_10359_ _03171_ _03172_ _03057_ VGND VGND VPWR VPWR _03176_ sky130_fd_sc_hd__o21ai_1
X_13147_ _06082_ _06084_ _06214_ VGND VGND VPWR VPWR _06217_ sky130_fd_sc_hd__nand3_1
XFILLER_111_113 VPWR VGND VPWR VGND sky130_ef_sc_hd__decap_12
XFILLER_97_358 VGND VGND VPWR VPWR sky130_fd_sc_hd__decap_6
X_13078_ net412 _05994_ _05894_ VGND VGND VPWR VPWR _06141_ sky130_fd_sc_hd__a21oi_1
X_12029_ _04991_ _04993_ VGND VGND VPWR VPWR _04995_ sky130_fd_sc_hd__xnor2_1
XTAP_TAPCELL_ROW_49_976 VGND VPWR sky130_fd_sc_hd__tapvpwrvgnd_1
X_07570_ _00147_ _00309_ VGND VGND VPWR VPWR _00310_ sky130_fd_sc_hd__and2b_1
XFILLER_65_277 VGND VGND VPWR VPWR sky130_fd_sc_hd__decap_3
XTAP_TAPCELL_ROW_49_987 VGND VPWR sky130_fd_sc_hd__tapvpwrvgnd_1
XFILLER_25_108 VGND VGND VPWR VPWR sky130_fd_sc_hd__decap_4
X_09240_ _01963_ _01923_ VGND VGND VPWR VPWR _01964_ sky130_fd_sc_hd__nand2b_1
XTAP_TAPCELL_ROW_105_1768 VGND VPWR sky130_fd_sc_hd__tapvpwrvgnd_1
XFILLER_61_472 VGND VGND VPWR VPWR sky130_fd_sc_hd__decap_3
XFILLER_21_314 VGND VGND VPWR VPWR sky130_fd_sc_hd__decap_8
X_09171_ _01892_ _01894_ _01837_ VGND VGND VPWR VPWR _01896_ sky130_fd_sc_hd__a21oi_1
X_08122_ _00730_ _00743_ _00729_ VGND VGND VPWR VPWR _00858_ sky130_fd_sc_hd__o21ba_1
X_08053_ _00586_ _00592_ _00788_ VGND VGND VPWR VPWR _00790_ sky130_fd_sc_hd__nand3_1
X_07004_ _05494_ _05560_ VGND VGND VPWR VPWR _05571_ sky130_fd_sc_hd__nor2_1
XPHY_EDGE_ROW_131_Right_131 VGND VGND VPWR VPWR sky130_fd_sc_hd__decap_3
XFILLER_115_441 VGND VGND VPWR VPWR sky130_fd_sc_hd__decap_6
XFILLER_103_625 VGND VGND VPWR VPWR sky130_fd_sc_hd__fill_2
XFILLER_130_433 VPWR VGND VPWR VGND sky130_ef_sc_hd__decap_12
XFILLER_88_358 VGND VGND VPWR VPWR sky130_fd_sc_hd__decap_6
X_08955_ _01526_ _01680_ VGND VGND VPWR VPWR _01681_ sky130_fd_sc_hd__xnor2_1
Xinput108 w21[2] VGND VGND VPWR VPWR net108 sky130_fd_sc_hd__dlymetal6s2s_1
XFILLER_130_477 VPWR VGND VPWR VGND sky130_ef_sc_hd__decap_12
X_07906_ _00546_ _00643_ VGND VGND VPWR VPWR _00644_ sky130_fd_sc_hd__nand2_1
Xinput119 w22[5] VGND VGND VPWR VPWR net119 sky130_fd_sc_hd__buf_1
X_08886_ _01609_ _01610_ VGND VGND VPWR VPWR _01612_ sky130_fd_sc_hd__xnor2_1
XFILLER_29_425 VGND VGND VPWR VPWR sky130_fd_sc_hd__fill_1
X_07837_ _00296_ _00454_ _00453_ VGND VGND VPWR VPWR _00575_ sky130_fd_sc_hd__a21oi_1
XFILLER_110_190 VGND VGND VPWR VPWR sky130_fd_sc_hd__decap_6
XFILLER_17_609 VGND VGND VPWR VPWR sky130_fd_sc_hd__decap_6
X_07768_ _00476_ _00506_ VGND VGND VPWR VPWR _00507_ sky130_fd_sc_hd__xor2_1
XFILLER_84_586 VGND VGND VPWR VPWR sky130_fd_sc_hd__fill_2
XFILLER_72_737 VPWR VGND VPWR VGND sky130_ef_sc_hd__decap_12
XTAP_TAPCELL_ROW_67_1229 VGND VPWR sky130_fd_sc_hd__tapvpwrvgnd_1
X_09507_ _02250_ VGND VGND VPWR VPWR _02252_ sky130_fd_sc_hd__inv_2
X_06719_ _02446_ _02457_ VGND VGND VPWR VPWR _02468_ sky130_fd_sc_hd__nor2_1
XFILLER_25_653 VGND VGND VPWR VPWR sky130_fd_sc_hd__decap_6
X_07699_ _00304_ _00319_ _00318_ VGND VGND VPWR VPWR _00438_ sky130_fd_sc_hd__o21a_1
XTAP_TAPCELL_ROW_80_1418 VGND VPWR sky130_fd_sc_hd__tapvpwrvgnd_1
XFILLER_72_48 VPWR VGND VPWR VGND sky130_ef_sc_hd__decap_12
XFILLER_71_269 VGND VGND VPWR VPWR sky130_fd_sc_hd__fill_1
XFILLER_40_601 VGND VGND VPWR VPWR sky130_fd_sc_hd__fill_2
X_09438_ net357 net326 _02021_ _02020_ VGND VGND VPWR VPWR _02177_ sky130_fd_sc_hd__a31o_1
XFILLER_12_336 VGND VGND VPWR VPWR sky130_fd_sc_hd__decap_4
X_09369_ _02099_ _02100_ VGND VGND VPWR VPWR _02101_ sky130_fd_sc_hd__nor2_1
X_11400_ _04170_ _04183_ _04311_ VGND VGND VPWR VPWR _04312_ sky130_fd_sc_hd__o21a_1
X_12380_ net480 net677 _05194_ _05193_ VGND VGND VPWR VPWR _05378_ sky130_fd_sc_hd__a31o_1
XFILLER_122_3 VPWR VGND VPWR VGND sky130_ef_sc_hd__decap_12
X_11331_ _04234_ _04235_ VGND VGND VPWR VPWR _04237_ sky130_fd_sc_hd__xnor2_1
XFILLER_4_513 VPWR VGND VPWR VGND sky130_ef_sc_hd__decap_12
XFILLER_4_557 VPWR VGND VPWR VGND sky130_ef_sc_hd__decap_12
XFILLER_21_74 VGND VGND VPWR VPWR sky130_fd_sc_hd__decap_4
X_11262_ _04026_ _04061_ _04063_ VGND VGND VPWR VPWR _04161_ sky130_fd_sc_hd__a21oi_1
X_10213_ net943 _03011_ _02830_ VGND VGND VPWR VPWR _03016_ sky130_fd_sc_hd__a21oi_4
X_11193_ _04074_ _04085_ VGND VGND VPWR VPWR _04086_ sky130_fd_sc_hd__xor2_1
X_13001_ _05918_ _05920_ VGND VGND VPWR VPWR _06057_ sky130_fd_sc_hd__nand2_1
XFILLER_97_89 VPWR VGND VPWR VGND sky130_ef_sc_hd__decap_12
XTAP_TAPCELL_ROW_91_1569 VGND VPWR sky130_fd_sc_hd__tapvpwrvgnd_1
X_10144_ _02938_ _02939_ VGND VGND VPWR VPWR _02940_ sky130_fd_sc_hd__and2b_1
XFILLER_0_741 VPWR VGND VPWR VGND sky130_ef_sc_hd__decap_12
X_10075_ _02863_ _02864_ VGND VGND VPWR VPWR _02865_ sky130_fd_sc_hd__nand2_1
XFILLER_47_200 VGND VGND VPWR VPWR sky130_fd_sc_hd__decap_3
XTAP_TAPCELL_ROW_7_395 VGND VPWR sky130_fd_sc_hd__tapvpwrvgnd_1
XFILLER_0_785 VPWR VGND VPWR VGND sky130_ef_sc_hd__decap_12
XFILLER_63_704 VGND VGND VPWR VPWR sky130_fd_sc_hd__fill_1
XFILLER_47_233 VGND VGND VPWR VPWR sky130_fd_sc_hd__fill_2
XTAP_TAPCELL_ROW_122_2002 VGND VPWR sky130_fd_sc_hd__tapvpwrvgnd_1
XFILLER_90_523 VGND VGND VPWR VPWR sky130_fd_sc_hd__decap_8
XFILLER_75_586 VGND VGND VPWR VPWR sky130_fd_sc_hd__decap_6
XFILLER_47_288 VPWR VGND VPWR VGND sky130_ef_sc_hd__decap_12
XTAP_TAPCELL_ROW_46_935 VGND VPWR sky130_fd_sc_hd__tapvpwrvgnd_1
XFILLER_46_60 VGND VGND VPWR VPWR sky130_fd_sc_hd__fill_1
XFILLER_90_545 VPWR VGND VPWR VGND sky130_ef_sc_hd__decap_12
XFILLER_62_269 VGND VGND VPWR VPWR sky130_fd_sc_hd__fill_1
X_10977_ _03677_ _03679_ _03848_ _03849_ VGND VGND VPWR VPWR _03851_ sky130_fd_sc_hd__o211ai_2
XFILLER_43_461 VGND VGND VPWR VPWR sky130_fd_sc_hd__decap_3
XFILLER_16_686 VGND VGND VPWR VPWR sky130_fd_sc_hd__fill_2
XFILLER_43_472 VPWR VGND VPWR VGND sky130_ef_sc_hd__decap_12
X_12716_ _05608_ _05610_ _05611_ _05609_ _05435_ VGND VGND VPWR VPWR _05745_ sky130_fd_sc_hd__o32a_2
XFILLER_31_645 VGND VGND VPWR VPWR sky130_fd_sc_hd__decap_4
XFILLER_87_6 VGND VGND VPWR VPWR sky130_fd_sc_hd__fill_2
XFILLER_62_70 VGND VGND VPWR VPWR sky130_fd_sc_hd__decap_3
X_12647_ net567 net541 net296 net294 VGND VGND VPWR VPWR _05670_ sky130_fd_sc_hd__and4_1
XFILLER_30_155 VGND VGND VPWR VPWR sky130_fd_sc_hd__decap_3
XFILLER_30_166 VPWR VGND VPWR VGND sky130_ef_sc_hd__decap_12
XFILLER_30_188 VGND VGND VPWR VPWR sky130_fd_sc_hd__decap_8
XTAP_TAPCELL_ROW_100_1698 VGND VPWR sky130_fd_sc_hd__tapvpwrvgnd_1
XFILLER_11_391 VGND VGND VPWR VPWR sky130_fd_sc_hd__fill_1
X_12578_ _05410_ _05413_ VGND VGND VPWR VPWR _05595_ sky130_fd_sc_hd__nand2_1
XTAP_TAPCELL_ROW_133_2153 VGND VPWR sky130_fd_sc_hd__tapvpwrvgnd_1
X_11529_ _04448_ _04452_ VGND VGND VPWR VPWR _04453_ sky130_fd_sc_hd__xnor2_1
XFILLER_7_373 VPWR VGND VPWR VGND sky130_ef_sc_hd__decap_12
XFILLER_116_238 VPWR VGND VPWR VGND sky130_ef_sc_hd__decap_12
XFILLER_125_783 VGND VGND VPWR VPWR sky130_fd_sc_hd__fill_1
XFILLER_98_601 VPWR VGND VPWR VGND sky130_ef_sc_hd__decap_12
XTAP_TAPCELL_ROW_51_1008 VGND VPWR sky130_fd_sc_hd__tapvpwrvgnd_1
XFILLER_98_689 VGND VGND VPWR VPWR sky130_fd_sc_hd__fill_2
X_08740_ _01346_ _01465_ VGND VGND VPWR VPWR _01467_ sky130_fd_sc_hd__and2_1
XFILLER_97_177 VGND VGND VPWR VPWR sky130_fd_sc_hd__fill_1
XFILLER_85_328 VGND VGND VPWR VPWR sky130_fd_sc_hd__decap_8
X_08671_ _01396_ _01397_ _01398_ VGND VGND VPWR VPWR _01399_ sky130_fd_sc_hd__and3_1
XFILLER_66_564 VPWR VGND VPWR VGND sky130_ef_sc_hd__decap_12
XFILLER_38_233 VGND VGND VPWR VPWR sky130_fd_sc_hd__fill_1
X_07622_ net435 net605 net418 net603 VGND VGND VPWR VPWR _00362_ sky130_fd_sc_hd__and4_1
XFILLER_38_266 VGND VGND VPWR VPWR sky130_fd_sc_hd__decap_6
XFILLER_38_277 VGND VGND VPWR VPWR sky130_fd_sc_hd__fill_1
XFILLER_19_491 VGND VGND VPWR VPWR sky130_fd_sc_hd__fill_1
XFILLER_26_439 VGND VGND VPWR VPWR sky130_fd_sc_hd__decap_4
XFILLER_38_299 VGND VGND VPWR VPWR sky130_fd_sc_hd__fill_1
X_07553_ net642 net305 _06675_ _06674_ VGND VGND VPWR VPWR _00293_ sky130_fd_sc_hd__a31o_1
XFILLER_22_601 VPWR VGND VPWR VGND sky130_ef_sc_hd__decap_12
X_07484_ _06587_ _00223_ VGND VGND VPWR VPWR _00225_ sky130_fd_sc_hd__xnor2_1
XFILLER_21_100 VGND VGND VPWR VPWR sky130_fd_sc_hd__decap_4
XTAP_TAPCELL_ROW_24_629 VGND VPWR sky130_fd_sc_hd__tapvpwrvgnd_1
XFILLER_34_472 VGND VGND VPWR VPWR sky130_fd_sc_hd__decap_4
X_09223_ net544 net260 VGND VGND VPWR VPWR _01947_ sky130_fd_sc_hd__and2_1
XTAP_TAPCELL_ROW_62_1159 VGND VPWR sky130_fd_sc_hd__tapvpwrvgnd_1
XFILLER_22_645 VPWR VGND VPWR VGND sky130_ef_sc_hd__decap_12
X_09154_ _01872_ _01873_ _01878_ VGND VGND VPWR VPWR _01879_ sky130_fd_sc_hd__a21o_1
XFILLER_21_177 VGND VGND VPWR VPWR sky130_fd_sc_hd__decap_3
XFILLER_135_503 VGND VGND VPWR VPWR sky130_fd_sc_hd__fill_1
X_08105_ _00832_ _00839_ VGND VGND VPWR VPWR _00841_ sky130_fd_sc_hd__xnor2_1
XTAP_TAPCELL_ROW_118_1948 VGND VPWR sky130_fd_sc_hd__tapvpwrvgnd_1
X_09085_ net493 net487 net631 net629 VGND VGND VPWR VPWR _01810_ sky130_fd_sc_hd__and4_1
Xinput90 w13[0] VGND VGND VPWR VPWR net90 sky130_fd_sc_hd__clkbuf_1
X_08036_ _00748_ _00771_ VGND VGND VPWR VPWR _00773_ sky130_fd_sc_hd__xnor2_1
XPHY_EDGE_ROW_2_Left_139 VGND VGND VPWR VPWR sky130_fd_sc_hd__decap_3
XFILLER_1_505 VPWR VGND VPWR VGND sky130_ef_sc_hd__decap_12
XFILLER_107_55 VGND VGND VPWR VPWR sky130_fd_sc_hd__fill_1
XFILLER_103_422 VPWR VGND VPWR VGND sky130_ef_sc_hd__decap_12
XFILLER_88_122 VGND VGND VPWR VPWR sky130_fd_sc_hd__decap_3
XFILLER_131_753 VPWR VGND VPWR VGND sky130_ef_sc_hd__decap_12
X_09987_ _02756_ _02771_ VGND VGND VPWR VPWR _02773_ sky130_fd_sc_hd__xnor2_1
XFILLER_76_306 VGND VGND VPWR VPWR sky130_fd_sc_hd__fill_2
XFILLER_131_797 VPWR VGND VPWR VGND sky130_ef_sc_hd__decap_12
X_08938_ _01661_ _01662_ _01507_ VGND VGND VPWR VPWR _01664_ sky130_fd_sc_hd__a21bo_1
XFILLER_88_177 VGND VGND VPWR VPWR sky130_fd_sc_hd__decap_4
X_08869_ net693 net670 net255 net254 VGND VGND VPWR VPWR _01595_ sky130_fd_sc_hd__and4_1
XTAP_TAPCELL_ROW_4_354 VGND VPWR sky130_fd_sc_hd__tapvpwrvgnd_1
XFILLER_29_233 VGND VGND VPWR VPWR sky130_fd_sc_hd__fill_1
XFILLER_84_372 VGND VGND VPWR VPWR sky130_fd_sc_hd__decap_6
XFILLER_29_266 VGND VGND VPWR VPWR sky130_fd_sc_hd__decap_6
X_10900_ _03396_ _03765_ VGND VGND VPWR VPWR _03766_ sky130_fd_sc_hd__xnor2_1
XFILLER_84_394 VGND VGND VPWR VPWR sky130_fd_sc_hd__fill_2
XFILLER_83_69 VGND VGND VPWR VPWR sky130_fd_sc_hd__fill_1
X_11880_ _04634_ _04645_ _04633_ VGND VGND VPWR VPWR _04833_ sky130_fd_sc_hd__a21o_1
X_10831_ _03690_ _03689_ VGND VGND VPWR VPWR _00023_ sky130_fd_sc_hd__xor2_1
XFILLER_16_41 VGND VGND VPWR VPWR sky130_fd_sc_hd__decap_8
XFILLER_53_781 VGND VGND VPWR VPWR sky130_fd_sc_hd__decap_3
XPHY_EDGE_ROW_11_Right_11 VGND VGND VPWR VPWR sky130_fd_sc_hd__decap_3
X_10762_ _02011_ net57 _03436_ _03433_ VGND VGND VPWR VPWR _03615_ sky130_fd_sc_hd__a31o_1
XFILLER_52_291 VGND VGND VPWR VPWR sky130_fd_sc_hd__decap_8
XFILLER_12_133 VGND VGND VPWR VPWR sky130_fd_sc_hd__decap_6
XFILLER_13_656 VGND VGND VPWR VPWR sky130_fd_sc_hd__decap_6
X_12501_ _05506_ _05509_ VGND VGND VPWR VPWR _05510_ sky130_fd_sc_hd__nand2_1
X_10693_ _03391_ _03400_ _03399_ VGND VGND VPWR VPWR _03539_ sky130_fd_sc_hd__a21bo_1
X_12432_ net42 net369 net290 VGND VGND VPWR VPWR _05435_ sky130_fd_sc_hd__o21a_4
XFILLER_40_475 VGND VGND VPWR VPWR sky130_fd_sc_hd__fill_1
XFILLER_8_137 VGND VGND VPWR VPWR sky130_fd_sc_hd__decap_3
X_12363_ _05336_ _05358_ VGND VGND VPWR VPWR _05359_ sky130_fd_sc_hd__nand2b_1
X_12294_ _05281_ _05282_ VGND VGND VPWR VPWR _05284_ sky130_fd_sc_hd__xor2_2
XFILLER_4_321 VPWR VGND VPWR VGND sky130_ef_sc_hd__decap_12
X_11314_ net416 _02251_ _03396_ VGND VGND VPWR VPWR _04218_ sky130_fd_sc_hd__o21ai_1
XFILLER_107_783 VGND VGND VPWR VPWR sky130_fd_sc_hd__fill_1
XFILLER_4_365 VPWR VGND VPWR VGND sky130_ef_sc_hd__decap_12
X_11245_ _04107_ _04141_ VGND VGND VPWR VPWR _04143_ sky130_fd_sc_hd__xor2_2
XPHY_EDGE_ROW_20_Right_20 VGND VGND VPWR VPWR sky130_fd_sc_hd__decap_3
XFILLER_95_604 VGND VGND VPWR VPWR sky130_fd_sc_hd__decap_6
XFILLER_79_166 VGND VGND VPWR VPWR sky130_fd_sc_hd__fill_2
XFILLER_79_144 VGND VGND VPWR VPWR sky130_fd_sc_hd__decap_8
X_11176_ net308 net344 VGND VGND VPWR VPWR _04067_ sky130_fd_sc_hd__nand2_1
X_10127_ net531 net649 VGND VGND VPWR VPWR _02922_ sky130_fd_sc_hd__nand2_1
XFILLER_121_296 VGND VGND VPWR VPWR sky130_fd_sc_hd__decap_8
XFILLER_94_158 VPWR VGND VPWR VGND sky130_ef_sc_hd__decap_12
XFILLER_82_309 VPWR VGND VPWR VGND sky130_ef_sc_hd__decap_12
X_10058_ net531 net652 VGND VGND VPWR VPWR _02847_ sky130_fd_sc_hd__nand2_1
XFILLER_48_531 VGND VGND VPWR VPWR sky130_fd_sc_hd__fill_1
XFILLER_75_361 VPWR VGND VPWR VGND sky130_ef_sc_hd__decap_12
XFILLER_75_383 VGND VGND VPWR VPWR sky130_fd_sc_hd__decap_8
XFILLER_63_556 VGND VGND VPWR VPWR sky130_fd_sc_hd__decap_4
XFILLER_35_225 VGND VGND VPWR VPWR sky130_fd_sc_hd__decap_4
XFILLER_35_258 VPWR VGND VPWR VGND sky130_ef_sc_hd__decap_12
XTAP_TAPCELL_ROW_102_1727 VGND VPWR sky130_fd_sc_hd__tapvpwrvgnd_1
XTAP_TAPCELL_ROW_102_1716 VGND VPWR sky130_fd_sc_hd__tapvpwrvgnd_1
XFILLER_31_442 VGND VGND VPWR VPWR sky130_fd_sc_hd__decap_6
XFILLER_117_503 VGND VGND VPWR VPWR sky130_fd_sc_hd__fill_1
XFILLER_117_569 VGND VGND VPWR VPWR sky130_fd_sc_hd__fill_2
XFILLER_7_181 VPWR VGND VPWR VGND sky130_ef_sc_hd__decap_12
X_09910_ _01949_ _02421_ _02547_ VGND VGND VPWR VPWR _02690_ sky130_fd_sc_hd__or3_1
Xfanout606 net134 VGND VGND VPWR VPWR net606 sky130_fd_sc_hd__clkbuf_2
X_09841_ _02252_ _02463_ _02461_ VGND VGND VPWR VPWR _02615_ sky130_fd_sc_hd__o21a_1
XFILLER_113_764 VPWR VGND VPWR VGND sky130_ef_sc_hd__decap_12
XTAP_TAPCELL_ROW_113_1878 VGND VPWR sky130_fd_sc_hd__tapvpwrvgnd_1
Xfanout628 net126 VGND VGND VPWR VPWR net628 sky130_fd_sc_hd__buf_2
Xfanout639 net646 VGND VGND VPWR VPWR net639 sky130_fd_sc_hd__clkbuf_2
XFILLER_58_306 VGND VGND VPWR VPWR sky130_fd_sc_hd__fill_2
Xfanout617 net623 VGND VGND VPWR VPWR net617 sky130_fd_sc_hd__buf_2
XFILLER_113_797 VPWR VGND VPWR VGND sky130_ef_sc_hd__decap_12
XFILLER_112_274 VPWR VGND VPWR VGND sky130_ef_sc_hd__decap_12
X_06984_ _03609_ _03631_ _05341_ VGND VGND VPWR VPWR _05352_ sky130_fd_sc_hd__a21oi_1
X_09772_ _02399_ _02411_ _02398_ VGND VGND VPWR VPWR _02539_ sky130_fd_sc_hd__a21bo_1
X_08723_ _01449_ _01450_ VGND VGND VPWR VPWR _01451_ sky130_fd_sc_hd__and2_4
XFILLER_85_169 VGND VGND VPWR VPWR sky130_fd_sc_hd__decap_4
XTAP_TAPCELL_ROW_1_302 VGND VPWR sky130_fd_sc_hd__tapvpwrvgnd_1
XTAP_TAPCELL_ROW_1_313 VGND VPWR sky130_fd_sc_hd__tapvpwrvgnd_1
XFILLER_27_726 VGND VGND VPWR VPWR sky130_fd_sc_hd__fill_2
X_08654_ _01223_ _01380_ VGND VGND VPWR VPWR _01382_ sky130_fd_sc_hd__nor2_1
XFILLER_81_331 VGND VGND VPWR VPWR sky130_fd_sc_hd__fill_1
XFILLER_81_320 VGND VGND VPWR VPWR sky130_fd_sc_hd__fill_2
XFILLER_54_523 VGND VGND VPWR VPWR sky130_fd_sc_hd__decap_8
XFILLER_26_225 VGND VGND VPWR VPWR sky130_fd_sc_hd__decap_8
X_07605_ net453 net136 _00202_ _00201_ VGND VGND VPWR VPWR _00345_ sky130_fd_sc_hd__a31o_1
X_08585_ _01304_ _01303_ _01307_ _01311_ VGND VGND VPWR VPWR _01314_ sky130_fd_sc_hd__a211o_4
X_07536_ _00275_ _06656_ _00276_ VGND VGND VPWR VPWR _00277_ sky130_fd_sc_hd__and3_1
XFILLER_50_740 VGND VGND VPWR VPWR sky130_fd_sc_hd__decap_8
XFILLER_34_280 VGND VGND VPWR VPWR sky130_fd_sc_hd__fill_1
X_09206_ net645 net95 _01764_ _01763_ VGND VGND VPWR VPWR _01930_ sky130_fd_sc_hd__a31o_1
X_07467_ net609 net411 net403 net612 VGND VGND VPWR VPWR _00208_ sky130_fd_sc_hd__a22o_1
X_07398_ _06671_ _00138_ VGND VGND VPWR VPWR _00139_ sky130_fd_sc_hd__xnor2_1
Xrebuffer201 _02977_ VGND VGND VPWR VPWR net901 sky130_fd_sc_hd__dlygate4sd1_1
Xrebuffer212 _05104_ VGND VGND VPWR VPWR net912 sky130_fd_sc_hd__buf_2
XFILLER_10_637 VGND VGND VPWR VPWR sky130_fd_sc_hd__decap_6
X_09137_ _01677_ _01860_ VGND VGND VPWR VPWR _01862_ sky130_fd_sc_hd__xnor2_1
Xrebuffer245 net426 VGND VGND VPWR VPWR net945 sky130_fd_sc_hd__buf_2
X_09068_ _01779_ _01791_ VGND VGND VPWR VPWR _01793_ sky130_fd_sc_hd__xnor2_1
XFILLER_123_528 VGND VGND VPWR VPWR sky130_fd_sc_hd__fill_1
XFILLER_118_65 VPWR VGND VPWR VGND sky130_ef_sc_hd__decap_12
X_08019_ _00750_ _00755_ VGND VGND VPWR VPWR _00756_ sky130_fd_sc_hd__nand2b_1
XTAP_TAPCELL_ROW_75_1339 VGND VPWR sky130_fd_sc_hd__tapvpwrvgnd_1
XTAP_TAPCELL_ROW_9_424 VGND VPWR sky130_fd_sc_hd__tapvpwrvgnd_1
XFILLER_131_561 VPWR VGND VPWR VGND sky130_ef_sc_hd__decap_12
XFILLER_77_604 VGND VGND VPWR VPWR sky130_fd_sc_hd__fill_1
XFILLER_1_335 VGND VGND VPWR VPWR sky130_fd_sc_hd__fill_1
XFILLER_1_357 VGND VGND VPWR VPWR sky130_fd_sc_hd__decap_3
X_11030_ _03761_ _03774_ _03772_ VGND VGND VPWR VPWR _03908_ sky130_fd_sc_hd__o21ai_1
XFILLER_134_53 VPWR VGND VPWR VGND sky130_ef_sc_hd__decap_12
XFILLER_89_497 VGND VGND VPWR VPWR sky130_fd_sc_hd__decap_6
XFILLER_76_114 VGND VGND VPWR VPWR sky130_fd_sc_hd__decap_8
XFILLER_134_97 VPWR VGND VPWR VGND sky130_ef_sc_hd__decap_12
XFILLER_17_203 VGND VGND VPWR VPWR sky130_fd_sc_hd__decap_8
X_12981_ _06005_ _06034_ VGND VGND VPWR VPWR _06035_ sky130_fd_sc_hd__xor2_1
X_11932_ net529 net662 VGND VGND VPWR VPWR _04889_ sky130_fd_sc_hd__nand2_1
XFILLER_27_51 VGND VGND VPWR VPWR sky130_fd_sc_hd__fill_1
X_11863_ _04736_ net717 _04813_ VGND VGND VPWR VPWR _04814_ sky130_fd_sc_hd__nor3_4
XFILLER_60_515 VPWR VGND VPWR VGND sky130_ef_sc_hd__decap_12
X_10814_ _03564_ _03669_ _03671_ VGND VGND VPWR VPWR _03672_ sky130_fd_sc_hd__and3_1
X_11794_ net463 net587 VGND VGND VPWR VPWR _04738_ sky130_fd_sc_hd__nand2_1
X_10745_ _03595_ _03594_ VGND VGND VPWR VPWR _03596_ sky130_fd_sc_hd__nand2b_1
X_10676_ net663 net273 _02230_ net686 VGND VGND VPWR VPWR _03520_ sky130_fd_sc_hd__o2bb2a_1
X_13395_ clknet_3_1__leaf_clk _00024_ _00105_ VGND VGND VPWR VPWR net209 sky130_fd_sc_hd__dfrtp_1
X_12415_ _05412_ _05413_ _05414_ VGND VGND VPWR VPWR _05416_ sky130_fd_sc_hd__a21o_1
XFILLER_5_641 VPWR VGND VPWR VGND sky130_ef_sc_hd__decap_12
X_12346_ net542 net301 net299 VGND VGND VPWR VPWR _05340_ sky130_fd_sc_hd__and3_1
XTAP_TAPCELL_ROW_130_2112 VGND VPWR sky130_fd_sc_hd__tapvpwrvgnd_1
Xoutput209 net209 VGND VGND VPWR VPWR out2[9] sky130_fd_sc_hd__buf_2
XFILLER_5_685 VPWR VGND VPWR VGND sky130_ef_sc_hd__decap_12
X_12277_ net657 _05264_ VGND VGND VPWR VPWR _05266_ sky130_fd_sc_hd__xnor2_1
XFILLER_110_701 VPWR VGND VPWR VGND sky130_ef_sc_hd__decap_12
XFILLER_4_195 VGND VGND VPWR VPWR sky130_fd_sc_hd__fill_1
XFILLER_4_77 VGND VGND VPWR VPWR sky130_fd_sc_hd__decap_6
X_11228_ _04122_ _04124_ VGND VGND VPWR VPWR _04125_ sky130_fd_sc_hd__nor2_1
XFILLER_122_561 VGND VGND VPWR VPWR sky130_fd_sc_hd__decap_8
X_11159_ _03911_ _03913_ _03910_ VGND VGND VPWR VPWR _04049_ sky130_fd_sc_hd__a21oi_1
XTAP_TAPCELL_ROW_128_2085 VGND VPWR sky130_fd_sc_hd__tapvpwrvgnd_1
XFILLER_67_169 VGND VGND VPWR VPWR sky130_fd_sc_hd__decap_8
XFILLER_36_512 VPWR VGND VPWR VGND sky130_ef_sc_hd__decap_12
XFILLER_82_139 VGND VGND VPWR VPWR sky130_fd_sc_hd__fill_1
XFILLER_48_394 VPWR VGND VPWR VGND sky130_ef_sc_hd__decap_12
XFILLER_36_545 VPWR VGND VPWR VGND sky130_ef_sc_hd__decap_12
XFILLER_91_673 VGND VGND VPWR VPWR sky130_fd_sc_hd__decap_3
XFILLER_24_707 VGND VGND VPWR VPWR sky130_fd_sc_hd__fill_1
XFILLER_90_172 VGND VGND VPWR VPWR sky130_fd_sc_hd__fill_1
X_08370_ _01087_ _01100_ VGND VGND VPWR VPWR _01101_ sky130_fd_sc_hd__nand2_1
XFILLER_51_515 VGND VGND VPWR VPWR sky130_fd_sc_hd__fill_2
XFILLER_36_589 VGND VGND VPWR VPWR sky130_fd_sc_hd__decap_4
X_07321_ net767 net384 _06609_ _06610_ VGND VGND VPWR VPWR _06612_ sky130_fd_sc_hd__nand4_1
XTAP_TAPCELL_ROW_34_768 VGND VPWR sky130_fd_sc_hd__tapvpwrvgnd_1
Xclkbuf_3_2__f_clk clknet_0_clk VGND VGND VPWR VPWR clknet_3_2__leaf_clk sky130_fd_sc_hd__clkbuf_16
X_07252_ _06541_ _06542_ VGND VGND VPWR VPWR _06543_ sky130_fd_sc_hd__nand2_1
XTAP_TAPCELL_ROW_14_492 VGND VPWR sky130_fd_sc_hd__tapvpwrvgnd_1
XFILLER_117_300 VGND VGND VPWR VPWR sky130_fd_sc_hd__decap_6
X_07183_ _06472_ _06473_ _06474_ VGND VGND VPWR VPWR _06475_ sky130_fd_sc_hd__nand3_1
XTAP_TAPCELL_ROW_115_1907 VGND VPWR sky130_fd_sc_hd__tapvpwrvgnd_1
XFILLER_105_517 VPWR VGND VPWR VGND sky130_ef_sc_hd__decap_12
XFILLER_117_388 VGND VGND VPWR VPWR sky130_fd_sc_hd__decap_4
XFILLER_105_539 VGND VGND VPWR VPWR sky130_fd_sc_hd__fill_1
XFILLER_120_509 VPWR VGND VPWR VGND sky130_ef_sc_hd__decap_12
XFILLER_113_550 VGND VGND VPWR VPWR sky130_fd_sc_hd__fill_2
XFILLER_99_751 VGND VGND VPWR VPWR sky130_fd_sc_hd__decap_8
Xfanout414 net415 VGND VGND VPWR VPWR net414 sky130_fd_sc_hd__buf_2
Xfanout403 net32 VGND VGND VPWR VPWR net403 sky130_fd_sc_hd__buf_2
XFILLER_113_561 VGND VGND VPWR VPWR sky130_fd_sc_hd__fill_1
X_09824_ _02591_ _02595_ VGND VGND VPWR VPWR _02596_ sky130_fd_sc_hd__nand2_1
XPHY_EDGE_ROW_92_Left_229 VGND VGND VPWR VPWR sky130_fd_sc_hd__decap_3
Xfanout447 net449 VGND VGND VPWR VPWR net447 sky130_fd_sc_hd__clkbuf_4
Xfanout436 net441 VGND VGND VPWR VPWR net436 sky130_fd_sc_hd__clkbuf_2
Xfanout425 net432 VGND VGND VPWR VPWR net425 sky130_fd_sc_hd__clkbuf_4
XFILLER_101_745 VGND VGND VPWR VPWR sky130_fd_sc_hd__fill_1
Xfanout469 net470 VGND VGND VPWR VPWR net469 sky130_fd_sc_hd__buf_2
XTAP_TAPCELL_ROW_70_1269 VGND VPWR sky130_fd_sc_hd__tapvpwrvgnd_1
Xfanout458 net26 VGND VGND VPWR VPWR net458 sky130_fd_sc_hd__buf_2
XFILLER_59_659 VGND VGND VPWR VPWR sky130_fd_sc_hd__decap_8
X_06967_ _05144_ _05155_ VGND VGND VPWR VPWR _05166_ sky130_fd_sc_hd__nand2_1
X_09755_ _02512_ _02518_ VGND VGND VPWR VPWR _02520_ sky130_fd_sc_hd__xnor2_1
XFILLER_46_309 VPWR VGND VPWR VGND sky130_ef_sc_hd__decap_12
XFILLER_100_288 VGND VGND VPWR VPWR sky130_fd_sc_hd__decap_3
X_09686_ _02319_ _02320_ _02354_ VGND VGND VPWR VPWR _02445_ sky130_fd_sc_hd__o21a_1
X_08706_ _01291_ _01288_ net241 _01433_ VGND VGND VPWR VPWR _01434_ sky130_fd_sc_hd__a211oi_4
X_06898_ _04330_ _04341_ _04407_ VGND VGND VPWR VPWR _04417_ sky130_fd_sc_hd__nand3_2
XFILLER_64_27 VGND VGND VPWR VPWR sky130_fd_sc_hd__fill_1
X_08637_ _01201_ _01203_ _01363_ VGND VGND VPWR VPWR _01365_ sky130_fd_sc_hd__and3_1
XFILLER_54_342 VGND VGND VPWR VPWR sky130_fd_sc_hd__fill_2
XFILLER_15_718 VGND VGND VPWR VPWR sky130_fd_sc_hd__decap_8
XFILLER_27_556 VGND VGND VPWR VPWR sky130_fd_sc_hd__decap_4
XFILLER_14_228 VPWR VGND VPWR VGND sky130_ef_sc_hd__decap_12
XFILLER_15_729 VGND VGND VPWR VPWR sky130_fd_sc_hd__decap_3
XTAP_TAPCELL_ROW_85_1490 VGND VPWR sky130_fd_sc_hd__tapvpwrvgnd_1
X_08568_ _01248_ _01296_ VGND VGND VPWR VPWR _01297_ sky130_fd_sc_hd__or2_1
XFILLER_120_77 VGND VGND VPWR VPWR sky130_fd_sc_hd__decap_6
X_08499_ net523 net122 _01088_ _01109_ _01171_ VGND VGND VPWR VPWR _01228_ sky130_fd_sc_hd__a2111o_1
X_07519_ _00256_ _00258_ _00199_ VGND VGND VPWR VPWR _00260_ sky130_fd_sc_hd__a21oi_1
XFILLER_80_48 VGND VGND VPWR VPWR sky130_fd_sc_hd__decap_3
XFILLER_50_570 VGND VGND VPWR VPWR sky130_fd_sc_hd__fill_1
XFILLER_10_401 VGND VGND VPWR VPWR sky130_fd_sc_hd__decap_8
X_10530_ _03359_ _03360_ VGND VGND VPWR VPWR _03361_ sky130_fd_sc_hd__nand2_1
XFILLER_13_31 VGND VGND VPWR VPWR sky130_fd_sc_hd__fill_1
X_10461_ net425 net375 net349 net347 VGND VGND VPWR VPWR _03286_ sky130_fd_sc_hd__and4_1
XFILLER_108_344 VGND VGND VPWR VPWR sky130_fd_sc_hd__decap_6
X_12200_ _05136_ _05179_ VGND VGND VPWR VPWR _05181_ sky130_fd_sc_hd__xnor2_1
XFILLER_136_664 VGND VGND VPWR VPWR sky130_fd_sc_hd__decap_4
XFILLER_89_57 VGND VGND VPWR VPWR sky130_fd_sc_hd__fill_1
X_10392_ net639 net279 _03069_ _03068_ VGND VGND VPWR VPWR _03211_ sky130_fd_sc_hd__a31o_1
X_13180_ _05389_ _06251_ VGND VGND VPWR VPWR _06252_ sky130_fd_sc_hd__xnor2_1
XFILLER_123_325 VGND VGND VPWR VPWR sky130_fd_sc_hd__fill_1
XFILLER_89_79 VGND VGND VPWR VPWR sky130_fd_sc_hd__fill_1
X_12131_ _04955_ _04952_ _05104_ _05105_ VGND VGND VPWR VPWR _05106_ sky130_fd_sc_hd__a211o_1
X_12062_ net499 net673 VGND VGND VPWR VPWR _05031_ sky130_fd_sc_hd__nand2_1
XFILLER_77_412 VGND VGND VPWR VPWR sky130_fd_sc_hd__fill_2
XFILLER_2_699 VGND VGND VPWR VPWR sky130_fd_sc_hd__fill_1
X_11013_ _03541_ _03546_ VGND VGND VPWR VPWR _03889_ sky130_fd_sc_hd__nor2_2
XFILLER_18_501 VPWR VGND VPWR VGND sky130_ef_sc_hd__decap_12
XFILLER_92_426 VGND VGND VPWR VPWR sky130_fd_sc_hd__decap_3
X_12964_ _05388_ _05926_ net440 _05386_ VGND VGND VPWR VPWR _06016_ sky130_fd_sc_hd__o2bb2a_1
XFILLER_38_83 VGND VGND VPWR VPWR sky130_fd_sc_hd__fill_1
X_11915_ _04868_ _04869_ VGND VGND VPWR VPWR _04870_ sky130_fd_sc_hd__xnor2_1
XFILLER_73_673 VGND VGND VPWR VPWR sky130_fd_sc_hd__decap_4
XFILLER_45_375 VPWR VGND VPWR VGND sky130_ef_sc_hd__decap_12
XFILLER_18_589 VPWR VGND VPWR VGND sky130_ef_sc_hd__decap_12
X_12895_ _05939_ _05940_ VGND VGND VPWR VPWR _05941_ sky130_fd_sc_hd__nor2_1
X_11846_ net739 _04793_ _04792_ VGND VGND VPWR VPWR _04795_ sky130_fd_sc_hd__nand3_2
XFILLER_54_82 VGND VGND VPWR VPWR sky130_fd_sc_hd__fill_2
XFILLER_60_389 VPWR VGND VPWR VGND sky130_ef_sc_hd__decap_12
X_11777_ _04667_ _04718_ VGND VGND VPWR VPWR _04720_ sky130_fd_sc_hd__and2_1
XFILLER_9_243 VPWR VGND VPWR VGND sky130_ef_sc_hd__decap_12
XFILLER_9_221 VGND VGND VPWR VPWR sky130_fd_sc_hd__decap_3
XTAP_TAPCELL_ROW_31_727 VGND VPWR sky130_fd_sc_hd__tapvpwrvgnd_1
X_10728_ _03575_ _03577_ VGND VGND VPWR VPWR _03578_ sky130_fd_sc_hd__xnor2_1
XFILLER_127_620 VPWR VGND VPWR VGND sky130_ef_sc_hd__decap_12
X_10659_ _03499_ _03501_ VGND VGND VPWR VPWR _03503_ sky130_fd_sc_hd__xor2_1
XTAP_TAPCELL_ROW_11_451 VGND VPWR sky130_fd_sc_hd__tapvpwrvgnd_1
X_13378_ clknet_3_4__leaf_clk _00036_ _00088_ VGND VGND VPWR VPWR net192 sky130_fd_sc_hd__dfrtp_1
XFILLER_127_697 VPWR VGND VPWR VGND sky130_ef_sc_hd__decap_12
X_12329_ net592 net296 net294 net617 VGND VGND VPWR VPWR _05322_ sky130_fd_sc_hd__a22o_1
XFILLER_102_509 VGND VGND VPWR VPWR sky130_fd_sc_hd__fill_1
XFILLER_87_209 VPWR VGND VPWR VGND sky130_ef_sc_hd__decap_12
XTAP_TAPCELL_ROW_110_1837 VGND VPWR sky130_fd_sc_hd__tapvpwrvgnd_1
XTAP_TAPCELL_ROW_56_1080 VGND VPWR sky130_fd_sc_hd__tapvpwrvgnd_1
X_07870_ _00606_ _00607_ VGND VGND VPWR VPWR _00608_ sky130_fd_sc_hd__or2_1
X_06821_ _03042_ _03074_ _03521_ VGND VGND VPWR VPWR _03576_ sky130_fd_sc_hd__nor3_1
XFILLER_28_309 VGND VGND VPWR VPWR sky130_fd_sc_hd__decap_8
XFILLER_110_597 VGND VGND VPWR VPWR sky130_fd_sc_hd__fill_2
X_06752_ _02791_ _02802_ VGND VGND VPWR VPWR _02823_ sky130_fd_sc_hd__xnor2_1
X_09540_ _02286_ _02287_ VGND VGND VPWR VPWR _02288_ sky130_fd_sc_hd__or2_1
XTAP_TAPCELL_ROW_39_838 VGND VPWR sky130_fd_sc_hd__tapvpwrvgnd_1
X_09471_ _02211_ _02210_ VGND VGND VPWR VPWR _02213_ sky130_fd_sc_hd__nand2b_1
XFILLER_64_651 VGND VGND VPWR VPWR sky130_fd_sc_hd__fill_1
X_08422_ _01151_ VGND VGND VPWR VPWR _01152_ sky130_fd_sc_hd__inv_2
XFILLER_64_684 VPWR VGND VPWR VGND sky130_ef_sc_hd__decap_12
XFILLER_51_301 VGND VGND VPWR VPWR sky130_fd_sc_hd__fill_1
XTAP_TAPCELL_ROW_19_562 VGND VPWR sky130_fd_sc_hd__tapvpwrvgnd_1
XFILLER_24_504 VPWR VGND VPWR VGND sky130_ef_sc_hd__decap_12
X_06683_ net638 VGND VGND VPWR VPWR _02077_ sky130_fd_sc_hd__inv_4
X_08353_ net699 net341 net557 net473 VGND VGND VPWR VPWR _01085_ sky130_fd_sc_hd__a22o_1
XTAP_TAPCELL_ROW_121_1988 VGND VPWR sky130_fd_sc_hd__tapvpwrvgnd_1
X_08284_ _00889_ _00923_ _00888_ VGND VGND VPWR VPWR _01019_ sky130_fd_sc_hd__a21oi_1
X_07304_ net514 net427 net382 net40 VGND VGND VPWR VPWR _06595_ sky130_fd_sc_hd__nand4_1
X_07235_ _06374_ _06377_ _06525_ VGND VGND VPWR VPWR _06526_ sky130_fd_sc_hd__a21o_1
XFILLER_50_29 VGND VGND VPWR VPWR sky130_fd_sc_hd__fill_1
XFILLER_20_754 VGND VGND VPWR VPWR sky130_fd_sc_hd__fill_2
XFILLER_118_620 VPWR VGND VPWR VGND sky130_ef_sc_hd__decap_12
X_07166_ _06453_ _06456_ VGND VGND VPWR VPWR _06458_ sky130_fd_sc_hd__xnor2_1
X_07097_ net319 net643 _05188_ _05177_ VGND VGND VPWR VPWR _06389_ sky130_fd_sc_hd__a31o_1
XFILLER_105_314 VPWR VGND VPWR VGND sky130_ef_sc_hd__decap_12
XFILLER_132_133 VGND VGND VPWR VPWR sky130_fd_sc_hd__decap_6
XFILLER_105_369 VGND VGND VPWR VPWR sky130_fd_sc_hd__decap_4
XTAP_TAPCELL_ROW_72_1309 VGND VPWR sky130_fd_sc_hd__tapvpwrvgnd_1
XFILLER_87_710 VGND VGND VPWR VPWR sky130_fd_sc_hd__decap_6
Xfanout255 net95 VGND VGND VPWR VPWR net255 sky130_fd_sc_hd__buf_2
XFILLER_86_220 VPWR VGND VPWR VGND sky130_ef_sc_hd__decap_12
X_09807_ _02242_ _02454_ _02456_ VGND VGND VPWR VPWR _02578_ sky130_fd_sc_hd__a21boi_2
XFILLER_86_253 VPWR VGND VPWR VGND sky130_ef_sc_hd__decap_12
X_07999_ net410 net602 _00735_ VGND VGND VPWR VPWR _00736_ sky130_fd_sc_hd__a21o_1
Xfanout288 net289 VGND VGND VPWR VPWR net288 sky130_fd_sc_hd__buf_6
Xfanout299 net75 VGND VGND VPWR VPWR net299 sky130_fd_sc_hd__buf_2
Xfanout266 net268 VGND VGND VPWR VPWR net266 sky130_fd_sc_hd__buf_2
Xfanout277 net85 VGND VGND VPWR VPWR net277 sky130_fd_sc_hd__buf_2
XFILLER_28_810 VGND VGND VPWR VPWR sky130_fd_sc_hd__fill_1
X_09738_ _01917_ _02078_ _02500_ _01915_ VGND VGND VPWR VPWR _02503_ sky130_fd_sc_hd__and4b_1
XFILLER_27_353 VGND VGND VPWR VPWR sky130_fd_sc_hd__decap_4
XFILLER_39_191 VPWR VGND VPWR VGND sky130_ef_sc_hd__decap_12
X_09669_ _02419_ _02426_ VGND VGND VPWR VPWR _02427_ sky130_fd_sc_hd__xnor2_1
XFILLER_42_312 VGND VGND VPWR VPWR sky130_fd_sc_hd__decap_4
X_11700_ net524 net676 VGND VGND VPWR VPWR _04636_ sky130_fd_sc_hd__nand2_1
X_12680_ _05666_ _05705_ VGND VGND VPWR VPWR _05706_ sky130_fd_sc_hd__nand2b_1
XFILLER_42_323 VGND VGND VPWR VPWR sky130_fd_sc_hd__fill_1
XFILLER_91_69 VGND VGND VPWR VPWR sky130_fd_sc_hd__decap_3
X_11631_ _04440_ _04441_ _04465_ VGND VGND VPWR VPWR _04564_ sky130_fd_sc_hd__o21a_1
X_11562_ _04482_ _04487_ VGND VGND VPWR VPWR _04489_ sky130_fd_sc_hd__or2_1
XFILLER_24_85 VGND VGND VPWR VPWR sky130_fd_sc_hd__decap_6
X_13301_ net394 VGND VGND VPWR VPWR _00075_ sky130_fd_sc_hd__inv_2
X_10513_ _03340_ _03341_ VGND VGND VPWR VPWR _03342_ sky130_fd_sc_hd__xnor2_1
XFILLER_11_765 VPWR VGND VPWR VGND sky130_ef_sc_hd__decap_12
XFILLER_24_96 VGND VGND VPWR VPWR sky130_fd_sc_hd__fill_2
X_11493_ _04413_ VGND VGND VPWR VPWR _04414_ sky130_fd_sc_hd__inv_2
XFILLER_136_461 VPWR VGND VPWR VGND sky130_ef_sc_hd__decap_12
XFILLER_108_130 VGND VGND VPWR VPWR sky130_fd_sc_hd__decap_3
XTAP_TAPCELL_ROW_98_1670 VGND VPWR sky130_fd_sc_hd__tapvpwrvgnd_1
X_10444_ _03264_ _03265_ _03262_ VGND VGND VPWR VPWR _03267_ sky130_fd_sc_hd__o21ai_1
X_13232_ _06304_ _06308_ VGND VGND VPWR VPWR _06309_ sky130_fd_sc_hd__xor2_1
XFILLER_109_686 VGND VGND VPWR VPWR sky130_fd_sc_hd__decap_8
X_10375_ _03190_ _03191_ VGND VGND VPWR VPWR _03192_ sky130_fd_sc_hd__xnor2_1
X_13163_ _06230_ _06231_ VGND VGND VPWR VPWR _06233_ sky130_fd_sc_hd__xor2_1
X_12114_ _05085_ _05086_ VGND VGND VPWR VPWR _05087_ sky130_fd_sc_hd__and2b_1
X_13094_ _06130_ _06157_ VGND VGND VPWR VPWR _06158_ sky130_fd_sc_hd__nor2_1
XFILLER_78_743 VGND VGND VPWR VPWR sky130_fd_sc_hd__fill_1
X_12045_ _05009_ _05010_ VGND VGND VPWR VPWR _05012_ sky130_fd_sc_hd__xor2_1
XFILLER_93_713 VPWR VGND VPWR VGND sky130_ef_sc_hd__decap_12
XFILLER_78_776 VGND VGND VPWR VPWR sky130_fd_sc_hd__decap_3
XFILLER_65_437 VGND VGND VPWR VPWR sky130_fd_sc_hd__fill_1
XFILLER_37_139 VGND VGND VPWR VPWR sky130_fd_sc_hd__fill_2
XTAP_TAPCELL_ROW_125_2044 VGND VPWR sky130_fd_sc_hd__tapvpwrvgnd_1
XFILLER_93_779 VGND VGND VPWR VPWR sky130_fd_sc_hd__decap_4
XFILLER_73_470 VGND VGND VPWR VPWR sky130_fd_sc_hd__decap_8
XFILLER_46_673 VGND VGND VPWR VPWR sky130_fd_sc_hd__fill_1
X_12947_ _05990_ _05996_ VGND VGND VPWR VPWR _05998_ sky130_fd_sc_hd__nand2b_1
XTAP_TAPCELL_ROW_16_521 VGND VPWR sky130_fd_sc_hd__tapvpwrvgnd_1
XFILLER_18_397 VGND VGND VPWR VPWR sky130_fd_sc_hd__fill_1
X_12878_ net449 _05386_ _05388_ _05730_ VGND VGND VPWR VPWR _05923_ sky130_fd_sc_hd__a2bb2o_1
X_11829_ _04769_ _04768_ _04775_ VGND VGND VPWR VPWR _04777_ sky130_fd_sc_hd__a21o_1
XFILLER_21_529 VPWR VGND VPWR VGND sky130_ef_sc_hd__decap_12
XFILLER_33_389 VGND VGND VPWR VPWR sky130_fd_sc_hd__decap_3
XPHY_EDGE_ROW_112_Right_112 VGND VGND VPWR VPWR sky130_fd_sc_hd__decap_3
XTAP_TAPCELL_ROW_136_2195 VGND VPWR sky130_fd_sc_hd__tapvpwrvgnd_1
XFILLER_127_461 VPWR VGND VPWR VGND sky130_ef_sc_hd__decap_12
X_07020_ _05702_ _05713_ _05724_ VGND VGND VPWR VPWR _05746_ sky130_fd_sc_hd__a21oi_1
XFILLER_115_612 VGND VGND VPWR VPWR sky130_fd_sc_hd__decap_4
XPHY_EDGE_ROW_49_Right_49 VGND VGND VPWR VPWR sky130_fd_sc_hd__decap_3
XFILLER_88_529 VGND VGND VPWR VPWR sky130_fd_sc_hd__decap_3
X_08971_ net517 net63 _01548_ _01547_ VGND VGND VPWR VPWR _01697_ sky130_fd_sc_hd__a31o_1
XFILLER_130_637 VGND VGND VPWR VPWR sky130_fd_sc_hd__decap_6
X_07922_ net490 net679 net483 net678 VGND VGND VPWR VPWR _00660_ sky130_fd_sc_hd__and4_1
X_07853_ _00588_ _00590_ VGND VGND VPWR VPWR _00591_ sky130_fd_sc_hd__nor2_1
XFILLER_68_253 VPWR VGND VPWR VGND sky130_ef_sc_hd__decap_12
X_06804_ net323 net321 net619 net643 VGND VGND VPWR VPWR _03390_ sky130_fd_sc_hd__and4_1
XFILLER_83_212 VPWR VGND VPWR VGND sky130_ef_sc_hd__decap_12
XFILLER_84_768 VGND VGND VPWR VPWR sky130_fd_sc_hd__fill_1
X_07784_ _00521_ _00522_ VGND VGND VPWR VPWR _00523_ sky130_fd_sc_hd__nor2_1
XPHY_EDGE_ROW_58_Right_58 VGND VGND VPWR VPWR sky130_fd_sc_hd__decap_3
X_06735_ _02349_ _02621_ VGND VGND VPWR VPWR _02642_ sky130_fd_sc_hd__xor2_1
X_09523_ _02263_ _02267_ VGND VGND VPWR VPWR _02269_ sky130_fd_sc_hd__xnor2_1
XTAP_TAPCELL_ROW_69_1260 VGND VPWR sky130_fd_sc_hd__tapvpwrvgnd_1
XFILLER_37_673 VGND VGND VPWR VPWR sky130_fd_sc_hd__decap_4
X_09454_ net414 net550 net548 net422 VGND VGND VPWR VPWR _02194_ sky130_fd_sc_hd__a22oi_1
XFILLER_52_643 VGND VGND VPWR VPWR sky130_fd_sc_hd__fill_1
X_09385_ _02107_ _02117_ VGND VGND VPWR VPWR _02118_ sky130_fd_sc_hd__xnor2_1
XFILLER_101_57 VPWR VGND VPWR VGND sky130_ef_sc_hd__decap_12
X_08405_ net473 net464 net556 net553 VGND VGND VPWR VPWR _01135_ sky130_fd_sc_hd__and4_1
XFILLER_52_665 VPWR VGND VPWR VGND sky130_ef_sc_hd__decap_12
X_08336_ _01067_ _01069_ VGND VGND VPWR VPWR _01070_ sky130_fd_sc_hd__xnor2_1
XFILLER_61_28 VGND VGND VPWR VPWR sky130_fd_sc_hd__decap_6
X_08267_ net249 _01000_ VGND VGND VPWR VPWR _01002_ sky130_fd_sc_hd__nand2_1
X_07218_ _06507_ _06508_ VGND VGND VPWR VPWR _06509_ sky130_fd_sc_hd__nand2b_1
X_08198_ _00932_ _00933_ VGND VGND VPWR VPWR _00934_ sky130_fd_sc_hd__nor2_1
XFILLER_106_601 VGND VGND VPWR VPWR sky130_fd_sc_hd__decap_4
XPHY_EDGE_ROW_67_Right_67 VGND VGND VPWR VPWR sky130_fd_sc_hd__decap_3
XFILLER_106_623 VPWR VGND VPWR VGND sky130_ef_sc_hd__decap_12
X_07149_ net610 net436 net419 net611 VGND VGND VPWR VPWR _06441_ sky130_fd_sc_hd__a22oi_2
XFILLER_3_205 VPWR VGND VPWR VGND sky130_ef_sc_hd__decap_12
XFILLER_3_249 VPWR VGND VPWR VGND sky130_ef_sc_hd__decap_12
XFILLER_106_678 VPWR VGND VPWR VGND sky130_ef_sc_hd__decap_12
X_10160_ _02944_ _02956_ VGND VGND VPWR VPWR _02958_ sky130_fd_sc_hd__xnor2_1
XFILLER_133_497 VGND VGND VPWR VPWR sky130_fd_sc_hd__decap_6
XFILLER_126_65 VPWR VGND VPWR VGND sky130_ef_sc_hd__decap_12
X_10091_ _02848_ _02881_ VGND VGND VPWR VPWR _02882_ sky130_fd_sc_hd__nand2b_1
XFILLER_59_242 VGND VGND VPWR VPWR sky130_fd_sc_hd__decap_8
XPHY_EDGE_ROW_76_Right_76 VGND VGND VPWR VPWR sky130_fd_sc_hd__decap_3
XFILLER_47_437 VGND VGND VPWR VPWR sky130_fd_sc_hd__fill_2
XFILLER_19_63 VPWR VGND VPWR VGND sky130_ef_sc_hd__decap_12
XFILLER_75_779 VGND VGND VPWR VPWR sky130_fd_sc_hd__decap_4
X_12801_ _05836_ _05837_ VGND VGND VPWR VPWR _05838_ sky130_fd_sc_hd__and2_1
X_10993_ _03743_ _03778_ _03777_ VGND VGND VPWR VPWR _03867_ sky130_fd_sc_hd__a21oi_1
XFILLER_15_312 VGND VGND VPWR VPWR sky130_fd_sc_hd__fill_1
XFILLER_15_334 VGND VGND VPWR VPWR sky130_fd_sc_hd__fill_2
X_12732_ _05226_ _05761_ VGND VGND VPWR VPWR _05763_ sky130_fd_sc_hd__xnor2_1
XFILLER_70_451 VGND VGND VPWR VPWR sky130_fd_sc_hd__decap_3
XFILLER_35_95 VGND VGND VPWR VPWR sky130_fd_sc_hd__decap_4
X_12663_ _05550_ _05559_ _05558_ VGND VGND VPWR VPWR _05687_ sky130_fd_sc_hd__a21o_1
XFILLER_42_197 VGND VGND VPWR VPWR sky130_fd_sc_hd__fill_1
X_11614_ _04453_ _04454_ _04448_ _04452_ VGND VGND VPWR VPWR _04545_ sky130_fd_sc_hd__a2bb2o_1
XFILLER_11_540 VGND VGND VPWR VPWR sky130_fd_sc_hd__decap_6
XFILLER_7_500 VGND VGND VPWR VPWR sky130_fd_sc_hd__decap_4
X_12594_ _05608_ _05610_ _05611_ VGND VGND VPWR VPWR _05612_ sky130_fd_sc_hd__nor3_1
XTAP_TAPCELL_ROW_41_866 VGND VPWR sky130_fd_sc_hd__tapvpwrvgnd_1
XPHY_EDGE_ROW_85_Right_85 VGND VGND VPWR VPWR sky130_fd_sc_hd__decap_3
X_11545_ _04468_ _04469_ VGND VGND VPWR VPWR _04470_ sky130_fd_sc_hd__nor2_1
X_11476_ _04394_ _04362_ VGND VGND VPWR VPWR _04395_ sky130_fd_sc_hd__and2b_1
XTAP_TAPCELL_ROW_21_590 VGND VPWR sky130_fd_sc_hd__tapvpwrvgnd_1
XFILLER_109_461 VPWR VGND VPWR VGND sky130_ef_sc_hd__decap_12
X_10427_ _03240_ _03247_ VGND VGND VPWR VPWR _03249_ sky130_fd_sc_hd__nand2_1
X_13215_ _06282_ _06288_ VGND VGND VPWR VPWR _06290_ sky130_fd_sc_hd__xnor2_1
XFILLER_124_475 VGND VGND VPWR VPWR sky130_fd_sc_hd__fill_1
XFILLER_112_615 VGND VGND VPWR VPWR sky130_fd_sc_hd__decap_8
X_10358_ _03057_ _03171_ _03172_ VGND VGND VPWR VPWR _03175_ sky130_fd_sc_hd__or3_4
X_13146_ _06082_ _06084_ _06214_ VGND VGND VPWR VPWR _06215_ sky130_fd_sc_hd__a21o_1
XFILLER_111_125 VPWR VGND VPWR VGND sky130_ef_sc_hd__decap_12
X_10289_ _03088_ _03098_ VGND VGND VPWR VPWR _03099_ sky130_fd_sc_hd__xnor2_1
XFILLER_3_783 VGND VGND VPWR VPWR sky130_fd_sc_hd__fill_1
X_13077_ net421 _05386_ _05388_ _06018_ VGND VGND VPWR VPWR _06140_ sky130_fd_sc_hd__a2bb2o_1
XPHY_EDGE_ROW_94_Right_94 VGND VGND VPWR VPWR sky130_fd_sc_hd__decap_3
XFILLER_78_551 VGND VGND VPWR VPWR sky130_fd_sc_hd__decap_8
X_12028_ _04993_ _04991_ VGND VGND VPWR VPWR _04994_ sky130_fd_sc_hd__nand2b_1
XFILLER_38_437 VGND VGND VPWR VPWR sky130_fd_sc_hd__fill_1
XFILLER_66_757 VGND VGND VPWR VPWR sky130_fd_sc_hd__fill_2
XFILLER_19_651 VPWR VGND VPWR VGND sky130_ef_sc_hd__decap_12
XFILLER_81_738 VPWR VGND VPWR VGND sky130_ef_sc_hd__decap_12
XTAP_TAPCELL_ROW_49_977 VGND VPWR sky130_fd_sc_hd__tapvpwrvgnd_1
XFILLER_19_673 VGND VGND VPWR VPWR sky130_fd_sc_hd__decap_6
XFILLER_34_610 VGND VGND VPWR VPWR sky130_fd_sc_hd__decap_8
XFILLER_34_632 VPWR VGND VPWR VGND sky130_ef_sc_hd__decap_12
XTAP_TAPCELL_ROW_105_1769 VGND VPWR sky130_fd_sc_hd__tapvpwrvgnd_1
XTAP_TAPCELL_ROW_105_1758 VGND VPWR sky130_fd_sc_hd__tapvpwrvgnd_1
X_09170_ _01837_ _01892_ _01894_ VGND VGND VPWR VPWR _01895_ sky130_fd_sc_hd__and3_4
XTAP_TAPCELL_ROW_64_1190 VGND VPWR sky130_fd_sc_hd__tapvpwrvgnd_1
XFILLER_119_225 VPWR VGND VPWR VGND sky130_ef_sc_hd__decap_12
X_08121_ _00846_ _00856_ VGND VGND VPWR VPWR _00857_ sky130_fd_sc_hd__xor2_2
X_08052_ _00586_ _00592_ _00788_ VGND VGND VPWR VPWR _00789_ sky130_fd_sc_hd__a21o_1
XFILLER_135_729 VPWR VGND VPWR VGND sky130_ef_sc_hd__decap_12
XFILLER_128_781 VPWR VGND VPWR VGND sky130_ef_sc_hd__decap_12
X_07003_ _05527_ _05538_ VGND VGND VPWR VPWR _05560_ sky130_fd_sc_hd__xor2_1
XFILLER_1_709 VPWR VGND VPWR VGND sky130_ef_sc_hd__decap_12
XFILLER_103_615 VGND VGND VPWR VPWR sky130_fd_sc_hd__fill_1
XFILLER_130_445 VPWR VGND VPWR VGND sky130_ef_sc_hd__decap_12
X_08954_ _01678_ _01679_ VGND VGND VPWR VPWR _01680_ sky130_fd_sc_hd__nor2_1
Xinput109 w21[3] VGND VGND VPWR VPWR net109 sky130_fd_sc_hd__buf_1
X_07905_ _00367_ _00543_ VGND VGND VPWR VPWR _00643_ sky130_fd_sc_hd__nand2_1
XFILLER_130_489 VPWR VGND VPWR VGND sky130_ef_sc_hd__decap_12
X_08885_ _01610_ _01609_ VGND VGND VPWR VPWR _01611_ sky130_fd_sc_hd__nand2b_1
X_07836_ _00572_ net721 VGND VGND VPWR VPWR _00039_ sky130_fd_sc_hd__xnor2_1
X_07767_ _00477_ _00504_ VGND VGND VPWR VPWR _00506_ sky130_fd_sc_hd__xnor2_1
XFILLER_44_418 VGND VGND VPWR VPWR sky130_fd_sc_hd__fill_2
X_09506_ net621 net596 net253 net97 VGND VGND VPWR VPWR _02250_ sky130_fd_sc_hd__and4b_1
X_06718_ net613 net460 _02413_ _02435_ VGND VGND VPWR VPWR _02457_ sky130_fd_sc_hd__a22oi_1
XFILLER_72_749 VGND VGND VPWR VPWR sky130_fd_sc_hd__decap_6
XFILLER_71_237 VGND VGND VPWR VPWR sky130_fd_sc_hd__fill_1
XFILLER_65_790 VGND VGND VPWR VPWR sky130_fd_sc_hd__fill_1
X_07698_ _00435_ _00436_ VGND VGND VPWR VPWR _00437_ sky130_fd_sc_hd__nor2_1
XFILLER_80_760 VPWR VGND VPWR VGND sky130_ef_sc_hd__decap_12
XTAP_TAPCELL_ROW_80_1408 VGND VPWR sky130_fd_sc_hd__tapvpwrvgnd_1
XTAP_TAPCELL_ROW_80_1419 VGND VPWR sky130_fd_sc_hd__tapvpwrvgnd_1
X_09437_ net789 _02208_ _02041_ _02045_ VGND VGND VPWR VPWR _02176_ sky130_fd_sc_hd__o31ai_2
XFILLER_9_809 VGND VGND VPWR VPWR sky130_fd_sc_hd__fill_2
XFILLER_25_687 VGND VGND VPWR VPWR sky130_fd_sc_hd__fill_2
X_09368_ net621 net253 _02197_ net645 VGND VGND VPWR VPWR _02100_ sky130_fd_sc_hd__o2bb2a_1
XFILLER_24_197 VGND VGND VPWR VPWR sky130_fd_sc_hd__decap_6
X_08319_ _00950_ _00951_ _00958_ VGND VGND VPWR VPWR _01053_ sky130_fd_sc_hd__o21a_1
X_09299_ _02023_ _02024_ VGND VGND VPWR VPWR _02025_ sky130_fd_sc_hd__xnor2_1
X_11330_ _04235_ _04234_ VGND VGND VPWR VPWR _04236_ sky130_fd_sc_hd__nand2b_1
XFILLER_125_217 VGND VGND VPWR VPWR sky130_fd_sc_hd__decap_6
XFILLER_125_206 VGND VGND VPWR VPWR sky130_fd_sc_hd__decap_6
XFILLER_119_781 VGND VGND VPWR VPWR sky130_fd_sc_hd__decap_3
XFILLER_115_3 VPWR VGND VPWR VGND sky130_ef_sc_hd__decap_12
XFILLER_4_525 VGND VGND VPWR VPWR sky130_fd_sc_hd__decap_6
XFILLER_21_53 VGND VGND VPWR VPWR sky130_fd_sc_hd__decap_3
XFILLER_106_431 VGND VGND VPWR VPWR sky130_fd_sc_hd__fill_1
X_11261_ _04159_ _04160_ VGND VGND VPWR VPWR _00014_ sky130_fd_sc_hd__xnor2_1
XFILLER_97_46 VGND VGND VPWR VPWR sky130_fd_sc_hd__decap_4
X_10212_ _02961_ _03014_ VGND VGND VPWR VPWR _03015_ sky130_fd_sc_hd__or2_1
XFILLER_4_569 VPWR VGND VPWR VGND sky130_ef_sc_hd__decap_12
X_11192_ _04075_ _04084_ VGND VGND VPWR VPWR _04085_ sky130_fd_sc_hd__xnor2_1
X_13000_ _05525_ _05846_ _05848_ VGND VGND VPWR VPWR _06056_ sky130_fd_sc_hd__o21ai_1
XFILLER_121_423 VGND VGND VPWR VPWR sky130_fd_sc_hd__decap_8
XFILLER_97_57 VPWR VGND VPWR VGND sky130_ef_sc_hd__decap_12
X_10143_ _02844_ _02876_ _02880_ _02873_ VGND VGND VPWR VPWR _02939_ sky130_fd_sc_hd__o22ai_1
XFILLER_0_753 VGND VGND VPWR VPWR sky130_fd_sc_hd__decap_3
XFILLER_87_370 VGND VGND VPWR VPWR sky130_fd_sc_hd__fill_1
X_10074_ _02853_ _02862_ VGND VGND VPWR VPWR _02864_ sky130_fd_sc_hd__nand2_1
XTAP_TAPCELL_ROW_7_396 VGND VPWR sky130_fd_sc_hd__tapvpwrvgnd_1
XFILLER_0_797 VPWR VGND VPWR VGND sky130_ef_sc_hd__decap_12
XFILLER_48_757 VPWR VGND VPWR VGND sky130_ef_sc_hd__decap_12
XFILLER_47_245 VGND VGND VPWR VPWR sky130_fd_sc_hd__fill_1
XFILLER_47_223 VGND VGND VPWR VPWR sky130_fd_sc_hd__fill_1
XTAP_TAPCELL_ROW_122_2003 VGND VPWR sky130_fd_sc_hd__tapvpwrvgnd_1
XFILLER_90_557 VGND VGND VPWR VPWR sky130_fd_sc_hd__decap_8
XTAP_TAPCELL_ROW_46_936 VGND VPWR sky130_fd_sc_hd__tapvpwrvgnd_1
XFILLER_46_83 VGND VGND VPWR VPWR sky130_fd_sc_hd__fill_1
XFILLER_16_643 VGND VGND VPWR VPWR sky130_fd_sc_hd__fill_1
X_10976_ _03846_ _03847_ _03695_ VGND VGND VPWR VPWR _03849_ sky130_fd_sc_hd__a21o_1
XFILLER_43_484 VPWR VGND VPWR VGND sky130_ef_sc_hd__decap_12
XFILLER_15_175 VPWR VGND VPWR VGND sky130_ef_sc_hd__decap_12
X_12715_ _05435_ _05609_ VGND VGND VPWR VPWR _05744_ sky130_fd_sc_hd__nor2_1
XTAP_TAPCELL_ROW_26_660 VGND VPWR sky130_fd_sc_hd__tapvpwrvgnd_1
XFILLER_30_101 VGND VGND VPWR VPWR sky130_fd_sc_hd__fill_2
X_12646_ net541 net296 net294 VGND VGND VPWR VPWR _05668_ sky130_fd_sc_hd__and3_1
XFILLER_129_523 VGND VGND VPWR VPWR sky130_fd_sc_hd__fill_1
XFILLER_30_178 VGND VGND VPWR VPWR sky130_fd_sc_hd__decap_3
XTAP_TAPCELL_ROW_100_1699 VGND VPWR sky130_fd_sc_hd__tapvpwrvgnd_1
XTAP_TAPCELL_ROW_100_1688 VGND VPWR sky130_fd_sc_hd__tapvpwrvgnd_1
XFILLER_7_55 VGND VGND VPWR VPWR sky130_fd_sc_hd__fill_1
X_12577_ _05591_ _05592_ VGND VGND VPWR VPWR _05594_ sky130_fd_sc_hd__xnor2_1
XFILLER_117_729 VGND VGND VPWR VPWR sky130_fd_sc_hd__fill_2
X_11528_ _03590_ _04451_ VGND VGND VPWR VPWR _04452_ sky130_fd_sc_hd__xnor2_1
XTAP_TAPCELL_ROW_133_2154 VGND VPWR sky130_fd_sc_hd__tapvpwrvgnd_1
XFILLER_7_385 VGND VGND VPWR VPWR sky130_fd_sc_hd__decap_6
X_11459_ _03890_ _04258_ _04257_ VGND VGND VPWR VPWR _04377_ sky130_fd_sc_hd__a21bo_1
XFILLER_98_613 VPWR VGND VPWR VGND sky130_ef_sc_hd__decap_12
XFILLER_124_294 VGND VGND VPWR VPWR sky130_fd_sc_hd__fill_1
XFILLER_97_101 VGND VGND VPWR VPWR sky130_fd_sc_hd__decap_4
X_13129_ _06165_ _06195_ VGND VGND VPWR VPWR _06197_ sky130_fd_sc_hd__xnor2_1
XFILLER_112_445 VPWR VGND VPWR VGND sky130_ef_sc_hd__decap_12
XFILLER_97_167 VGND VGND VPWR VPWR sky130_fd_sc_hd__fill_1
XTAP_TAPCELL_ROW_51_1009 VGND VPWR sky130_fd_sc_hd__tapvpwrvgnd_1
XFILLER_97_189 VGND VGND VPWR VPWR sky130_fd_sc_hd__fill_1
X_08670_ net465 net157 _01235_ _01234_ VGND VGND VPWR VPWR _01398_ sky130_fd_sc_hd__a31o_1
X_07621_ _00220_ _00227_ _00226_ VGND VGND VPWR VPWR _00361_ sky130_fd_sc_hd__a21o_1
XFILLER_66_576 VPWR VGND VPWR VGND sky130_ef_sc_hd__decap_12
X_07552_ _00290_ _00291_ VGND VGND VPWR VPWR _00292_ sky130_fd_sc_hd__xnor2_1
XFILLER_62_760 VGND VGND VPWR VPWR sky130_fd_sc_hd__fill_1
X_07483_ _06588_ _00223_ VGND VGND VPWR VPWR _00224_ sky130_fd_sc_hd__nor2_1
XFILLER_22_613 VPWR VGND VPWR VGND sky130_ef_sc_hd__decap_12
X_09222_ _02022_ net129 _01806_ _01805_ VGND VGND VPWR VPWR _01946_ sky130_fd_sc_hd__a31o_1
XFILLER_61_281 VPWR VGND VPWR VGND sky130_ef_sc_hd__decap_12
XFILLER_22_657 VPWR VGND VPWR VGND sky130_ef_sc_hd__decap_12
X_09153_ _01876_ _01877_ VGND VGND VPWR VPWR _01878_ sky130_fd_sc_hd__xor2_1
X_08104_ _00832_ _00839_ VGND VGND VPWR VPWR _00840_ sky130_fd_sc_hd__and2b_1
XTAP_TAPCELL_ROW_118_1949 VGND VPWR sky130_fd_sc_hd__tapvpwrvgnd_1
X_09084_ _01807_ _01808_ VGND VGND VPWR VPWR _01809_ sky130_fd_sc_hd__xnor2_1
XFILLER_135_559 VGND VGND VPWR VPWR sky130_fd_sc_hd__fill_1
Xinput91 w13[1] VGND VGND VPWR VPWR net91 sky130_fd_sc_hd__clkbuf_1
X_08035_ _00748_ _00771_ VGND VGND VPWR VPWR _00772_ sky130_fd_sc_hd__and2b_1
Xinput80 w11[6] VGND VGND VPWR VPWR net80 sky130_fd_sc_hd__buf_1
XTAP_TAPCELL_ROW_77_1370 VGND VPWR sky130_fd_sc_hd__tapvpwrvgnd_1
XFILLER_1_517 VPWR VGND VPWR VGND sky130_ef_sc_hd__decap_12
XFILLER_131_721 VGND VGND VPWR VPWR sky130_fd_sc_hd__decap_6
XFILLER_103_434 VGND VGND VPWR VPWR sky130_fd_sc_hd__decap_8
XFILLER_131_765 VPWR VGND VPWR VGND sky130_ef_sc_hd__decap_12
XFILLER_130_231 VGND VGND VPWR VPWR sky130_fd_sc_hd__decap_6
X_09986_ _02767_ _02770_ VGND VGND VPWR VPWR _02771_ sky130_fd_sc_hd__xnor2_1
XFILLER_107_67 VGND VGND VPWR VPWR sky130_fd_sc_hd__fill_1
XFILLER_67_27 VGND VGND VPWR VPWR sky130_fd_sc_hd__decap_3
XFILLER_130_286 VGND VGND VPWR VPWR sky130_fd_sc_hd__fill_1
XFILLER_130_264 VGND VGND VPWR VPWR sky130_fd_sc_hd__fill_1
XFILLER_103_478 VPWR VGND VPWR VGND sky130_ef_sc_hd__decap_12
X_08937_ _01507_ _01661_ _01662_ VGND VGND VPWR VPWR _01663_ sky130_fd_sc_hd__nand3b_1
X_08868_ _01490_ _01517_ _01515_ VGND VGND VPWR VPWR _01594_ sky130_fd_sc_hd__o21a_1
XTAP_TAPCELL_ROW_4_355 VGND VPWR sky130_fd_sc_hd__tapvpwrvgnd_1
XTAP_TAPCELL_ROW_4_344 VGND VPWR sky130_fd_sc_hd__tapvpwrvgnd_1
XFILLER_123_55 VGND VGND VPWR VPWR sky130_fd_sc_hd__fill_1
X_07819_ _00556_ _00557_ VGND VGND VPWR VPWR _00558_ sky130_fd_sc_hd__and2b_1
XFILLER_84_362 VGND VGND VPWR VPWR sky130_fd_sc_hd__fill_2
XFILLER_45_727 VGND VGND VPWR VPWR sky130_fd_sc_hd__fill_1
XFILLER_44_204 VPWR VGND VPWR VGND sky130_ef_sc_hd__decap_12
X_08799_ net422 net553 VGND VGND VPWR VPWR _01526_ sky130_fd_sc_hd__nand2_1
XFILLER_29_289 VPWR VGND VPWR VGND sky130_ef_sc_hd__decap_12
X_10830_ _03506_ _03505_ _03504_ VGND VGND VPWR VPWR _03690_ sky130_fd_sc_hd__a21oi_4
XFILLER_25_473 VPWR VGND VPWR VGND sky130_ef_sc_hd__decap_12
X_10761_ net416 net574 _03611_ _03612_ VGND VGND VPWR VPWR _03614_ sky130_fd_sc_hd__nand4_1
XFILLER_40_410 VGND VGND VPWR VPWR sky130_fd_sc_hd__decap_8
X_10692_ _03227_ _03369_ _03370_ _03364_ VGND VGND VPWR VPWR _03538_ sky130_fd_sc_hd__a22oi_2
XFILLER_12_123 VGND VGND VPWR VPWR sky130_fd_sc_hd__fill_1
XFILLER_9_617 VGND VGND VPWR VPWR sky130_fd_sc_hd__decap_3
X_12500_ _05507_ _05508_ VGND VGND VPWR VPWR _05509_ sky130_fd_sc_hd__nor2_1
XFILLER_40_421 VPWR VGND VPWR VGND sky130_ef_sc_hd__decap_12
X_12431_ net290 net42 net369 VGND VGND VPWR VPWR _05434_ sky130_fd_sc_hd__nand3_2
XFILLER_32_41 VGND VGND VPWR VPWR sky130_fd_sc_hd__decap_4
X_12362_ _05355_ _05356_ VGND VGND VPWR VPWR _05358_ sky130_fd_sc_hd__xnor2_1
XFILLER_126_537 VGND VGND VPWR VPWR sky130_fd_sc_hd__fill_1
XPHY_EDGE_ROW_112_Left_249 VGND VGND VPWR VPWR sky130_fd_sc_hd__decap_3
X_12293_ _05281_ _05282_ VGND VGND VPWR VPWR _05283_ sky130_fd_sc_hd__nand2b_1
XFILLER_4_333 VPWR VGND VPWR VGND sky130_ef_sc_hd__decap_12
X_11313_ net416 net559 _04097_ _04096_ net408 VGND VGND VPWR VPWR _04217_ sky130_fd_sc_hd__a32o_1
X_11244_ _04107_ _04141_ VGND VGND VPWR VPWR _04142_ sky130_fd_sc_hd__or2_1
XFILLER_134_581 VGND VGND VPWR VPWR sky130_fd_sc_hd__decap_6
XFILLER_106_261 VPWR VGND VPWR VGND sky130_ef_sc_hd__decap_12
XFILLER_4_377 VPWR VGND VPWR VGND sky130_ef_sc_hd__decap_12
X_11175_ _03946_ _04065_ VGND VGND VPWR VPWR _04066_ sky130_fd_sc_hd__nor2_1
XFILLER_94_126 VPWR VGND VPWR VGND sky130_ef_sc_hd__decap_12
XFILLER_94_104 VGND VGND VPWR VPWR sky130_fd_sc_hd__decap_8
X_10126_ _02916_ _02919_ VGND VGND VPWR VPWR _02920_ sky130_fd_sc_hd__xnor2_1
XFILLER_88_690 VGND VGND VPWR VPWR sky130_fd_sc_hd__decap_4
X_10057_ _02803_ _02843_ VGND VGND VPWR VPWR _02846_ sky130_fd_sc_hd__xnor2_1
XPHY_EDGE_ROW_121_Left_258 VGND VGND VPWR VPWR sky130_fd_sc_hd__decap_3
XFILLER_75_373 VGND VGND VPWR VPWR sky130_fd_sc_hd__decap_3
XFILLER_48_587 VGND VGND VPWR VPWR sky130_fd_sc_hd__fill_1
XTAP_TAPCELL_ROW_102_1728 VGND VPWR sky130_fd_sc_hd__tapvpwrvgnd_1
XTAP_TAPCELL_ROW_102_1717 VGND VPWR sky130_fd_sc_hd__tapvpwrvgnd_1
XFILLER_16_473 VGND VGND VPWR VPWR sky130_fd_sc_hd__decap_3
X_10959_ _03818_ _03819_ _03830_ VGND VGND VPWR VPWR _03831_ sky130_fd_sc_hd__a21o_1
XFILLER_43_281 VGND VGND VPWR VPWR sky130_fd_sc_hd__fill_1
X_12629_ _05647_ _05649_ _05495_ VGND VGND VPWR VPWR _05651_ sky130_fd_sc_hd__a21o_1
XFILLER_12_690 VGND VGND VPWR VPWR sky130_fd_sc_hd__decap_8
XPHY_EDGE_ROW_130_Left_267 VGND VGND VPWR VPWR sky130_fd_sc_hd__decap_3
XFILLER_8_661 VPWR VGND VPWR VGND sky130_ef_sc_hd__decap_12
XFILLER_7_193 VPWR VGND VPWR VGND sky130_ef_sc_hd__decap_12
XFILLER_98_421 VPWR VGND VPWR VGND sky130_ef_sc_hd__decap_12
X_09840_ _02612_ _02613_ VGND VGND VPWR VPWR _02614_ sky130_fd_sc_hd__nand2b_1
XFILLER_113_776 VGND VGND VPWR VPWR sky130_fd_sc_hd__decap_8
XTAP_TAPCELL_ROW_113_1879 VGND VPWR sky130_fd_sc_hd__tapvpwrvgnd_1
Xfanout629 net125 VGND VGND VPWR VPWR net629 sky130_fd_sc_hd__buf_2
Xfanout607 net133 VGND VGND VPWR VPWR net607 sky130_fd_sc_hd__buf_2
Xfanout618 net623 VGND VGND VPWR VPWR net618 sky130_fd_sc_hd__dlymetal6s2s_1
XFILLER_112_253 VGND VGND VPWR VPWR sky130_fd_sc_hd__decap_4
X_06983_ _05319_ _05330_ VGND VGND VPWR VPWR _05341_ sky130_fd_sc_hd__or2_1
X_09771_ _02525_ _02537_ VGND VGND VPWR VPWR _02538_ sky130_fd_sc_hd__xnor2_1
XFILLER_112_297 VGND VGND VPWR VPWR sky130_fd_sc_hd__fill_1
X_08722_ _01446_ _01445_ _01448_ VGND VGND VPWR VPWR _01450_ sky130_fd_sc_hd__a21o_1
XFILLER_85_148 VPWR VGND VPWR VGND sky130_ef_sc_hd__decap_12
XTAP_TAPCELL_ROW_1_303 VGND VPWR sky130_fd_sc_hd__tapvpwrvgnd_1
XTAP_TAPCELL_ROW_1_314 VGND VPWR sky130_fd_sc_hd__tapvpwrvgnd_1
X_08653_ net509 net123 _01141_ _01222_ VGND VGND VPWR VPWR _01381_ sky130_fd_sc_hd__a31o_1
X_07604_ net461 _00184_ _00185_ _00186_ VGND VGND VPWR VPWR _00344_ sky130_fd_sc_hd__a2bb2o_1
X_08584_ _01307_ net231 _01303_ _01304_ VGND VGND VPWR VPWR _01313_ sky130_fd_sc_hd__o211ai_4
X_07535_ _00272_ _00273_ _06503_ VGND VGND VPWR VPWR _00276_ sky130_fd_sc_hd__o21ai_1
XFILLER_41_218 VGND VGND VPWR VPWR sky130_fd_sc_hd__decap_6
X_07466_ net612 net609 net411 net403 VGND VGND VPWR VPWR _00207_ sky130_fd_sc_hd__nand4_1
X_09205_ _01927_ _01928_ VGND VGND VPWR VPWR _01929_ sky130_fd_sc_hd__xnor2_1
X_07397_ _00135_ _00136_ VGND VGND VPWR VPWR _00138_ sky130_fd_sc_hd__xor2_1
Xrebuffer202 _02989_ VGND VGND VPWR VPWR net902 sky130_fd_sc_hd__clkbuf_2
X_09136_ _01676_ _01860_ VGND VGND VPWR VPWR _01861_ sky130_fd_sc_hd__nand2_1
Xrebuffer246 _04795_ VGND VGND VPWR VPWR net946 sky130_fd_sc_hd__dlygate4sd1_1
X_09067_ _01779_ _01791_ VGND VGND VPWR VPWR _01792_ sky130_fd_sc_hd__nand2_1
X_08018_ _00753_ _00754_ VGND VGND VPWR VPWR _00755_ sky130_fd_sc_hd__xnor2_1
XTAP_TAPCELL_ROW_9_425 VGND VPWR sky130_fd_sc_hd__tapvpwrvgnd_1
XTAP_TAPCELL_ROW_9_414 VGND VPWR sky130_fd_sc_hd__tapvpwrvgnd_1
XFILLER_118_77 VGND VGND VPWR VPWR sky130_fd_sc_hd__decap_6
XFILLER_89_432 VGND VGND VPWR VPWR sky130_fd_sc_hd__decap_3
XFILLER_78_26 VGND VGND VPWR VPWR sky130_fd_sc_hd__fill_2
XFILLER_103_220 VGND VGND VPWR VPWR sky130_fd_sc_hd__decap_4
XFILLER_131_573 VPWR VGND VPWR VGND sky130_ef_sc_hd__decap_12
X_09969_ _02652_ _02666_ _02663_ VGND VGND VPWR VPWR _02753_ sky130_fd_sc_hd__a21oi_1
XFILLER_134_65 VPWR VGND VPWR VGND sky130_ef_sc_hd__decap_12
XFILLER_94_36 VGND VGND VPWR VPWR sky130_fd_sc_hd__fill_1
XFILLER_76_137 VGND VGND VPWR VPWR sky130_fd_sc_hd__decap_3
XFILLER_94_47 VPWR VGND VPWR VGND sky130_ef_sc_hd__decap_12
XFILLER_85_671 VGND VGND VPWR VPWR sky130_fd_sc_hd__fill_1
X_12980_ _06032_ _06033_ VGND VGND VPWR VPWR _06034_ sky130_fd_sc_hd__nor2_1
X_11931_ net534 net660 VGND VGND VPWR VPWR _04888_ sky130_fd_sc_hd__nand2_1
XFILLER_45_535 VPWR VGND VPWR VGND sky130_ef_sc_hd__decap_12
XFILLER_45_513 VGND VGND VPWR VPWR sky130_fd_sc_hd__fill_2
XFILLER_72_365 VGND VGND VPWR VPWR sky130_fd_sc_hd__decap_4
X_11862_ _04801_ _04803_ _04806_ _04811_ VGND VGND VPWR VPWR _04813_ sky130_fd_sc_hd__o211a_4
XFILLER_72_376 VGND VGND VPWR VPWR sky130_fd_sc_hd__decap_8
XFILLER_60_538 VPWR VGND VPWR VGND sky130_ef_sc_hd__decap_12
XFILLER_60_527 VGND VGND VPWR VPWR sky130_fd_sc_hd__decap_4
X_10813_ _03667_ _03668_ _03484_ _03486_ VGND VGND VPWR VPWR _03671_ sky130_fd_sc_hd__o211ai_2
X_11793_ net472 net585 VGND VGND VPWR VPWR _04737_ sky130_fd_sc_hd__nand2_1
XFILLER_53_590 VPWR VGND VPWR VGND sky130_ef_sc_hd__decap_12
XFILLER_25_281 VPWR VGND VPWR VGND sky130_ef_sc_hd__decap_12
X_10744_ _03409_ _03411_ VGND VGND VPWR VPWR _03595_ sky130_fd_sc_hd__and2_1
XFILLER_9_447 VGND VGND VPWR VPWR sky130_fd_sc_hd__fill_1
XFILLER_40_273 VGND VGND VPWR VPWR sky130_fd_sc_hd__decap_8
X_10675_ net686 net663 net273 net89 VGND VGND VPWR VPWR _03519_ sky130_fd_sc_hd__and4b_1
XFILLER_126_301 VGND VGND VPWR VPWR sky130_fd_sc_hd__fill_1
X_13394_ clknet_3_1__leaf_clk _00023_ _00104_ VGND VGND VPWR VPWR net208 sky130_fd_sc_hd__dfrtp_1
X_12414_ _05412_ _05413_ _05414_ VGND VGND VPWR VPWR _05415_ sky130_fd_sc_hd__nand3_1
XFILLER_126_334 VGND VGND VPWR VPWR sky130_fd_sc_hd__fill_1
XFILLER_64_9 VPWR VGND VPWR VGND sky130_ef_sc_hd__decap_12
X_12345_ net499 net673 _05187_ _05186_ VGND VGND VPWR VPWR _05339_ sky130_fd_sc_hd__a31o_1
XTAP_TAPCELL_ROW_130_2113 VGND VPWR sky130_fd_sc_hd__tapvpwrvgnd_1
XFILLER_99_218 VGND VGND VPWR VPWR sky130_fd_sc_hd__decap_6
XFILLER_5_653 VPWR VGND VPWR VGND sky130_ef_sc_hd__decap_12
XFILLER_4_141 VPWR VGND VPWR VGND sky130_ef_sc_hd__decap_12
XFILLER_107_581 VGND VGND VPWR VPWR sky130_fd_sc_hd__fill_2
XFILLER_5_697 VPWR VGND VPWR VGND sky130_ef_sc_hd__decap_12
X_12276_ net81 net360 VGND VGND VPWR VPWR _05264_ sky130_fd_sc_hd__xor2_1
X_11227_ _04115_ _04121_ VGND VGND VPWR VPWR _04124_ sky130_fd_sc_hd__and2b_1
XFILLER_110_724 VGND VGND VPWR VPWR sky130_fd_sc_hd__decap_3
X_11158_ _03914_ _03924_ _03923_ VGND VGND VPWR VPWR _04048_ sky130_fd_sc_hd__a21boi_1
XFILLER_110_757 VPWR VGND VPWR VGND sky130_ef_sc_hd__decap_12
XFILLER_68_92 VPWR VGND VPWR VGND sky130_ef_sc_hd__decap_12
X_10109_ _02900_ _02901_ VGND VGND VPWR VPWR _02902_ sky130_fd_sc_hd__nor2_1
XTAP_TAPCELL_ROW_128_2086 VGND VPWR sky130_fd_sc_hd__tapvpwrvgnd_1
X_11089_ net416 net409 net563 net561 VGND VGND VPWR VPWR _03973_ sky130_fd_sc_hd__and4_1
XFILLER_63_310 VGND VGND VPWR VPWR sky130_fd_sc_hd__fill_1
XFILLER_36_524 VGND VGND VPWR VPWR sky130_fd_sc_hd__decap_8
XFILLER_91_663 VGND VGND VPWR VPWR sky130_fd_sc_hd__fill_1
XFILLER_36_557 VPWR VGND VPWR VGND sky130_ef_sc_hd__decap_12
XFILLER_17_771 VPWR VGND VPWR VGND sky130_ef_sc_hd__decap_12
XFILLER_90_195 VGND VGND VPWR VPWR sky130_fd_sc_hd__fill_1
X_07320_ net767 net384 _06609_ _06610_ VGND VGND VPWR VPWR _06611_ sky130_fd_sc_hd__a22o_1
XFILLER_16_270 VGND VGND VPWR VPWR sky130_fd_sc_hd__decap_6
XTAP_TAPCELL_ROW_34_769 VGND VPWR sky130_fd_sc_hd__tapvpwrvgnd_1
X_07251_ _05221_ _05243_ _06392_ _06391_ _06382_ VGND VGND VPWR VPWR _06542_ sky130_fd_sc_hd__a32o_1
XFILLER_136_109 VGND VGND VPWR VPWR sky130_fd_sc_hd__decap_3
XFILLER_129_161 VGND VGND VPWR VPWR sky130_fd_sc_hd__decap_6
X_07182_ _05877_ net725 _05954_ VGND VGND VPWR VPWR _06474_ sky130_fd_sc_hd__a21bo_1
XTAP_TAPCELL_ROW_14_493 VGND VPWR sky130_fd_sc_hd__tapvpwrvgnd_1
XTAP_TAPCELL_ROW_115_1908 VGND VPWR sky130_fd_sc_hd__tapvpwrvgnd_1
Xfanout404 net405 VGND VGND VPWR VPWR net404 sky130_fd_sc_hd__buf_2
X_09823_ _02110_ _02593_ VGND VGND VPWR VPWR _02595_ sky130_fd_sc_hd__xnor2_1
XFILLER_98_251 VGND VGND VPWR VPWR sky130_fd_sc_hd__fill_1
Xfanout448 net449 VGND VGND VPWR VPWR net448 sky130_fd_sc_hd__dlymetal6s2s_1
Xfanout415 net31 VGND VGND VPWR VPWR net415 sky130_fd_sc_hd__buf_2
Xfanout426 net742 VGND VGND VPWR VPWR net426 sky130_fd_sc_hd__buf_6
Xfanout437 net440 VGND VGND VPWR VPWR net437 sky130_fd_sc_hd__buf_2
XFILLER_101_757 VGND VGND VPWR VPWR sky130_fd_sc_hd__fill_1
Xfanout459 net26 VGND VGND VPWR VPWR net459 sky130_fd_sc_hd__dlymetal6s2s_1
X_06966_ _03368_ _05133_ VGND VGND VPWR VPWR _05155_ sky130_fd_sc_hd__or2_1
XFILLER_74_619 VGND VGND VPWR VPWR sky130_fd_sc_hd__decap_6
X_09754_ _02512_ _02518_ VGND VGND VPWR VPWR _02519_ sky130_fd_sc_hd__nand2b_1
XFILLER_39_362 VPWR VGND VPWR VGND sky130_ef_sc_hd__decap_12
X_09685_ _02416_ _02443_ VGND VGND VPWR VPWR _02444_ sky130_fd_sc_hd__xor2_1
X_08705_ _01403_ _01404_ _01430_ _01431_ VGND VGND VPWR VPWR _01433_ sky130_fd_sc_hd__o22a_1
XFILLER_82_630 VGND VGND VPWR VPWR sky130_fd_sc_hd__fill_1
X_06897_ _04156_ _04385_ net919 VGND VGND VPWR VPWR _04407_ sky130_fd_sc_hd__o21bai_1
XFILLER_54_321 VGND VGND VPWR VPWR sky130_fd_sc_hd__decap_4
XPHY_EDGE_ROW_126_Right_126 VGND VGND VPWR VPWR sky130_fd_sc_hd__decap_3
X_08636_ _01201_ _01203_ _01363_ VGND VGND VPWR VPWR _01364_ sky130_fd_sc_hd__a21oi_1
XFILLER_54_354 VGND VGND VPWR VPWR sky130_fd_sc_hd__decap_8
XTAP_TAPCELL_ROW_85_1491 VGND VPWR sky130_fd_sc_hd__tapvpwrvgnd_1
XTAP_TAPCELL_ROW_85_1480 VGND VPWR sky130_fd_sc_hd__tapvpwrvgnd_1
X_08567_ _01135_ _01247_ VGND VGND VPWR VPWR _01296_ sky130_fd_sc_hd__nor2_1
XFILLER_23_741 VPWR VGND VPWR VGND sky130_ef_sc_hd__decap_12
X_08498_ _01218_ _01226_ VGND VGND VPWR VPWR _01227_ sky130_fd_sc_hd__xnor2_2
X_07518_ _00199_ _00256_ _00258_ VGND VGND VPWR VPWR _00259_ sky130_fd_sc_hd__and3_4
XFILLER_23_785 VPWR VGND VPWR VGND sky130_ef_sc_hd__decap_12
X_07449_ _00182_ _00188_ VGND VGND VPWR VPWR _00190_ sky130_fd_sc_hd__xor2_1
XFILLER_50_582 VGND VGND VPWR VPWR sky130_fd_sc_hd__decap_6
XFILLER_10_424 VGND VGND VPWR VPWR sky130_fd_sc_hd__fill_2
XFILLER_10_468 VGND VGND VPWR VPWR sky130_fd_sc_hd__decap_8
X_10460_ net512 net345 VGND VGND VPWR VPWR _03285_ sky130_fd_sc_hd__nand2_1
XFILLER_136_643 VGND VGND VPWR VPWR sky130_fd_sc_hd__fill_1
XFILLER_89_14 VPWR VGND VPWR VGND sky130_ef_sc_hd__decap_12
X_09119_ net414 net406 net555 net553 VGND VGND VPWR VPWR _01844_ sky130_fd_sc_hd__nand4_1
XFILLER_124_805 VGND VGND VPWR VPWR sky130_fd_sc_hd__fill_2
X_10391_ _03208_ _03209_ VGND VGND VPWR VPWR _03210_ sky130_fd_sc_hd__xnor2_1
XFILLER_123_337 VGND VGND VPWR VPWR sky130_fd_sc_hd__fill_1
X_12130_ _05102_ _05103_ _05083_ VGND VGND VPWR VPWR _05105_ sky130_fd_sc_hd__a21oi_2
XFILLER_2_601 VPWR VGND VPWR VGND sky130_ef_sc_hd__decap_12
XFILLER_104_540 VGND VGND VPWR VPWR sky130_fd_sc_hd__decap_6
X_12061_ net524 net110 VGND VGND VPWR VPWR _05030_ sky130_fd_sc_hd__nand2_1
XFILLER_8_3 VPWR VGND VPWR VGND sky130_ef_sc_hd__decap_12
XFILLER_1_111 VGND VGND VPWR VPWR sky130_fd_sc_hd__fill_1
XFILLER_2_645 VPWR VGND VPWR VGND sky130_ef_sc_hd__decap_12
XFILLER_104_573 VGND VGND VPWR VPWR sky130_fd_sc_hd__decap_6
X_11012_ _03749_ _03759_ _03758_ VGND VGND VPWR VPWR _03888_ sky130_fd_sc_hd__a21o_1
X_12963_ _06009_ _06014_ VGND VGND VPWR VPWR _06015_ sky130_fd_sc_hd__xor2_1
XFILLER_18_513 VPWR VGND VPWR VGND sky130_ef_sc_hd__decap_12
XFILLER_57_192 VGND VGND VPWR VPWR sky130_fd_sc_hd__decap_8
X_11914_ net640 net298 VGND VGND VPWR VPWR _04869_ sky130_fd_sc_hd__nand2_1
XFILLER_45_387 VGND VGND VPWR VPWR sky130_fd_sc_hd__decap_4
X_12894_ _05905_ _05938_ VGND VGND VPWR VPWR _05940_ sky130_fd_sc_hd__and2_1
XFILLER_33_505 VGND VGND VPWR VPWR sky130_fd_sc_hd__decap_3
X_11845_ _04791_ _04784_ _04620_ VGND VGND VPWR VPWR _04794_ sky130_fd_sc_hd__a21o_1
XFILLER_60_346 VGND VGND VPWR VPWR sky130_fd_sc_hd__decap_6
XFILLER_60_324 VGND VGND VPWR VPWR sky130_fd_sc_hd__fill_2
X_11776_ _04714_ _04717_ VGND VGND VPWR VPWR _04718_ sky130_fd_sc_hd__xnor2_1
XFILLER_13_251 VPWR VGND VPWR VGND sky130_ef_sc_hd__decap_12
XTAP_TAPCELL_ROW_31_728 VGND VPWR sky130_fd_sc_hd__tapvpwrvgnd_1
X_10727_ net495 net649 VGND VGND VPWR VPWR _03577_ sky130_fd_sc_hd__nand2_1
XFILLER_9_255 VPWR VGND VPWR VGND sky130_ef_sc_hd__decap_12
XFILLER_127_632 VPWR VGND VPWR VGND sky130_ef_sc_hd__decap_12
X_10658_ _03320_ _03322_ _03499_ VGND VGND VPWR VPWR _03502_ sky130_fd_sc_hd__a21oi_1
XTAP_TAPCELL_ROW_11_452 VGND VPWR sky130_fd_sc_hd__tapvpwrvgnd_1
X_13377_ clknet_3_4__leaf_clk _00035_ _00087_ VGND VGND VPWR VPWR net191 sky130_fd_sc_hd__dfrtp_1
X_10589_ net400 net580 VGND VGND VPWR VPWR _03426_ sky130_fd_sc_hd__and2_4
XFILLER_5_461 VPWR VGND VPWR VGND sky130_ef_sc_hd__decap_12
X_12328_ net617 net592 net296 net294 VGND VGND VPWR VPWR _05321_ sky130_fd_sc_hd__and4_1
XFILLER_126_197 VPWR VGND VPWR VGND sky130_ef_sc_hd__decap_12
X_12259_ _05082_ _05244_ VGND VGND VPWR VPWR _05246_ sky130_fd_sc_hd__xor2_1
XTAP_TAPCELL_ROW_110_1838 VGND VPWR sky130_fd_sc_hd__tapvpwrvgnd_1
XTAP_TAPCELL_ROW_56_1081 VGND VPWR sky130_fd_sc_hd__tapvpwrvgnd_1
XFILLER_122_381 VGND VGND VPWR VPWR sky130_fd_sc_hd__fill_2
X_06820_ _03543_ _03554_ VGND VGND VPWR VPWR _03565_ sky130_fd_sc_hd__nor2_1
XFILLER_95_254 VPWR VGND VPWR VGND sky130_ef_sc_hd__decap_12
XFILLER_83_405 VPWR VGND VPWR VGND sky130_ef_sc_hd__decap_12
XFILLER_110_587 VGND VGND VPWR VPWR sky130_fd_sc_hd__fill_1
X_06751_ net613 net452 _02791_ VGND VGND VPWR VPWR _02813_ sky130_fd_sc_hd__and3_1
XFILLER_55_118 VGND VGND VPWR VPWR sky130_fd_sc_hd__fill_1
XTAP_TAPCELL_ROW_39_839 VGND VPWR sky130_fd_sc_hd__tapvpwrvgnd_1
X_06682_ net681 VGND VGND VPWR VPWR _02066_ sky130_fd_sc_hd__inv_2
X_09470_ _02210_ _02211_ VGND VGND VPWR VPWR _02212_ sky130_fd_sc_hd__and2b_1
XFILLER_52_803 VGND VGND VPWR VPWR sky130_fd_sc_hd__fill_1
XFILLER_48_192 VGND VGND VPWR VPWR sky130_fd_sc_hd__decap_4
X_08421_ net692 net669 net265 net263 VGND VGND VPWR VPWR _01151_ sky130_fd_sc_hd__and4_1
XFILLER_64_696 VGND VGND VPWR VPWR sky130_fd_sc_hd__decap_4
XTAP_TAPCELL_ROW_19_563 VGND VPWR sky130_fd_sc_hd__tapvpwrvgnd_1
XFILLER_24_516 VGND VGND VPWR VPWR sky130_fd_sc_hd__decap_6
X_08352_ _05025_ _01084_ _03194_ VGND VGND VPWR VPWR _00038_ sky130_fd_sc_hd__mux2_1
XTAP_TAPCELL_ROW_121_1989 VGND VPWR sky130_fd_sc_hd__tapvpwrvgnd_1
X_08283_ _00987_ _01016_ VGND VGND VPWR VPWR _01018_ sky130_fd_sc_hd__xor2_1
X_07303_ net514 net427 net382 net40 VGND VGND VPWR VPWR _06594_ sky130_fd_sc_hd__and4_1
X_07234_ _06516_ _06524_ VGND VGND VPWR VPWR _06525_ sky130_fd_sc_hd__xnor2_1
XFILLER_118_632 VPWR VGND VPWR VGND sky130_ef_sc_hd__decap_12
X_07165_ _06453_ _06454_ _06455_ VGND VGND VPWR VPWR _06457_ sky130_fd_sc_hd__or3_1
X_07096_ _06386_ _06387_ VGND VGND VPWR VPWR _06388_ sky130_fd_sc_hd__xnor2_1
XFILLER_105_326 VGND VGND VPWR VPWR sky130_fd_sc_hd__decap_8
XFILLER_105_337 VGND VGND VPWR VPWR sky130_fd_sc_hd__decap_4
XFILLER_120_307 VGND VGND VPWR VPWR sky130_fd_sc_hd__fill_1
Xfanout256 net94 VGND VGND VPWR VPWR net256 sky130_fd_sc_hd__buf_2
XFILLER_113_381 VGND VGND VPWR VPWR sky130_fd_sc_hd__decap_8
XFILLER_86_232 VPWR VGND VPWR VGND sky130_ef_sc_hd__decap_12
Xfanout267 net268 VGND VGND VPWR VPWR net267 sky130_fd_sc_hd__buf_2
XFILLER_115_67 VPWR VGND VPWR VGND sky130_ef_sc_hd__decap_12
XFILLER_101_576 VGND VGND VPWR VPWR sky130_fd_sc_hd__decap_3
X_09806_ _02417_ _02442_ _02441_ VGND VGND VPWR VPWR _02576_ sky130_fd_sc_hd__a21o_1
X_07998_ _00733_ _00734_ VGND VGND VPWR VPWR _00735_ sky130_fd_sc_hd__nor2_1
XFILLER_86_265 VGND VGND VPWR VPWR sky130_fd_sc_hd__decap_4
Xfanout278 net85 VGND VGND VPWR VPWR net278 sky130_fd_sc_hd__buf_1
Xfanout289 net8 VGND VGND VPWR VPWR net289 sky130_fd_sc_hd__buf_8
X_09737_ _02232_ _02500_ VGND VGND VPWR VPWR _02502_ sky130_fd_sc_hd__and2b_1
X_06949_ _02522_ _02588_ _03020_ _03140_ VGND VGND VPWR VPWR _04971_ sky130_fd_sc_hd__a31o_1
XFILLER_74_449 VPWR VGND VPWR VGND sky130_ef_sc_hd__decap_12
XFILLER_74_427 VGND VGND VPWR VPWR sky130_fd_sc_hd__decap_8
XFILLER_131_55 VGND VGND VPWR VPWR sky130_fd_sc_hd__fill_1
X_09668_ _02423_ _02425_ VGND VGND VPWR VPWR _02426_ sky130_fd_sc_hd__nor2_1
XFILLER_15_505 VGND VGND VPWR VPWR sky130_fd_sc_hd__fill_2
X_08619_ _01178_ _01345_ VGND VGND VPWR VPWR _01347_ sky130_fd_sc_hd__or2_1
X_09599_ _02323_ _02350_ VGND VGND VPWR VPWR _02352_ sky130_fd_sc_hd__xnor2_1
XFILLER_70_655 VGND VGND VPWR VPWR sky130_fd_sc_hd__fill_2
XFILLER_54_195 VGND VGND VPWR VPWR sky130_fd_sc_hd__fill_1
X_11630_ _04558_ _04562_ VGND VGND VPWR VPWR _04563_ sky130_fd_sc_hd__xnor2_1
XFILLER_70_699 VGND VGND VPWR VPWR sky130_fd_sc_hd__fill_1
X_11561_ _04482_ _04487_ VGND VGND VPWR VPWR _04488_ sky130_fd_sc_hd__nand2_1
X_13300_ net395 VGND VGND VPWR VPWR _00074_ sky130_fd_sc_hd__inv_2
XFILLER_128_418 VGND VGND VPWR VPWR sky130_fd_sc_hd__fill_2
X_10512_ net266 _02230_ VGND VGND VPWR VPWR _03341_ sky130_fd_sc_hd__nor2_1
XFILLER_11_777 VGND VGND VPWR VPWR sky130_fd_sc_hd__decap_6
X_11492_ _04281_ _04283_ _04411_ VGND VGND VPWR VPWR _04413_ sky130_fd_sc_hd__and3_1
XTAP_TAPCELL_ROW_98_1671 VGND VPWR sky130_fd_sc_hd__tapvpwrvgnd_1
XTAP_TAPCELL_ROW_98_1660 VGND VPWR sky130_fd_sc_hd__tapvpwrvgnd_1
X_10443_ _03262_ _03264_ _03265_ VGND VGND VPWR VPWR _03266_ sky130_fd_sc_hd__or3_1
X_13231_ _06306_ _06307_ VGND VGND VPWR VPWR _06308_ sky130_fd_sc_hd__and2b_1
XFILLER_40_63 VPWR VGND VPWR VGND sky130_ef_sc_hd__decap_12
XFILLER_136_473 VGND VGND VPWR VPWR sky130_fd_sc_hd__decap_3
X_10374_ net689 net274 VGND VGND VPWR VPWR _03191_ sky130_fd_sc_hd__nand2_1
X_13162_ _06230_ _06231_ VGND VGND VPWR VPWR _06232_ sky130_fd_sc_hd__and2_1
XFILLER_40_85 VPWR VGND VPWR VGND sky130_ef_sc_hd__decap_12
XFILLER_123_145 VGND VGND VPWR VPWR sky130_fd_sc_hd__decap_6
X_12113_ net379 net367 net365 net428 VGND VGND VPWR VPWR _05086_ sky130_fd_sc_hd__a22o_1
X_13093_ _06131_ _06156_ VGND VGND VPWR VPWR _06157_ sky130_fd_sc_hd__xnor2_1
XFILLER_2_475 VGND VGND VPWR VPWR sky130_fd_sc_hd__fill_1
XFILLER_104_392 VGND VGND VPWR VPWR sky130_fd_sc_hd__fill_1
XFILLER_78_755 VGND VGND VPWR VPWR sky130_fd_sc_hd__fill_1
X_12044_ _05009_ _05010_ VGND VGND VPWR VPWR _05011_ sky130_fd_sc_hd__nand2_1
XFILLER_49_72 VGND VGND VPWR VPWR sky130_fd_sc_hd__decap_4
XFILLER_49_50 VGND VGND VPWR VPWR sky130_fd_sc_hd__fill_1
XFILLER_77_254 VPWR VGND VPWR VGND sky130_ef_sc_hd__decap_12
XFILLER_65_405 VGND VGND VPWR VPWR sky130_fd_sc_hd__fill_1
XFILLER_93_725 VGND VGND VPWR VPWR sky130_fd_sc_hd__decap_3
XFILLER_65_416 VGND VGND VPWR VPWR sky130_fd_sc_hd__decap_6
XTAP_TAPCELL_ROW_125_2045 VGND VPWR sky130_fd_sc_hd__tapvpwrvgnd_1
XFILLER_65_449 VGND VGND VPWR VPWR sky130_fd_sc_hd__decap_4
XFILLER_1_57 VPWR VGND VPWR VGND sky130_ef_sc_hd__decap_12
XFILLER_18_321 VGND VGND VPWR VPWR sky130_fd_sc_hd__fill_1
X_12946_ _05891_ _05995_ VGND VGND VPWR VPWR _05996_ sky130_fd_sc_hd__xnor2_1
XTAP_TAPCELL_ROW_16_522 VGND VPWR sky130_fd_sc_hd__tapvpwrvgnd_1
X_12877_ _05914_ _05919_ VGND VGND VPWR VPWR _05922_ sky130_fd_sc_hd__xnor2_1
XFILLER_33_335 VGND VGND VPWR VPWR sky130_fd_sc_hd__fill_1
X_11828_ _04768_ _04769_ _04775_ VGND VGND VPWR VPWR _04776_ sky130_fd_sc_hd__nand3_1
X_11759_ _04655_ _04699_ VGND VGND VPWR VPWR _04700_ sky130_fd_sc_hd__and2_1
XFILLER_41_390 VGND VGND VPWR VPWR sky130_fd_sc_hd__fill_2
XTAP_TAPCELL_ROW_136_2196 VGND VPWR sky130_fd_sc_hd__tapvpwrvgnd_1
XTAP_TAPCELL_ROW_58_1110 VGND VPWR sky130_fd_sc_hd__tapvpwrvgnd_1
XFILLER_127_473 VPWR VGND VPWR VGND sky130_ef_sc_hd__decap_12
XFILLER_115_624 VGND VGND VPWR VPWR sky130_fd_sc_hd__decap_8
XFILLER_6_781 VPWR VGND VPWR VGND sky130_ef_sc_hd__decap_12
XFILLER_115_668 VGND VGND VPWR VPWR sky130_fd_sc_hd__decap_4
XFILLER_114_134 VGND VGND VPWR VPWR sky130_fd_sc_hd__decap_6
X_08970_ _01695_ _01675_ VGND VGND VPWR VPWR _01696_ sky130_fd_sc_hd__xor2_1
XFILLER_123_690 VPWR VGND VPWR VGND sky130_ef_sc_hd__decap_12
X_07921_ _00534_ _00550_ _00549_ VGND VGND VPWR VPWR _00659_ sky130_fd_sc_hd__a21oi_1
X_07852_ net594 net303 _02131_ net620 VGND VGND VPWR VPWR _00590_ sky130_fd_sc_hd__o2bb2a_1
XFILLER_110_340 VGND VGND VPWR VPWR sky130_fd_sc_hd__fill_1
XFILLER_68_265 VGND VGND VPWR VPWR sky130_fd_sc_hd__fill_1
X_06803_ _03346_ _03368_ VGND VGND VPWR VPWR _03379_ sky130_fd_sc_hd__or2_1
XFILLER_110_362 VGND VGND VPWR VPWR sky130_fd_sc_hd__fill_2
Xinput1 in0[0] VGND VGND VPWR VPWR net1 sky130_fd_sc_hd__clkbuf_2
X_09522_ _02263_ _02267_ VGND VGND VPWR VPWR _02268_ sky130_fd_sc_hd__nand2b_1
XFILLER_83_257 VGND VGND VPWR VPWR sky130_fd_sc_hd__decap_6
X_07783_ net376 net373 VGND VGND VPWR VPWR _00522_ sky130_fd_sc_hd__nand2b_1
X_06734_ _02621_ VGND VGND VPWR VPWR _02631_ sky130_fd_sc_hd__inv_2
XFILLER_83_279 VGND VGND VPWR VPWR sky130_fd_sc_hd__fill_1
XFILLER_83_268 VGND VGND VPWR VPWR sky130_fd_sc_hd__fill_1
XFILLER_71_408 VGND VGND VPWR VPWR sky130_fd_sc_hd__fill_1
XTAP_TAPCELL_ROW_69_1261 VGND VPWR sky130_fd_sc_hd__tapvpwrvgnd_1
X_09453_ net423 net414 net550 net548 VGND VGND VPWR VPWR _02193_ sky130_fd_sc_hd__and4_1
XFILLER_52_622 VGND VGND VPWR VPWR sky130_fd_sc_hd__fill_2
XFILLER_36_195 VGND VGND VPWR VPWR sky130_fd_sc_hd__fill_1
X_09384_ _02108_ _02115_ VGND VGND VPWR VPWR _02117_ sky130_fd_sc_hd__xor2_1
X_08404_ net464 net555 net553 net473 VGND VGND VPWR VPWR _01134_ sky130_fd_sc_hd__a22oi_1
XFILLER_52_688 VGND VGND VPWR VPWR sky130_fd_sc_hd__fill_2
XFILLER_52_677 VGND VGND VPWR VPWR sky130_fd_sc_hd__decap_4
XFILLER_101_69 VGND VGND VPWR VPWR sky130_fd_sc_hd__decap_6
X_08335_ _01056_ _01068_ VGND VGND VPWR VPWR _01069_ sky130_fd_sc_hd__xnor2_1
XFILLER_32_390 VPWR VGND VPWR VGND sky130_ef_sc_hd__decap_12
X_08266_ net249 _01000_ VGND VGND VPWR VPWR _01001_ sky130_fd_sc_hd__nor2_1
X_07217_ net667 net71 net304 net687 VGND VGND VPWR VPWR _06508_ sky130_fd_sc_hd__a22o_1
X_08197_ _00710_ _00815_ _00814_ VGND VGND VPWR VPWR _00933_ sky130_fd_sc_hd__a21boi_1
X_07148_ net611 net610 net436 net419 VGND VGND VPWR VPWR _06440_ sky130_fd_sc_hd__and4_1
XFILLER_3_217 VGND VGND VPWR VPWR sky130_fd_sc_hd__decap_6
XFILLER_106_635 VGND VGND VPWR VPWR sky130_fd_sc_hd__decap_8
X_07079_ net687 net305 VGND VGND VPWR VPWR _06371_ sky130_fd_sc_hd__nand2_1
XFILLER_105_167 VGND VGND VPWR VPWR sky130_fd_sc_hd__fill_1
XFILLER_126_77 VGND VGND VPWR VPWR sky130_fd_sc_hd__decap_6
XFILLER_99_390 VGND VGND VPWR VPWR sky130_fd_sc_hd__fill_2
XTAP_TAPCELL_ROW_93_1590 VGND VPWR sky130_fd_sc_hd__tapvpwrvgnd_1
X_10090_ _02873_ _02880_ VGND VGND VPWR VPWR _02881_ sky130_fd_sc_hd__xor2_1
XFILLER_47_405 VGND VGND VPWR VPWR sky130_fd_sc_hd__decap_4
XFILLER_47_449 VGND VGND VPWR VPWR sky130_fd_sc_hd__decap_3
XFILLER_19_75 VGND VGND VPWR VPWR sky130_fd_sc_hd__decap_8
X_12800_ _05832_ _05835_ _05831_ VGND VGND VPWR VPWR _05837_ sky130_fd_sc_hd__o21ai_1
XFILLER_90_739 VGND VGND VPWR VPWR sky130_fd_sc_hd__decap_8
XFILLER_62_419 VGND VGND VPWR VPWR sky130_fd_sc_hd__fill_1
XFILLER_43_600 VGND VGND VPWR VPWR sky130_fd_sc_hd__fill_1
X_10992_ _03717_ _03735_ _03734_ VGND VGND VPWR VPWR _03866_ sky130_fd_sc_hd__o21a_1
XFILLER_43_644 VGND VGND VPWR VPWR sky130_fd_sc_hd__decap_4
X_12731_ _05225_ _05761_ VGND VGND VPWR VPWR _05762_ sky130_fd_sc_hd__nand2_1
XFILLER_15_346 VPWR VGND VPWR VGND sky130_ef_sc_hd__decap_12
X_12662_ _05521_ _05524_ _05528_ VGND VGND VPWR VPWR _05686_ sky130_fd_sc_hd__a21o_1
X_11613_ _04423_ _04426_ VGND VGND VPWR VPWR _04544_ sky130_fd_sc_hd__nand2_1
XFILLER_129_727 VGND VGND VPWR VPWR sky130_fd_sc_hd__fill_1
X_12593_ _05434_ _05435_ _05609_ VGND VGND VPWR VPWR _05611_ sky130_fd_sc_hd__and3_1
XFILLER_23_390 VGND VGND VPWR VPWR sky130_fd_sc_hd__fill_2
XTAP_TAPCELL_ROW_41_867 VGND VPWR sky130_fd_sc_hd__tapvpwrvgnd_1
X_11544_ _04466_ _04467_ VGND VGND VPWR VPWR _04469_ sky130_fd_sc_hd__and2b_1
XFILLER_51_73 VGND VGND VPWR VPWR sky130_fd_sc_hd__decap_8
XFILLER_7_556 VGND VGND VPWR VPWR sky130_fd_sc_hd__decap_4
X_11475_ _04364_ _04392_ VGND VGND VPWR VPWR _04394_ sky130_fd_sc_hd__xnor2_1
XTAP_TAPCELL_ROW_21_591 VGND VPWR sky130_fd_sc_hd__tapvpwrvgnd_1
XFILLER_109_473 VGND VGND VPWR VPWR sky130_fd_sc_hd__decap_6
X_10426_ _03245_ _03246_ VGND VGND VPWR VPWR _03247_ sky130_fd_sc_hd__xnor2_1
X_13214_ _06288_ _06282_ VGND VGND VPWR VPWR _06289_ sky130_fd_sc_hd__and2b_1
XFILLER_136_281 VGND VGND VPWR VPWR sky130_fd_sc_hd__fill_2
XFILLER_124_421 VPWR VGND VPWR VGND sky130_ef_sc_hd__decap_12
X_10357_ _03057_ _03171_ _03172_ VGND VGND VPWR VPWR _03174_ sky130_fd_sc_hd__nor3_1
X_13145_ _05962_ _06213_ VGND VGND VPWR VPWR _06214_ sky130_fd_sc_hd__xnor2_1
XFILLER_78_530 VGND VGND VPWR VPWR sky130_fd_sc_hd__fill_2
XTAP_TAPCELL_ROW_53_1040 VGND VPWR sky130_fd_sc_hd__tapvpwrvgnd_1
X_10288_ _03095_ _03097_ VGND VGND VPWR VPWR _03098_ sky130_fd_sc_hd__and2b_1
X_13076_ _06009_ _06137_ VGND VGND VPWR VPWR _06138_ sky130_fd_sc_hd__xor2_1
XFILLER_111_137 VPWR VGND VPWR VGND sky130_ef_sc_hd__decap_12
XFILLER_78_541 VGND VGND VPWR VPWR sky130_fd_sc_hd__fill_1
X_12027_ _04858_ _04860_ _04857_ VGND VGND VPWR VPWR _04993_ sky130_fd_sc_hd__o21ba_1
XFILLER_93_544 VGND VGND VPWR VPWR sky130_fd_sc_hd__fill_2
XFILLER_93_599 VPWR VGND VPWR VGND sky130_ef_sc_hd__decap_12
XFILLER_93_588 VGND VGND VPWR VPWR sky130_fd_sc_hd__fill_2
XFILLER_93_577 VGND VGND VPWR VPWR sky130_fd_sc_hd__fill_1
XTAP_TAPCELL_ROW_49_978 VGND VPWR sky130_fd_sc_hd__tapvpwrvgnd_1
XFILLER_19_663 VGND VGND VPWR VPWR sky130_fd_sc_hd__decap_4
X_12929_ _05972_ _05977_ VGND VGND VPWR VPWR _05978_ sky130_fd_sc_hd__or2_1
XFILLER_18_195 VGND VGND VPWR VPWR sky130_fd_sc_hd__fill_1
XTAP_TAPCELL_ROW_105_1759 VGND VPWR sky130_fd_sc_hd__tapvpwrvgnd_1
XFILLER_61_441 VGND VGND VPWR VPWR sky130_fd_sc_hd__decap_6
XFILLER_33_165 VGND VGND VPWR VPWR sky130_fd_sc_hd__decap_3
XFILLER_33_176 VGND VGND VPWR VPWR sky130_fd_sc_hd__decap_8
XFILLER_34_699 VGND VGND VPWR VPWR sky130_fd_sc_hd__fill_1
XTAP_TAPCELL_ROW_64_1191 VGND VPWR sky130_fd_sc_hd__tapvpwrvgnd_1
X_08120_ _00847_ _00855_ VGND VGND VPWR VPWR _00856_ sky130_fd_sc_hd__xnor2_2
X_08051_ _00782_ _00787_ VGND VGND VPWR VPWR _00788_ sky130_fd_sc_hd__xor2_1
XFILLER_128_793 VPWR VGND VPWR VGND sky130_ef_sc_hd__decap_12
X_07002_ _03839_ _05527_ VGND VGND VPWR VPWR _05549_ sky130_fd_sc_hd__nor2_1
XFILLER_115_432 VGND VGND VPWR VPWR sky130_fd_sc_hd__fill_2
XFILLER_88_305 VGND VGND VPWR VPWR sky130_fd_sc_hd__decap_3
XFILLER_0_209 VPWR VGND VPWR VGND sky130_ef_sc_hd__decap_12
XFILLER_102_115 VPWR VGND VPWR VGND sky130_ef_sc_hd__decap_12
X_08953_ net406 net557 net555 net414 VGND VGND VPWR VPWR _01679_ sky130_fd_sc_hd__a22oi_1
XFILLER_130_457 VPWR VGND VPWR VGND sky130_ef_sc_hd__decap_12
X_07904_ _00519_ _00527_ _00526_ VGND VGND VPWR VPWR _00642_ sky130_fd_sc_hd__o21a_1
X_08884_ _01456_ _01458_ _01455_ VGND VGND VPWR VPWR _01610_ sky130_fd_sc_hd__o21ba_1
XFILLER_111_671 VGND VGND VPWR VPWR sky130_fd_sc_hd__fill_1
XFILLER_96_371 VGND VGND VPWR VPWR sky130_fd_sc_hd__fill_1
XFILLER_84_511 VGND VGND VPWR VPWR sky130_fd_sc_hd__fill_1
XFILLER_29_405 VPWR VGND VPWR VGND sky130_ef_sc_hd__decap_12
X_07835_ _00279_ _00431_ _00280_ _00573_ VGND VGND VPWR VPWR _00574_ sky130_fd_sc_hd__o31ai_4
XFILLER_57_747 VGND VGND VPWR VPWR sky130_fd_sc_hd__decap_6
XPHY_EDGE_ROW_16_Left_153 VGND VGND VPWR VPWR sky130_fd_sc_hd__decap_3
XFILLER_29_449 VGND VGND VPWR VPWR sky130_fd_sc_hd__fill_1
X_07766_ _00477_ _00504_ VGND VGND VPWR VPWR _00505_ sky130_fd_sc_hd__and2b_1
X_09505_ _02247_ _02248_ VGND VGND VPWR VPWR _02249_ sky130_fd_sc_hd__nand2_1
X_06717_ net613 net460 _02413_ _02435_ VGND VGND VPWR VPWR _02446_ sky130_fd_sc_hd__and4_1
X_07697_ _00322_ _00324_ _00434_ VGND VGND VPWR VPWR _00436_ sky130_fd_sc_hd__and3_1
XTAP_TAPCELL_ROW_80_1409 VGND VPWR sky130_fd_sc_hd__tapvpwrvgnd_1
X_09436_ _02171_ _02172_ VGND VGND VPWR VPWR _02174_ sky130_fd_sc_hd__xnor2_2
XFILLER_24_121 VGND VGND VPWR VPWR sky130_fd_sc_hd__decap_4
XFILLER_25_666 VGND VGND VPWR VPWR sky130_fd_sc_hd__fill_1
XFILLER_80_772 VPWR VGND VPWR VGND sky130_ef_sc_hd__decap_12
XFILLER_24_165 VGND VGND VPWR VPWR sky130_fd_sc_hd__fill_1
X_09367_ net621 _02077_ net253 net97 VGND VGND VPWR VPWR _02099_ sky130_fd_sc_hd__and4_1
XFILLER_8_309 VPWR VGND VPWR VGND sky130_ef_sc_hd__decap_12
XFILLER_40_669 VGND VGND VPWR VPWR sky130_fd_sc_hd__fill_1
X_08318_ _00953_ _00956_ _00954_ VGND VGND VPWR VPWR _01052_ sky130_fd_sc_hd__a21oi_1
X_09298_ net357 net326 VGND VGND VPWR VPWR _02024_ sky130_fd_sc_hd__nand2_1
XPHY_EDGE_ROW_25_Left_162 VGND VGND VPWR VPWR sky130_fd_sc_hd__decap_3
X_08249_ _00964_ _00982_ VGND VGND VPWR VPWR _00984_ sky130_fd_sc_hd__xnor2_1
XFILLER_20_382 VGND VGND VPWR VPWR sky130_fd_sc_hd__fill_1
XTAP_TAPCELL_ROW_95_1630 VGND VPWR sky130_fd_sc_hd__tapvpwrvgnd_1
XFILLER_118_270 VPWR VGND VPWR VGND sky130_ef_sc_hd__decap_12
XFILLER_108_3 VPWR VGND VPWR VGND sky130_ef_sc_hd__decap_12
X_11260_ _04015_ _04019_ _04013_ VGND VGND VPWR VPWR _04160_ sky130_fd_sc_hd__o21a_1
XFILLER_133_240 VGND VGND VPWR VPWR sky130_fd_sc_hd__decap_4
X_10211_ _02835_ _02960_ VGND VGND VPWR VPWR _03014_ sky130_fd_sc_hd__nor2_1
X_11191_ _04076_ _04082_ VGND VGND VPWR VPWR _04084_ sky130_fd_sc_hd__xor2_1
XFILLER_97_69 VGND VGND VPWR VPWR sky130_fd_sc_hd__fill_1
XFILLER_79_349 VPWR VGND VPWR VGND sky130_ef_sc_hd__decap_12
XFILLER_79_327 VGND VGND VPWR VPWR sky130_fd_sc_hd__decap_8
X_10142_ _02929_ _02937_ VGND VGND VPWR VPWR _02938_ sky130_fd_sc_hd__xnor2_1
X_10073_ _02853_ _02862_ VGND VGND VPWR VPWR _02863_ sky130_fd_sc_hd__or2_1
Xoutput190 net190 VGND VGND VPWR VPWR out1[6] sky130_fd_sc_hd__buf_2
XTAP_TAPCELL_ROW_7_397 VGND VPWR sky130_fd_sc_hd__tapvpwrvgnd_1
XTAP_TAPCELL_ROW_7_386 VGND VPWR sky130_fd_sc_hd__tapvpwrvgnd_1
XPHY_EDGE_ROW_34_Left_171 VGND VGND VPWR VPWR sky130_fd_sc_hd__decap_3
XFILLER_87_393 VGND VGND VPWR VPWR sky130_fd_sc_hd__fill_1
XFILLER_48_747 VGND VGND VPWR VPWR sky130_fd_sc_hd__fill_1
XTAP_TAPCELL_ROW_122_2004 VGND VPWR sky130_fd_sc_hd__tapvpwrvgnd_1
XFILLER_47_279 VGND VGND VPWR VPWR sky130_fd_sc_hd__fill_1
XFILLER_28_460 VGND VGND VPWR VPWR sky130_fd_sc_hd__decap_8
XFILLER_56_780 VPWR VGND VPWR VGND sky130_ef_sc_hd__decap_12
XTAP_TAPCELL_ROW_46_937 VGND VPWR sky130_fd_sc_hd__tapvpwrvgnd_1
XFILLER_15_110 VGND VGND VPWR VPWR sky130_fd_sc_hd__fill_2
X_10975_ _03695_ _03846_ _03847_ VGND VGND VPWR VPWR _03848_ sky130_fd_sc_hd__nand3_1
XFILLER_16_666 VGND VGND VPWR VPWR sky130_fd_sc_hd__decap_6
X_12714_ _05742_ VGND VGND VPWR VPWR _05743_ sky130_fd_sc_hd__inv_2
XFILLER_43_496 VGND VGND VPWR VPWR sky130_fd_sc_hd__decap_8
XFILLER_15_187 VPWR VGND VPWR VGND sky130_ef_sc_hd__decap_12
XTAP_TAPCELL_ROW_26_661 VGND VPWR sky130_fd_sc_hd__tapvpwrvgnd_1
XFILLER_31_625 VGND VGND VPWR VPWR sky130_fd_sc_hd__decap_3
X_12645_ net541 net296 net294 net567 VGND VGND VPWR VPWR _05667_ sky130_fd_sc_hd__a22oi_1
XFILLER_30_124 VGND VGND VPWR VPWR sky130_fd_sc_hd__decap_3
XPHY_EDGE_ROW_43_Left_180 VGND VGND VPWR VPWR sky130_fd_sc_hd__decap_3
X_12576_ net413 net587 VGND VGND VPWR VPWR _05592_ sky130_fd_sc_hd__nand2_1
XFILLER_117_708 VGND VGND VPWR VPWR sky130_fd_sc_hd__decap_8
XTAP_TAPCELL_ROW_100_1689 VGND VPWR sky130_fd_sc_hd__tapvpwrvgnd_1
XFILLER_11_393 VPWR VGND VPWR VGND sky130_ef_sc_hd__decap_12
X_11527_ net401 _03586_ _04449_ VGND VGND VPWR VPWR _04451_ sky130_fd_sc_hd__o21ba_1
XTAP_TAPCELL_ROW_133_2155 VGND VPWR sky130_fd_sc_hd__tapvpwrvgnd_1
XFILLER_125_741 VPWR VGND VPWR VGND sky130_ef_sc_hd__decap_12
XFILLER_109_270 VGND VGND VPWR VPWR sky130_fd_sc_hd__fill_1
X_11458_ _04240_ _04375_ VGND VGND VPWR VPWR _04376_ sky130_fd_sc_hd__xnor2_1
XFILLER_125_785 VPWR VGND VPWR VGND sky130_ef_sc_hd__decap_12
X_10409_ _03227_ _03228_ VGND VGND VPWR VPWR _03229_ sky130_fd_sc_hd__or2_1
X_11389_ _04298_ _04299_ VGND VGND VPWR VPWR _04300_ sky130_fd_sc_hd__nand2_1
XFILLER_98_625 VPWR VGND VPWR VGND sky130_ef_sc_hd__decap_12
X_13128_ _06165_ _06195_ VGND VGND VPWR VPWR _06196_ sky130_fd_sc_hd__nor2_1
XFILLER_112_457 VGND VGND VPWR VPWR sky130_fd_sc_hd__decap_3
XFILLER_78_360 VGND VGND VPWR VPWR sky130_fd_sc_hd__decap_4
X_13059_ _06118_ _06119_ VGND VGND VPWR VPWR _06120_ sky130_fd_sc_hd__or2_1
XFILLER_93_330 VGND VGND VPWR VPWR sky130_fd_sc_hd__decap_6
X_07620_ _00212_ _00214_ VGND VGND VPWR VPWR _00360_ sky130_fd_sc_hd__nand2_1
XFILLER_81_514 VPWR VGND VPWR VGND sky130_ef_sc_hd__decap_12
XFILLER_54_728 VGND VGND VPWR VPWR sky130_fd_sc_hd__fill_2
XFILLER_26_419 VGND VGND VPWR VPWR sky130_fd_sc_hd__fill_1
X_07551_ net619 net305 VGND VGND VPWR VPWR _00291_ sky130_fd_sc_hd__nand2_1
XTAP_TAPCELL_ROW_66_1220 VGND VPWR sky130_fd_sc_hd__tapvpwrvgnd_1
XFILLER_81_558 VGND VGND VPWR VPWR sky130_fd_sc_hd__fill_2
X_07482_ _06593_ _00222_ VGND VGND VPWR VPWR _00223_ sky130_fd_sc_hd__xnor2_1
XFILLER_62_772 VGND VGND VPWR VPWR sky130_fd_sc_hd__decap_8
XFILLER_22_625 VPWR VGND VPWR VGND sky130_ef_sc_hd__decap_12
XFILLER_34_485 VGND VGND VPWR VPWR sky130_fd_sc_hd__fill_2
X_09221_ net572 _01785_ _01781_ VGND VGND VPWR VPWR _01945_ sky130_fd_sc_hd__a21oi_1
XFILLER_61_293 VGND VGND VPWR VPWR sky130_fd_sc_hd__decap_8
XFILLER_21_113 VGND VGND VPWR VPWR sky130_fd_sc_hd__decap_3
XFILLER_21_124 VPWR VGND VPWR VGND sky130_ef_sc_hd__decap_12
XFILLER_22_669 VGND VGND VPWR VPWR sky130_fd_sc_hd__decap_8
X_09152_ net785 net326 VGND VGND VPWR VPWR _01877_ sky130_fd_sc_hd__nand2_1
X_08103_ _00833_ _00837_ VGND VGND VPWR VPWR _00839_ sky130_fd_sc_hd__xor2_1
XFILLER_135_505 VPWR VGND VPWR VGND sky130_ef_sc_hd__decap_12
X_09083_ _02022_ net129 VGND VGND VPWR VPWR _01808_ sky130_fd_sc_hd__and2_1
Xinput70 w10[4] VGND VGND VPWR VPWR net70 sky130_fd_sc_hd__buf_1
X_08034_ _00749_ _00769_ VGND VGND VPWR VPWR _00771_ sky130_fd_sc_hd__xnor2_1
Xinput81 w11[7] VGND VGND VPWR VPWR net81 sky130_fd_sc_hd__clkbuf_4
XFILLER_115_251 VPWR VGND VPWR VGND sky130_ef_sc_hd__decap_12
Xinput92 w13[2] VGND VGND VPWR VPWR net92 sky130_fd_sc_hd__clkbuf_1
XTAP_TAPCELL_ROW_77_1371 VGND VPWR sky130_fd_sc_hd__tapvpwrvgnd_1
XFILLER_107_57 VGND VGND VPWR VPWR sky130_fd_sc_hd__decap_4
XFILLER_1_529 VPWR VGND VPWR VGND sky130_ef_sc_hd__decap_12
XFILLER_131_777 VGND VGND VPWR VPWR sky130_fd_sc_hd__decap_6
X_09985_ _02768_ _02769_ VGND VGND VPWR VPWR _02770_ sky130_fd_sc_hd__xnor2_1
XTAP_TAPCELL_ROW_90_1560 VGND VPWR sky130_fd_sc_hd__tapvpwrvgnd_1
X_08936_ _01659_ _01660_ _01656_ VGND VGND VPWR VPWR _01662_ sky130_fd_sc_hd__a21o_1
XFILLER_29_202 VPWR VGND VPWR VGND sky130_ef_sc_hd__decap_12
XFILLER_111_490 VPWR VGND VPWR VGND sky130_ef_sc_hd__decap_12
X_08867_ _01468_ _01485_ _01484_ VGND VGND VPWR VPWR _01593_ sky130_fd_sc_hd__o21bai_1
XFILLER_69_393 VGND VGND VPWR VPWR sky130_fd_sc_hd__decap_4
XTAP_TAPCELL_ROW_4_356 VGND VPWR sky130_fd_sc_hd__tapvpwrvgnd_1
XTAP_TAPCELL_ROW_4_345 VGND VPWR sky130_fd_sc_hd__tapvpwrvgnd_1
X_07818_ _00359_ _00413_ _00412_ VGND VGND VPWR VPWR _00557_ sky130_fd_sc_hd__a21bo_1
XFILLER_83_16 VPWR VGND VPWR VGND sky130_ef_sc_hd__decap_12
XFILLER_123_89 VGND VGND VPWR VPWR sky130_fd_sc_hd__fill_1
X_08798_ net448 net157 VGND VGND VPWR VPWR _01525_ sky130_fd_sc_hd__nand2_1
XFILLER_44_216 VGND VGND VPWR VPWR sky130_fd_sc_hd__decap_6
X_07749_ _00486_ _00487_ VGND VGND VPWR VPWR _00488_ sky130_fd_sc_hd__nand2_1
XFILLER_53_761 VPWR VGND VPWR VGND sky130_ef_sc_hd__decap_12
XFILLER_44_249 VGND VGND VPWR VPWR sky130_fd_sc_hd__decap_3
XFILLER_12_102 VGND VGND VPWR VPWR sky130_fd_sc_hd__decap_8
XFILLER_13_625 VGND VGND VPWR VPWR sky130_fd_sc_hd__fill_1
X_10760_ net416 net574 _03611_ _03612_ VGND VGND VPWR VPWR _03613_ sky130_fd_sc_hd__a22o_1
X_09419_ _01984_ _01990_ _01989_ VGND VGND VPWR VPWR _02156_ sky130_fd_sc_hd__a21oi_1
X_10691_ _03518_ _03536_ VGND VGND VPWR VPWR _03537_ sky130_fd_sc_hd__xnor2_1
XTAP_TAPCELL_ROW_23_620 VGND VPWR sky130_fd_sc_hd__tapvpwrvgnd_1
XFILLER_40_433 VGND VGND VPWR VPWR sky130_fd_sc_hd__decap_3
X_12430_ _05424_ _05432_ VGND VGND VPWR VPWR _05433_ sky130_fd_sc_hd__xor2_1
XFILLER_40_466 VGND VGND VPWR VPWR sky130_fd_sc_hd__decap_6
XFILLER_40_477 VPWR VGND VPWR VGND sky130_ef_sc_hd__decap_12
XFILLER_21_680 VPWR VGND VPWR VGND sky130_ef_sc_hd__decap_12
X_12361_ _05356_ _05355_ VGND VGND VPWR VPWR _05357_ sky130_fd_sc_hd__nand2b_1
XFILLER_32_75 VGND VGND VPWR VPWR sky130_fd_sc_hd__decap_8
XFILLER_32_97 VGND VGND VPWR VPWR sky130_fd_sc_hd__fill_1
X_12292_ _05076_ _05107_ _05106_ VGND VGND VPWR VPWR _05282_ sky130_fd_sc_hd__a21bo_1
XFILLER_4_301 VGND VGND VPWR VPWR sky130_fd_sc_hd__decap_6
X_11312_ _03589_ _04129_ net433 _03586_ VGND VGND VPWR VPWR _04216_ sky130_fd_sc_hd__o2bb2a_1
XFILLER_4_345 VPWR VGND VPWR VGND sky130_ef_sc_hd__decap_12
X_11243_ _04108_ _04140_ VGND VGND VPWR VPWR _04141_ sky130_fd_sc_hd__xnor2_1
XFILLER_107_785 VPWR VGND VPWR VGND sky130_ef_sc_hd__decap_12
XFILLER_106_273 VPWR VGND VPWR VGND sky130_ef_sc_hd__decap_12
XFILLER_4_389 VPWR VGND VPWR VGND sky130_ef_sc_hd__decap_12
XFILLER_68_809 VGND VGND VPWR VPWR sky130_fd_sc_hd__fill_2
X_11174_ net348 net346 net286 VGND VGND VPWR VPWR _04065_ sky130_fd_sc_hd__o21ai_1
XFILLER_67_308 VPWR VGND VPWR VGND sky130_ef_sc_hd__decap_12
X_10125_ _02918_ VGND VGND VPWR VPWR _02919_ sky130_fd_sc_hd__inv_2
XFILLER_48_500 VGND VGND VPWR VPWR sky130_fd_sc_hd__decap_4
XFILLER_94_138 VGND VGND VPWR VPWR sky130_fd_sc_hd__fill_2
X_10056_ _02803_ _02843_ VGND VGND VPWR VPWR _02844_ sky130_fd_sc_hd__nand2_1
XFILLER_48_533 VPWR VGND VPWR VGND sky130_ef_sc_hd__decap_12
XFILLER_90_300 VGND VGND VPWR VPWR sky130_fd_sc_hd__fill_2
XFILLER_16_441 VGND VGND VPWR VPWR sky130_fd_sc_hd__fill_1
XFILLER_35_249 VGND VGND VPWR VPWR sky130_fd_sc_hd__decap_3
XTAP_TAPCELL_ROW_102_1729 VGND VPWR sky130_fd_sc_hd__tapvpwrvgnd_1
XTAP_TAPCELL_ROW_102_1718 VGND VPWR sky130_fd_sc_hd__tapvpwrvgnd_1
XFILLER_16_452 VPWR VGND VPWR VGND sky130_ef_sc_hd__decap_12
X_10958_ _03820_ _03829_ VGND VGND VPWR VPWR _03830_ sky130_fd_sc_hd__xor2_1
XFILLER_92_6 VPWR VGND VPWR VGND sky130_ef_sc_hd__decap_12
XFILLER_16_496 VGND VGND VPWR VPWR sky130_fd_sc_hd__decap_4
XTAP_TAPCELL_ROW_61_1150 VGND VPWR sky130_fd_sc_hd__tapvpwrvgnd_1
X_12628_ _05495_ _05647_ _05649_ VGND VGND VPWR VPWR _05650_ sky130_fd_sc_hd__nand3_1
XFILLER_31_477 VGND VGND VPWR VPWR sky130_fd_sc_hd__decap_6
X_10889_ _03753_ VGND VGND VPWR VPWR _03754_ sky130_fd_sc_hd__inv_2
XFILLER_129_343 VGND VGND VPWR VPWR sky130_fd_sc_hd__decap_8
XFILLER_117_516 VPWR VGND VPWR VGND sky130_ef_sc_hd__decap_12
XFILLER_8_673 VPWR VGND VPWR VGND sky130_ef_sc_hd__decap_12
XFILLER_7_150 VPWR VGND VPWR VGND sky130_ef_sc_hd__decap_12
X_12559_ _05570_ _05572_ VGND VGND VPWR VPWR _05574_ sky130_fd_sc_hd__and2b_1
XPHY_EDGE_ROW_9_Right_9 VGND VGND VPWR VPWR sky130_fd_sc_hd__decap_3
Xfanout619 net620 VGND VGND VPWR VPWR net619 sky130_fd_sc_hd__buf_2
XFILLER_98_433 VGND VGND VPWR VPWR sky130_fd_sc_hd__decap_4
Xfanout608 net133 VGND VGND VPWR VPWR net608 sky130_fd_sc_hd__dlymetal6s2s_1
XPHY_EDGE_ROW_107_Right_107 VGND VGND VPWR VPWR sky130_fd_sc_hd__decap_3
X_06982_ _03904_ _05308_ VGND VGND VPWR VPWR _05330_ sky130_fd_sc_hd__nor2_1
XFILLER_86_617 VGND VGND VPWR VPWR sky130_fd_sc_hd__fill_1
X_09770_ _02526_ _02535_ VGND VGND VPWR VPWR _02537_ sky130_fd_sc_hd__xnor2_1
X_08721_ _01445_ _01446_ _01448_ VGND VGND VPWR VPWR _01449_ sky130_fd_sc_hd__nand3_1
XFILLER_85_138 VGND VGND VPWR VPWR sky130_fd_sc_hd__fill_1
XFILLER_39_533 VGND VGND VPWR VPWR sky130_fd_sc_hd__decap_3
X_08652_ net501 net634 _01379_ _01378_ _01220_ VGND VGND VPWR VPWR _01380_ sky130_fd_sc_hd__a32o_1
XFILLER_66_363 VGND VGND VPWR VPWR sky130_fd_sc_hd__fill_1
XTAP_TAPCELL_ROW_1_304 VGND VPWR sky130_fd_sc_hd__tapvpwrvgnd_1
XTAP_TAPCELL_ROW_1_315 VGND VPWR sky130_fd_sc_hd__tapvpwrvgnd_1
X_07603_ _00332_ _00342_ VGND VGND VPWR VPWR _00343_ sky130_fd_sc_hd__xor2_1
X_08583_ _01307_ _01309_ _01310_ VGND VGND VPWR VPWR _01312_ sky130_fd_sc_hd__or3_4
X_07534_ _06503_ _00272_ _00273_ VGND VGND VPWR VPWR _00275_ sky130_fd_sc_hd__or3_4
XFILLER_35_783 VGND VGND VPWR VPWR sky130_fd_sc_hd__fill_1
XFILLER_41_208 VGND VGND VPWR VPWR sky130_fd_sc_hd__fill_1
X_07465_ net612 net609 net402 VGND VGND VPWR VPWR _00206_ sky130_fd_sc_hd__and3_1
XFILLER_22_433 VPWR VGND VPWR VGND sky130_ef_sc_hd__decap_12
X_09204_ net621 net255 VGND VGND VPWR VPWR _01928_ sky130_fd_sc_hd__nand2_1
XFILLER_22_466 VGND VGND VPWR VPWR sky130_fd_sc_hd__decap_8
XFILLER_22_477 VGND VGND VPWR VPWR sky130_fd_sc_hd__decap_4
X_07396_ _00135_ _00136_ VGND VGND VPWR VPWR _00137_ sky130_fd_sc_hd__nand2b_1
XTAP_TAPCELL_ROW_79_1400 VGND VPWR sky130_fd_sc_hd__tapvpwrvgnd_1
Xrebuffer203 _02980_ VGND VGND VPWR VPWR net903 sky130_fd_sc_hd__dlymetal6s2s_1
Xrebuffer236 _04665_ VGND VGND VPWR VPWR net936 sky130_fd_sc_hd__buf_6
X_09135_ _01682_ _01859_ VGND VGND VPWR VPWR _01860_ sky130_fd_sc_hd__xnor2_1
XFILLER_135_335 VGND VGND VPWR VPWR sky130_fd_sc_hd__fill_1
X_09066_ _01789_ _01790_ VGND VGND VPWR VPWR _01791_ sky130_fd_sc_hd__xnor2_1
X_08017_ net490 _02153_ VGND VGND VPWR VPWR _00754_ sky130_fd_sc_hd__nor2_1
XTAP_TAPCELL_ROW_9_415 VGND VPWR sky130_fd_sc_hd__tapvpwrvgnd_1
XFILLER_2_805 VGND VGND VPWR VPWR sky130_fd_sc_hd__decap_6
XFILLER_89_400 VGND VGND VPWR VPWR sky130_fd_sc_hd__decap_3
XTAP_TAPCELL_ROW_9_426 VGND VPWR sky130_fd_sc_hd__tapvpwrvgnd_1
XFILLER_131_541 VPWR VGND VPWR VGND sky130_ef_sc_hd__decap_12
XFILLER_1_337 VPWR VGND VPWR VGND sky130_ef_sc_hd__decap_12
XFILLER_131_585 VPWR VGND VPWR VGND sky130_ef_sc_hd__decap_12
XFILLER_77_617 VPWR VGND VPWR VGND sky130_ef_sc_hd__decap_12
X_09968_ _02629_ _02636_ _02644_ VGND VGND VPWR VPWR _02752_ sky130_fd_sc_hd__a21oi_1
XFILLER_134_77 VGND VGND VPWR VPWR sky130_fd_sc_hd__decap_6
XFILLER_94_15 VGND VGND VPWR VPWR sky130_fd_sc_hd__decap_8
X_08919_ net464 net538 VGND VGND VPWR VPWR _01645_ sky130_fd_sc_hd__nand2_1
X_09899_ _02542_ _02569_ _02568_ VGND VGND VPWR VPWR _02678_ sky130_fd_sc_hd__a21oi_1
XFILLER_94_59 VGND VGND VPWR VPWR sky130_fd_sc_hd__decap_3
X_11930_ _04727_ _04728_ _04731_ _04722_ VGND VGND VPWR VPWR _04887_ sky130_fd_sc_hd__o22ai_1
XFILLER_45_503 VGND VGND VPWR VPWR sky130_fd_sc_hd__fill_1
XFILLER_57_385 VGND VGND VPWR VPWR sky130_fd_sc_hd__decap_6
X_11861_ _04811_ _04806_ net235 _04803_ VGND VGND VPWR VPWR _04812_ sky130_fd_sc_hd__a211oi_4
XFILLER_45_569 VPWR VGND VPWR VGND sky130_ef_sc_hd__decap_12
X_11792_ _04734_ _04735_ VGND VGND VPWR VPWR _04736_ sky130_fd_sc_hd__or2_1
X_10812_ _03669_ VGND VGND VPWR VPWR _03670_ sky130_fd_sc_hd__inv_2
XFILLER_26_783 VPWR VGND VPWR VGND sky130_ef_sc_hd__decap_12
XFILLER_25_293 VGND VGND VPWR VPWR sky130_fd_sc_hd__decap_8
X_10743_ _03583_ _03593_ VGND VGND VPWR VPWR _03594_ sky130_fd_sc_hd__xor2_1
XFILLER_43_30 VGND VGND VPWR VPWR sky130_fd_sc_hd__fill_1
XFILLER_43_41 VPWR VGND VPWR VGND sky130_ef_sc_hd__decap_12
XFILLER_13_466 VPWR VGND VPWR VGND sky130_ef_sc_hd__decap_12
XFILLER_41_753 VPWR VGND VPWR VGND sky130_ef_sc_hd__decap_12
X_10674_ _03516_ _03517_ VGND VGND VPWR VPWR _03518_ sky130_fd_sc_hd__or2_1
X_13393_ clknet_3_0__leaf_clk _00022_ _00103_ VGND VGND VPWR VPWR net207 sky130_fd_sc_hd__dfrtp_1
X_12413_ _02011_ net360 _05235_ _05233_ VGND VGND VPWR VPWR _05414_ sky130_fd_sc_hd__a31o_1
X_12344_ _05190_ _05200_ _05198_ VGND VGND VPWR VPWR _05338_ sky130_fd_sc_hd__a21bo_1
XTAP_TAPCELL_ROW_130_2114 VGND VPWR sky130_fd_sc_hd__tapvpwrvgnd_1
XFILLER_5_665 VGND VGND VPWR VPWR sky130_fd_sc_hd__decap_6
XFILLER_4_153 VPWR VGND VPWR VGND sky130_ef_sc_hd__decap_12
X_12275_ net81 net360 VGND VGND VPWR VPWR _05263_ sky130_fd_sc_hd__and2_1
XFILLER_4_197 VPWR VGND VPWR VGND sky130_ef_sc_hd__decap_12
X_11226_ _04121_ _04115_ VGND VGND VPWR VPWR _04122_ sky130_fd_sc_hd__and2b_1
XFILLER_68_617 VPWR VGND VPWR VGND sky130_ef_sc_hd__decap_12
X_11157_ _03890_ _03894_ _03892_ VGND VGND VPWR VPWR _04047_ sky130_fd_sc_hd__a21bo_1
XFILLER_95_447 VGND VGND VPWR VPWR sky130_fd_sc_hd__fill_1
X_10108_ net664 net279 _02897_ _02898_ VGND VGND VPWR VPWR _02901_ sky130_fd_sc_hd__o2bb2a_1
XFILLER_110_769 VPWR VGND VPWR VGND sky130_ef_sc_hd__decap_12
X_11088_ _03820_ _03829_ _03827_ VGND VGND VPWR VPWR _03972_ sky130_fd_sc_hd__a21boi_2
XTAP_TAPCELL_ROW_128_2087 VGND VPWR sky130_fd_sc_hd__tapvpwrvgnd_1
XFILLER_76_683 VGND VGND VPWR VPWR sky130_fd_sc_hd__decap_3
X_10039_ _02821_ _02825_ VGND VGND VPWR VPWR _02826_ sky130_fd_sc_hd__xnor2_1
XFILLER_48_363 VGND VGND VPWR VPWR sky130_fd_sc_hd__fill_1
XFILLER_63_344 VPWR VGND VPWR VGND sky130_ef_sc_hd__decap_12
XFILLER_36_569 VGND VGND VPWR VPWR sky130_fd_sc_hd__fill_1
XFILLER_17_783 VGND VGND VPWR VPWR sky130_fd_sc_hd__fill_1
XFILLER_32_753 VGND VGND VPWR VPWR sky130_fd_sc_hd__decap_3
XFILLER_32_775 VPWR VGND VPWR VGND sky130_ef_sc_hd__decap_12
X_07250_ _06390_ _06540_ VGND VGND VPWR VPWR _06541_ sky130_fd_sc_hd__xor2_1
XFILLER_31_274 VGND VGND VPWR VPWR sky130_fd_sc_hd__decap_6
X_07181_ _06470_ _06471_ _06463_ VGND VGND VPWR VPWR _06473_ sky130_fd_sc_hd__a21o_1
XTAP_TAPCELL_ROW_14_494 VGND VPWR sky130_fd_sc_hd__tapvpwrvgnd_1
XFILLER_117_335 VGND VGND VPWR VPWR sky130_fd_sc_hd__fill_1
XTAP_TAPCELL_ROW_115_1909 VGND VPWR sky130_fd_sc_hd__tapvpwrvgnd_1
XFILLER_117_346 VGND VGND VPWR VPWR sky130_fd_sc_hd__fill_1
XTAP_TAPCELL_ROW_74_1330 VGND VPWR sky130_fd_sc_hd__tapvpwrvgnd_1
XFILLER_113_530 VPWR VGND VPWR VGND sky130_ef_sc_hd__decap_12
Xfanout405 net32 VGND VGND VPWR VPWR net405 sky130_fd_sc_hd__buf_2
X_09822_ _02111_ _02593_ VGND VGND VPWR VPWR _02594_ sky130_fd_sc_hd__nand2_1
XFILLER_86_403 VGND VGND VPWR VPWR sky130_fd_sc_hd__decap_4
Xfanout427 net742 VGND VGND VPWR VPWR net427 sky130_fd_sc_hd__clkbuf_4
XFILLER_59_617 VPWR VGND VPWR VGND sky130_ef_sc_hd__decap_12
Xfanout438 net440 VGND VGND VPWR VPWR net438 sky130_fd_sc_hd__clkbuf_4
Xfanout416 net417 VGND VGND VPWR VPWR net416 sky130_fd_sc_hd__buf_2
Xfanout449 net28 VGND VGND VPWR VPWR net449 sky130_fd_sc_hd__buf_2
X_09753_ _02513_ _02517_ VGND VGND VPWR VPWR _02518_ sky130_fd_sc_hd__xor2_1
X_06965_ _03368_ _05133_ VGND VGND VPWR VPWR _05144_ sky130_fd_sc_hd__nand2_1
X_08704_ _01403_ _01404_ _01430_ _01431_ VGND VGND VPWR VPWR _01432_ sky130_fd_sc_hd__nor4_2
X_09684_ _02417_ _02442_ VGND VGND VPWR VPWR _02443_ sky130_fd_sc_hd__xor2_1
X_06896_ _04156_ _04374_ _04385_ VGND VGND VPWR VPWR _04396_ sky130_fd_sc_hd__or3_4
XFILLER_39_374 VGND VGND VPWR VPWR sky130_fd_sc_hd__decap_8
X_08635_ _01230_ _01361_ VGND VGND VPWR VPWR _01363_ sky130_fd_sc_hd__xnor2_1
XFILLER_82_642 VGND VGND VPWR VPWR sky130_fd_sc_hd__fill_2
XFILLER_64_29 VGND VGND VPWR VPWR sky130_fd_sc_hd__fill_2
XFILLER_27_569 VGND VGND VPWR VPWR sky130_fd_sc_hd__decap_3
X_08566_ _01131_ _01285_ _01293_ VGND VGND VPWR VPWR _01295_ sky130_fd_sc_hd__nand3_1
XFILLER_42_517 VGND VGND VPWR VPWR sky130_fd_sc_hd__decap_4
XFILLER_42_528 VGND VGND VPWR VPWR sky130_fd_sc_hd__decap_4
X_07517_ _00253_ _00255_ _06635_ _06637_ VGND VGND VPWR VPWR _00258_ sky130_fd_sc_hd__o211ai_1
XTAP_TAPCELL_ROW_85_1481 VGND VPWR sky130_fd_sc_hd__tapvpwrvgnd_1
XFILLER_42_539 VGND VGND VPWR VPWR sky130_fd_sc_hd__decap_6
X_08497_ _01223_ _01225_ VGND VGND VPWR VPWR _01226_ sky130_fd_sc_hd__xor2_2
XFILLER_22_241 VGND VGND VPWR VPWR sky130_fd_sc_hd__decap_8
XFILLER_23_753 VGND VGND VPWR VPWR sky130_fd_sc_hd__decap_8
X_07448_ _00182_ _00188_ VGND VGND VPWR VPWR _00189_ sky130_fd_sc_hd__and2_1
XFILLER_23_797 VPWR VGND VPWR VGND sky130_ef_sc_hd__decap_12
X_07379_ _06667_ _06668_ VGND VGND VPWR VPWR _06669_ sky130_fd_sc_hd__nor2_1
XFILLER_13_55 VGND VGND VPWR VPWR sky130_fd_sc_hd__fill_1
XFILLER_13_66 VPWR VGND VPWR VGND sky130_ef_sc_hd__decap_12
XFILLER_129_55 VGND VGND VPWR VPWR sky130_fd_sc_hd__fill_1
X_09118_ _01841_ _01842_ VGND VGND VPWR VPWR _01843_ sky130_fd_sc_hd__xnor2_1
XFILLER_89_26 VGND VGND VPWR VPWR sky130_fd_sc_hd__decap_8
X_10390_ net616 net279 VGND VGND VPWR VPWR _03209_ sky130_fd_sc_hd__nand2_1
XFILLER_136_699 VGND VGND VPWR VPWR sky130_fd_sc_hd__fill_1
XFILLER_123_305 VPWR VGND VPWR VGND sky130_ef_sc_hd__decap_12
X_09049_ _01604_ _01612_ _01611_ VGND VGND VPWR VPWR _01774_ sky130_fd_sc_hd__a21bo_1
XFILLER_2_613 VPWR VGND VPWR VGND sky130_ef_sc_hd__decap_12
X_12060_ _05027_ _05028_ VGND VGND VPWR VPWR _05029_ sky130_fd_sc_hd__or2_1
XFILLER_2_657 VPWR VGND VPWR VGND sky130_ef_sc_hd__decap_12
XFILLER_131_360 VGND VGND VPWR VPWR sky130_fd_sc_hd__fill_2
XPHY_EDGE_ROW_8_Left_145 VGND VGND VPWR VPWR sky130_fd_sc_hd__decap_3
XFILLER_1_167 VGND VGND VPWR VPWR sky130_fd_sc_hd__fill_1
X_11011_ _03722_ net247 _03727_ VGND VGND VPWR VPWR _03887_ sky130_fd_sc_hd__a21o_1
XFILLER_131_393 VPWR VGND VPWR VGND sky130_ef_sc_hd__decap_12
XFILLER_131_382 VGND VGND VPWR VPWR sky130_fd_sc_hd__decap_8
XFILLER_100_780 VGND VGND VPWR VPWR sky130_fd_sc_hd__fill_1
XFILLER_18_525 VGND VGND VPWR VPWR sky130_fd_sc_hd__decap_6
X_12962_ _06012_ _06013_ VGND VGND VPWR VPWR _06014_ sky130_fd_sc_hd__xnor2_1
XFILLER_100_791 VPWR VGND VPWR VGND sky130_ef_sc_hd__decap_12
XFILLER_73_653 VGND VGND VPWR VPWR sky130_fd_sc_hd__decap_8
X_11913_ _04866_ _04867_ VGND VGND VPWR VPWR _04868_ sky130_fd_sc_hd__and2b_1
X_12893_ _05905_ _05938_ VGND VGND VPWR VPWR _05939_ sky130_fd_sc_hd__nor2_1
XFILLER_72_141 VGND VGND VPWR VPWR sky130_fd_sc_hd__decap_6
X_11844_ net447 net601 VGND VGND VPWR VPWR _04793_ sky130_fd_sc_hd__and2_1
XFILLER_14_720 VGND VGND VPWR VPWR sky130_fd_sc_hd__decap_8
XFILLER_33_539 VGND VGND VPWR VPWR sky130_fd_sc_hd__decap_8
X_11775_ _04715_ _04716_ VGND VGND VPWR VPWR _04717_ sky130_fd_sc_hd__nor2_1
XFILLER_41_561 VGND VGND VPWR VPWR sky130_fd_sc_hd__decap_6
XFILLER_9_201 VPWR VGND VPWR VGND sky130_ef_sc_hd__decap_12
XFILLER_13_263 VGND VGND VPWR VPWR sky130_fd_sc_hd__decap_4
XFILLER_13_274 VGND VGND VPWR VPWR sky130_fd_sc_hd__decap_6
XTAP_TAPCELL_ROW_31_729 VGND VPWR sky130_fd_sc_hd__tapvpwrvgnd_1
X_10726_ _03573_ _03574_ VGND VGND VPWR VPWR _03575_ sky130_fd_sc_hd__and2b_1
X_10657_ _03320_ _03322_ VGND VGND VPWR VPWR _03501_ sky130_fd_sc_hd__nand2_1
XFILLER_70_83 VGND VGND VPWR VPWR sky130_fd_sc_hd__fill_1
XTAP_TAPCELL_ROW_11_453 VGND VPWR sky130_fd_sc_hd__tapvpwrvgnd_1
XTAP_TAPCELL_ROW_11_442 VGND VPWR sky130_fd_sc_hd__tapvpwrvgnd_1
XFILLER_127_644 VPWR VGND VPWR VGND sky130_ef_sc_hd__decap_12
X_13376_ clknet_3_4__leaf_clk _00034_ _00086_ VGND VGND VPWR VPWR net190 sky130_fd_sc_hd__dfrtp_1
XFILLER_62_7 VGND VGND VPWR VPWR sky130_fd_sc_hd__decap_8
X_10588_ _03269_ _03272_ VGND VGND VPWR VPWR _03425_ sky130_fd_sc_hd__nand2_1
XFILLER_5_473 VPWR VGND VPWR VGND sky130_ef_sc_hd__decap_12
X_12327_ net665 net285 _02273_ net690 VGND VGND VPWR VPWR _05320_ sky130_fd_sc_hd__o2bb2a_1
X_12258_ _05082_ _05244_ VGND VGND VPWR VPWR _05245_ sky130_fd_sc_hd__nor2_1
XTAP_TAPCELL_ROW_110_1839 VGND VPWR sky130_fd_sc_hd__tapvpwrvgnd_1
XTAP_TAPCELL_ROW_110_1828 VGND VPWR sky130_fd_sc_hd__tapvpwrvgnd_1
XFILLER_96_701 VPWR VGND VPWR VGND sky130_ef_sc_hd__decap_12
XFILLER_68_403 VGND VGND VPWR VPWR sky130_fd_sc_hd__fill_1
XTAP_TAPCELL_ROW_56_1082 VGND VPWR sky130_fd_sc_hd__tapvpwrvgnd_1
X_11209_ _04091_ _04102_ VGND VGND VPWR VPWR _04104_ sky130_fd_sc_hd__xnor2_1
XFILLER_110_533 VPWR VGND VPWR VGND sky130_ef_sc_hd__decap_12
XFILLER_95_211 VGND VGND VPWR VPWR sky130_fd_sc_hd__fill_2
X_12189_ _05164_ _05168_ VGND VGND VPWR VPWR _05169_ sky130_fd_sc_hd__xnor2_1
XFILLER_95_266 VGND VGND VPWR VPWR sky130_fd_sc_hd__fill_2
XFILLER_68_458 VPWR VGND VPWR VGND sky130_ef_sc_hd__decap_12
XFILLER_95_299 VPWR VGND VPWR VGND sky130_ef_sc_hd__decap_12
X_06750_ net613 net452 VGND VGND VPWR VPWR _02802_ sky130_fd_sc_hd__nand2_1
XFILLER_49_694 VPWR VGND VPWR VGND sky130_ef_sc_hd__decap_12
X_06681_ net663 VGND VGND VPWR VPWR _02055_ sky130_fd_sc_hd__clkinv_4
X_08420_ _01113_ _01149_ VGND VGND VPWR VPWR _01150_ sky130_fd_sc_hd__xor2_1
XFILLER_64_664 VGND VGND VPWR VPWR sky130_fd_sc_hd__decap_8
XTAP_TAPCELL_ROW_19_564 VGND VPWR sky130_fd_sc_hd__tapvpwrvgnd_1
XFILLER_36_355 VGND VGND VPWR VPWR sky130_fd_sc_hd__fill_1
X_08351_ _03216_ _05025_ VGND VGND VPWR VPWR _01084_ sky130_fd_sc_hd__xor2_1
X_08282_ _00987_ _01016_ VGND VGND VPWR VPWR _01017_ sky130_fd_sc_hd__nand2b_1
X_07302_ net427 net40 VGND VGND VPWR VPWR _06593_ sky130_fd_sc_hd__nand2_1
XFILLER_20_701 VGND VGND VPWR VPWR sky130_fd_sc_hd__decap_3
X_07233_ _06521_ _06522_ VGND VGND VPWR VPWR _06524_ sky130_fd_sc_hd__xnor2_1
XFILLER_118_666 VGND VGND VPWR VPWR sky130_fd_sc_hd__decap_4
X_07164_ _06454_ _06455_ VGND VGND VPWR VPWR _06456_ sky130_fd_sc_hd__nor2_1
X_07095_ net318 net619 VGND VGND VPWR VPWR _06387_ sky130_fd_sc_hd__nand2_1
XFILLER_99_561 VPWR VGND VPWR VGND sky130_ef_sc_hd__decap_12
Xfanout257 net94 VGND VGND VPWR VPWR net257 sky130_fd_sc_hd__dlymetal6s2s_1
XFILLER_115_79 VGND VGND VPWR VPWR sky130_fd_sc_hd__fill_1
XFILLER_115_57 VGND VGND VPWR VPWR sky130_fd_sc_hd__decap_3
X_09805_ _02464_ _02477_ _02476_ VGND VGND VPWR VPWR _02575_ sky130_fd_sc_hd__o21ba_1
XFILLER_101_555 VGND VGND VPWR VPWR sky130_fd_sc_hd__fill_1
X_07997_ net605 net603 net402 VGND VGND VPWR VPWR _00734_ sky130_fd_sc_hd__o21ai_1
XFILLER_86_244 VGND VGND VPWR VPWR sky130_fd_sc_hd__decap_8
Xfanout268 net9 VGND VGND VPWR VPWR net268 sky130_fd_sc_hd__buf_2
Xfanout279 net84 VGND VGND VPWR VPWR net279 sky130_fd_sc_hd__buf_2
X_09736_ _02231_ _02370_ VGND VGND VPWR VPWR _02500_ sky130_fd_sc_hd__and2_1
X_06948_ _04872_ _04905_ _04894_ VGND VGND VPWR VPWR _04960_ sky130_fd_sc_hd__o21ba_1
XTAP_TAPCELL_ROW_87_1510 VGND VPWR sky130_fd_sc_hd__tapvpwrvgnd_1
XFILLER_74_417 VGND VGND VPWR VPWR sky130_fd_sc_hd__decap_3
X_09667_ _02087_ net624 _02422_ VGND VGND VPWR VPWR _02425_ sky130_fd_sc_hd__and3_1
X_08618_ _01178_ _01345_ VGND VGND VPWR VPWR _01346_ sky130_fd_sc_hd__nand2_1
X_06879_ net34 net388 net752 net771 VGND VGND VPWR VPWR _04210_ sky130_fd_sc_hd__nand4_1
XFILLER_54_141 VPWR VGND VPWR VGND sky130_ef_sc_hd__decap_12
XFILLER_42_303 VGND VGND VPWR VPWR sky130_fd_sc_hd__decap_4
X_09598_ _02323_ _02350_ VGND VGND VPWR VPWR _02351_ sky130_fd_sc_hd__and2b_1
XFILLER_54_185 VGND VGND VPWR VPWR sky130_fd_sc_hd__fill_1
X_08549_ _01269_ _01270_ _01276_ VGND VGND VPWR VPWR _01278_ sky130_fd_sc_hd__a21o_1
X_11560_ _03889_ _04486_ VGND VGND VPWR VPWR _04487_ sky130_fd_sc_hd__xnor2_1
X_10511_ _03338_ _03339_ VGND VGND VPWR VPWR _03340_ sky130_fd_sc_hd__nand2b_1
XFILLER_109_611 VGND VGND VPWR VPWR sky130_fd_sc_hd__decap_4
XFILLER_7_727 VGND VGND VPWR VPWR sky130_fd_sc_hd__fill_1
X_13230_ _06196_ _06198_ _06305_ VGND VGND VPWR VPWR _06307_ sky130_fd_sc_hd__or3b_1
X_11491_ _04281_ _04283_ _04411_ VGND VGND VPWR VPWR _04412_ sky130_fd_sc_hd__a21oi_1
XFILLER_136_441 VGND VGND VPWR VPWR sky130_fd_sc_hd__decap_3
XFILLER_109_655 VPWR VGND VPWR VGND sky130_ef_sc_hd__decap_12
XTAP_TAPCELL_ROW_98_1672 VGND VPWR sky130_fd_sc_hd__tapvpwrvgnd_1
XTAP_TAPCELL_ROW_98_1661 VGND VPWR sky130_fd_sc_hd__tapvpwrvgnd_1
XFILLER_10_288 VPWR VGND VPWR VGND sky130_ef_sc_hd__decap_12
X_10442_ net417 net577 net576 net434 VGND VGND VPWR VPWR _03265_ sky130_fd_sc_hd__a22oi_2
XFILLER_124_614 VPWR VGND VPWR VGND sky130_ef_sc_hd__decap_12
X_10373_ _03188_ _03189_ VGND VGND VPWR VPWR _03190_ sky130_fd_sc_hd__nor2_1
X_13161_ _06097_ _06109_ _06094_ VGND VGND VPWR VPWR _06231_ sky130_fd_sc_hd__o21ai_1
XFILLER_40_75 VGND VGND VPWR VPWR sky130_fd_sc_hd__decap_8
XFILLER_40_97 VPWR VGND VPWR VGND sky130_ef_sc_hd__decap_12
XFILLER_108_187 VGND VGND VPWR VPWR sky130_fd_sc_hd__decap_8
XFILLER_2_421 VPWR VGND VPWR VGND sky130_ef_sc_hd__decap_12
X_13092_ _06132_ _06154_ VGND VGND VPWR VPWR _06156_ sky130_fd_sc_hd__xnor2_1
X_12112_ net428 net379 net367 net365 VGND VGND VPWR VPWR _05085_ sky130_fd_sc_hd__and4_1
XFILLER_111_308 VPWR VGND VPWR VGND sky130_ef_sc_hd__decap_12
XFILLER_78_701 VGND VGND VPWR VPWR sky130_fd_sc_hd__decap_4
X_12043_ net640 net298 _04867_ _04866_ VGND VGND VPWR VPWR _05010_ sky130_fd_sc_hd__a31o_1
XFILLER_104_371 VGND VGND VPWR VPWR sky130_fd_sc_hd__decap_8
XFILLER_78_723 VGND VGND VPWR VPWR sky130_fd_sc_hd__decap_3
XFILLER_49_95 VPWR VGND VPWR VGND sky130_ef_sc_hd__decap_12
XFILLER_77_277 VGND VGND VPWR VPWR sky130_fd_sc_hd__decap_3
XFILLER_77_266 VGND VGND VPWR VPWR sky130_fd_sc_hd__decap_4
XTAP_TAPCELL_ROW_125_2046 VGND VPWR sky130_fd_sc_hd__tapvpwrvgnd_1
XFILLER_1_69 VPWR VGND VPWR VGND sky130_ef_sc_hd__decap_12
XFILLER_45_141 VPWR VGND VPWR VGND sky130_ef_sc_hd__decap_12
X_12945_ net412 _05994_ _05993_ VGND VGND VPWR VPWR _05995_ sky130_fd_sc_hd__a21o_1
XFILLER_18_377 VPWR VGND VPWR VGND sky130_ef_sc_hd__decap_12
XFILLER_45_174 VGND VGND VPWR VPWR sky130_fd_sc_hd__decap_8
XTAP_TAPCELL_ROW_16_512 VGND VPWR sky130_fd_sc_hd__tapvpwrvgnd_1
XTAP_TAPCELL_ROW_16_523 VGND VPWR sky130_fd_sc_hd__tapvpwrvgnd_1
X_12876_ _05919_ _05914_ VGND VGND VPWR VPWR _05920_ sky130_fd_sc_hd__nand2b_1
XTAP_TAPCELL_ROW_107_1790 VGND VPWR sky130_fd_sc_hd__tapvpwrvgnd_1
X_11827_ _04771_ _04772_ _04770_ VGND VGND VPWR VPWR _04775_ sky130_fd_sc_hd__o21bai_1
X_11758_ _04681_ _04687_ VGND VGND VPWR VPWR _04699_ sky130_fd_sc_hd__xnor2_1
XFILLER_60_166 VGND VGND VPWR VPWR sky130_fd_sc_hd__fill_1
X_10709_ _03212_ _03373_ _03372_ VGND VGND VPWR VPWR _03557_ sky130_fd_sc_hd__o21a_1
X_11689_ net456 net600 _04622_ VGND VGND VPWR VPWR _04624_ sky130_fd_sc_hd__and3_1
XTAP_TAPCELL_ROW_136_2197 VGND VPWR sky130_fd_sc_hd__tapvpwrvgnd_1
XTAP_TAPCELL_ROW_58_1100 VGND VPWR sky130_fd_sc_hd__tapvpwrvgnd_1
X_13359_ clknet_3_3__leaf_clk _00046_ _00069_ VGND VGND VPWR VPWR net173 sky130_fd_sc_hd__dfrtp_1
XFILLER_127_485 VPWR VGND VPWR VGND sky130_ef_sc_hd__decap_12
XTAP_TAPCELL_ROW_58_1111 VGND VPWR sky130_fd_sc_hd__tapvpwrvgnd_1
XFILLER_6_793 VPWR VGND VPWR VGND sky130_ef_sc_hd__decap_12
XFILLER_5_281 VPWR VGND VPWR VGND sky130_ef_sc_hd__decap_12
XFILLER_114_168 VPWR VGND VPWR VGND sky130_ef_sc_hd__decap_12
X_07920_ _00492_ _00503_ _00502_ VGND VGND VPWR VPWR _00658_ sky130_fd_sc_hd__o21a_1
XFILLER_69_723 VGND VGND VPWR VPWR sky130_fd_sc_hd__decap_4
X_07851_ _00588_ VGND VGND VPWR VPWR _00589_ sky130_fd_sc_hd__inv_2
XFILLER_69_767 VGND VGND VPWR VPWR sky130_fd_sc_hd__fill_1
X_06802_ net268 net688 net317 net306 VGND VGND VPWR VPWR _03368_ sky130_fd_sc_hd__and4_1
XFILLER_110_385 VGND VGND VPWR VPWR sky130_fd_sc_hd__fill_1
X_07782_ net749 net374 VGND VGND VPWR VPWR _00521_ sky130_fd_sc_hd__nand2_1
Xinput2 in0[1] VGND VGND VPWR VPWR net2 sky130_fd_sc_hd__clkbuf_1
XFILLER_56_417 VGND VGND VPWR VPWR sky130_fd_sc_hd__decap_3
X_06733_ _02599_ _02610_ VGND VGND VPWR VPWR _02621_ sky130_fd_sc_hd__nand2_1
X_09521_ _02110_ _02265_ VGND VGND VPWR VPWR _02267_ sky130_fd_sc_hd__xnor2_1
XFILLER_83_225 VGND VGND VPWR VPWR sky130_fd_sc_hd__decap_3
XTAP_TAPCELL_ROW_69_1262 VGND VPWR sky130_fd_sc_hd__tapvpwrvgnd_1
XFILLER_36_141 VPWR VGND VPWR VGND sky130_ef_sc_hd__decap_12
XFILLER_37_653 VPWR VGND VPWR VGND sky130_ef_sc_hd__decap_12
X_09452_ _02039_ _02048_ _02047_ VGND VGND VPWR VPWR _02192_ sky130_fd_sc_hd__a21o_1
XFILLER_52_645 VGND VGND VPWR VPWR sky130_fd_sc_hd__decap_4
XFILLER_51_100 VGND VGND VPWR VPWR sky130_fd_sc_hd__decap_6
X_09383_ _02108_ _02115_ VGND VGND VPWR VPWR _02116_ sky130_fd_sc_hd__and2_1
XFILLER_101_37 VGND VGND VPWR VPWR sky130_fd_sc_hd__decap_4
XTAP_TAPCELL_ROW_82_1440 VGND VPWR sky130_fd_sc_hd__tapvpwrvgnd_1
X_08403_ _01098_ _01132_ VGND VGND VPWR VPWR _01133_ sky130_fd_sc_hd__xnor2_1
X_08334_ _01063_ _01065_ VGND VGND VPWR VPWR _01068_ sky130_fd_sc_hd__xnor2_1
XFILLER_51_166 VGND VGND VPWR VPWR sky130_fd_sc_hd__fill_2
XFILLER_51_199 VPWR VGND VPWR VGND sky130_ef_sc_hd__decap_12
XFILLER_20_531 VGND VGND VPWR VPWR sky130_fd_sc_hd__fill_1
XFILLER_32_380 VGND VGND VPWR VPWR sky130_fd_sc_hd__decap_4
X_08265_ _00865_ _00866_ _00863_ VGND VGND VPWR VPWR _01000_ sky130_fd_sc_hd__a21o_1
XFILLER_20_553 VPWR VGND VPWR VGND sky130_ef_sc_hd__decap_12
X_07216_ net687 net667 net71 net304 VGND VGND VPWR VPWR _06507_ sky130_fd_sc_hd__and4_1
X_08196_ _00927_ _00931_ VGND VGND VPWR VPWR _00932_ sky130_fd_sc_hd__xnor2_1
XPHY_EDGE_ROW_89_Left_226 VGND VGND VPWR VPWR sky130_fd_sc_hd__decap_3
XFILLER_20_586 VGND VGND VPWR VPWR sky130_fd_sc_hd__fill_2
X_07147_ net609 net419 VGND VGND VPWR VPWR _06439_ sky130_fd_sc_hd__nand2_1
XFILLER_105_113 VGND VGND VPWR VPWR sky130_fd_sc_hd__decap_8
X_07078_ _06356_ _06367_ VGND VGND VPWR VPWR _06370_ sky130_fd_sc_hd__nor2_1
XTAP_TAPCELL_ROW_93_1591 VGND VPWR sky130_fd_sc_hd__tapvpwrvgnd_1
XFILLER_86_27 VGND VGND VPWR VPWR sky130_fd_sc_hd__fill_1
XFILLER_59_222 VGND VGND VPWR VPWR sky130_fd_sc_hd__fill_2
XFILLER_75_704 VGND VGND VPWR VPWR sky130_fd_sc_hd__fill_2
XFILLER_87_575 VGND VGND VPWR VPWR sky130_fd_sc_hd__decap_8
XFILLER_75_726 VGND VGND VPWR VPWR sky130_fd_sc_hd__fill_2
XFILLER_59_288 VPWR VGND VPWR VGND sky130_ef_sc_hd__decap_12
XFILLER_19_43 VPWR VGND VPWR VGND sky130_ef_sc_hd__decap_12
XPHY_EDGE_ROW_98_Left_235 VGND VGND VPWR VPWR sky130_fd_sc_hd__decap_3
X_09719_ _02481_ _02449_ VGND VGND VPWR VPWR _02482_ sky130_fd_sc_hd__and2b_1
X_10991_ _03863_ _03864_ VGND VGND VPWR VPWR _03865_ sky130_fd_sc_hd__nor2_1
X_12730_ _05759_ _05760_ VGND VGND VPWR VPWR _05761_ sky130_fd_sc_hd__xnor2_1
XFILLER_43_678 VPWR VGND VPWR VGND sky130_ef_sc_hd__decap_12
XFILLER_15_358 VPWR VGND VPWR VGND sky130_ef_sc_hd__decap_12
XFILLER_35_75 VGND VGND VPWR VPWR sky130_fd_sc_hd__fill_1
X_12661_ _05507_ _05684_ VGND VGND VPWR VPWR _05685_ sky130_fd_sc_hd__xnor2_1
X_11612_ _04524_ _04542_ VGND VGND VPWR VPWR _04543_ sky130_fd_sc_hd__xnor2_1
XFILLER_30_306 VGND VGND VPWR VPWR sky130_fd_sc_hd__fill_2
X_12592_ _05434_ _05435_ _05609_ VGND VGND VPWR VPWR _05610_ sky130_fd_sc_hd__a21oi_1
XFILLER_30_339 VGND VGND VPWR VPWR sky130_fd_sc_hd__decap_3
XFILLER_128_205 VGND VGND VPWR VPWR sky130_fd_sc_hd__fill_2
XFILLER_11_575 VPWR VGND VPWR VGND sky130_ef_sc_hd__decap_12
X_11543_ _04467_ _04466_ VGND VGND VPWR VPWR _04468_ sky130_fd_sc_hd__and2b_1
XTAP_TAPCELL_ROW_41_868 VGND VPWR sky130_fd_sc_hd__tapvpwrvgnd_1
X_11474_ _04364_ _04392_ VGND VGND VPWR VPWR _04393_ sky130_fd_sc_hd__nor2_1
X_10425_ net504 net489 net655 _02933_ VGND VGND VPWR VPWR _03246_ sky130_fd_sc_hd__o211a_1
X_13213_ _06283_ _06287_ VGND VGND VPWR VPWR _06288_ sky130_fd_sc_hd__xnor2_1
XTAP_TAPCELL_ROW_21_592 VGND VPWR sky130_fd_sc_hd__tapvpwrvgnd_1
XFILLER_136_293 VGND VGND VPWR VPWR sky130_fd_sc_hd__decap_4
XFILLER_124_433 VPWR VGND VPWR VGND sky130_ef_sc_hd__decap_12
XFILLER_124_411 VGND VGND VPWR VPWR sky130_fd_sc_hd__decap_8
X_13144_ _06210_ _06211_ VGND VGND VPWR VPWR _06213_ sky130_fd_sc_hd__xnor2_1
XFILLER_124_477 VGND VGND VPWR VPWR sky130_fd_sc_hd__decap_4
X_10356_ _03169_ _03170_ _03032_ _03034_ VGND VGND VPWR VPWR _03172_ sky130_fd_sc_hd__o211a_1
XFILLER_3_741 VPWR VGND VPWR VGND sky130_ef_sc_hd__decap_12
X_10287_ _03092_ _03093_ _03094_ VGND VGND VPWR VPWR _03097_ sky130_fd_sc_hd__a21o_1
XTAP_TAPCELL_ROW_53_1030 VGND VPWR sky130_fd_sc_hd__tapvpwrvgnd_1
XFILLER_3_785 VPWR VGND VPWR VGND sky130_ef_sc_hd__decap_12
XFILLER_2_251 VGND VGND VPWR VPWR sky130_fd_sc_hd__fill_1
X_13075_ _06135_ _06136_ VGND VGND VPWR VPWR _06137_ sky130_fd_sc_hd__or2_1
XFILLER_111_149 VPWR VGND VPWR VGND sky130_ef_sc_hd__decap_12
XTAP_TAPCELL_ROW_53_1041 VGND VPWR sky130_fd_sc_hd__tapvpwrvgnd_1
XFILLER_25_7 VGND VGND VPWR VPWR sky130_fd_sc_hd__fill_1
X_12026_ _04989_ _04990_ VGND VGND VPWR VPWR _04991_ sky130_fd_sc_hd__xnor2_1
XFILLER_93_512 VPWR VGND VPWR VGND sky130_ef_sc_hd__decap_12
XFILLER_65_225 VPWR VGND VPWR VGND sky130_ef_sc_hd__decap_12
XFILLER_81_729 VGND VGND VPWR VPWR sky130_fd_sc_hd__decap_4
XTAP_TAPCELL_ROW_49_979 VGND VPWR sky130_fd_sc_hd__tapvpwrvgnd_1
XFILLER_18_141 VPWR VGND VPWR VGND sky130_ef_sc_hd__decap_12
XFILLER_34_601 VGND VGND VPWR VPWR sky130_fd_sc_hd__fill_1
XFILLER_74_781 VPWR VGND VPWR VGND sky130_ef_sc_hd__decap_12
X_12928_ _05225_ _05976_ VGND VGND VPWR VPWR _05977_ sky130_fd_sc_hd__xnor2_1
XFILLER_22_807 VGND VGND VPWR VPWR sky130_fd_sc_hd__fill_1
XFILLER_34_645 VPWR VGND VPWR VGND sky130_ef_sc_hd__decap_12
XFILLER_92_92 VGND VGND VPWR VPWR sky130_fd_sc_hd__fill_1
X_12859_ _05889_ _05900_ VGND VGND VPWR VPWR _05902_ sky130_fd_sc_hd__xnor2_1
XTAP_TAPCELL_ROW_64_1192 VGND VPWR sky130_fd_sc_hd__tapvpwrvgnd_1
XFILLER_135_709 VPWR VGND VPWR VGND sky130_ef_sc_hd__decap_12
X_08050_ _00785_ _00786_ VGND VGND VPWR VPWR _00787_ sky130_fd_sc_hd__nand2_1
X_07001_ net99 net506 _02921_ _03828_ VGND VGND VPWR VPWR _05538_ sky130_fd_sc_hd__a31o_1
XFILLER_103_617 VGND VGND VPWR VPWR sky130_fd_sc_hd__decap_8
XFILLER_102_127 VGND VGND VPWR VPWR sky130_fd_sc_hd__decap_6
X_08952_ net414 net406 net557 net555 VGND VGND VPWR VPWR _01678_ sky130_fd_sc_hd__and4_1
XFILLER_130_469 VGND VGND VPWR VPWR sky130_fd_sc_hd__decap_6
X_08883_ _01470_ _01608_ VGND VGND VPWR VPWR _01609_ sky130_fd_sc_hd__xnor2_1
XFILLER_102_138 VGND VGND VPWR VPWR sky130_fd_sc_hd__fill_2
X_07903_ _00541_ _00547_ _00546_ VGND VGND VPWR VPWR _00641_ sky130_fd_sc_hd__o21ai_1
XFILLER_69_542 VGND VGND VPWR VPWR sky130_fd_sc_hd__fill_1
X_07834_ _00428_ _00277_ _00429_ VGND VGND VPWR VPWR _00573_ sky130_fd_sc_hd__a21oi_2
XFILLER_111_683 VGND VGND VPWR VPWR sky130_fd_sc_hd__fill_2
XFILLER_57_737 VGND VGND VPWR VPWR sky130_fd_sc_hd__fill_2
XFILLER_56_19 VGND VGND VPWR VPWR sky130_fd_sc_hd__fill_1
XFILLER_29_417 VGND VGND VPWR VPWR sky130_fd_sc_hd__decap_8
X_07765_ _00492_ _00503_ VGND VGND VPWR VPWR _00504_ sky130_fd_sc_hd__xor2_1
XFILLER_84_589 VPWR VGND VPWR VGND sky130_ef_sc_hd__decap_12
X_09504_ _02244_ _02245_ _02246_ VGND VGND VPWR VPWR _02248_ sky130_fd_sc_hd__o21ai_1
X_07696_ _00322_ _00324_ _00434_ VGND VGND VPWR VPWR _00435_ sky130_fd_sc_hd__a21oi_2
X_06716_ _02424_ VGND VGND VPWR VPWR _02435_ sky130_fd_sc_hd__inv_2
XFILLER_64_280 VGND VGND VPWR VPWR sky130_fd_sc_hd__fill_1
X_09435_ _02171_ _02172_ VGND VGND VPWR VPWR _02173_ sky130_fd_sc_hd__nand2_1
XFILLER_72_29 VGND VGND VPWR VPWR sky130_fd_sc_hd__fill_2
XFILLER_80_784 VPWR VGND VPWR VGND sky130_ef_sc_hd__decap_12
X_09366_ _02094_ _02095_ VGND VGND VPWR VPWR _02097_ sky130_fd_sc_hd__xor2_1
X_08317_ _01042_ _01050_ VGND VGND VPWR VPWR _01051_ sky130_fd_sc_hd__xnor2_1
X_09297_ _02020_ _02021_ VGND VGND VPWR VPWR _02023_ sky130_fd_sc_hd__and2b_1
X_08248_ _00982_ _00964_ VGND VGND VPWR VPWR _00983_ sky130_fd_sc_hd__and2b_1
XFILLER_20_361 VGND VGND VPWR VPWR sky130_fd_sc_hd__decap_3
XTAP_TAPCELL_ROW_95_1631 VGND VPWR sky130_fd_sc_hd__tapvpwrvgnd_1
XTAP_TAPCELL_ROW_95_1620 VGND VPWR sky130_fd_sc_hd__tapvpwrvgnd_1
XFILLER_118_282 VPWR VGND VPWR VGND sky130_ef_sc_hd__decap_12
X_08179_ _00800_ _00802_ _00914_ VGND VGND VPWR VPWR _00915_ sky130_fd_sc_hd__a21oi_1
XFILLER_106_411 VGND VGND VPWR VPWR sky130_fd_sc_hd__fill_1
X_10210_ _02830_ _03002_ _03011_ VGND VGND VPWR VPWR _03013_ sky130_fd_sc_hd__nand3_2
X_11190_ _04076_ _04082_ VGND VGND VPWR VPWR _04083_ sky130_fd_sc_hd__and2_1
XFILLER_121_403 VGND VGND VPWR VPWR sky130_fd_sc_hd__decap_4
XFILLER_106_477 VPWR VGND VPWR VGND sky130_ef_sc_hd__decap_12
X_10141_ _02935_ _02936_ VGND VGND VPWR VPWR _02937_ sky130_fd_sc_hd__xor2_1
X_10072_ _02860_ _02861_ VGND VGND VPWR VPWR _02862_ sky130_fd_sc_hd__or2_1
Xoutput191 net191 VGND VGND VPWR VPWR out1[7] sky130_fd_sc_hd__buf_2
Xoutput180 net180 VGND VGND VPWR VPWR out1[11] sky130_fd_sc_hd__buf_2
XFILLER_102_672 VPWR VGND VPWR VGND sky130_ef_sc_hd__decap_12
XFILLER_94_309 VGND VGND VPWR VPWR sky130_fd_sc_hd__fill_1
XTAP_TAPCELL_ROW_7_398 VGND VPWR sky130_fd_sc_hd__tapvpwrvgnd_1
XTAP_TAPCELL_ROW_7_387 VGND VPWR sky130_fd_sc_hd__tapvpwrvgnd_1
XFILLER_47_225 VGND VGND VPWR VPWR sky130_fd_sc_hd__decap_8
XTAP_TAPCELL_ROW_122_2005 VGND VPWR sky130_fd_sc_hd__tapvpwrvgnd_1
XFILLER_90_515 VGND VGND VPWR VPWR sky130_fd_sc_hd__fill_1
XFILLER_63_729 VGND VGND VPWR VPWR sky130_fd_sc_hd__fill_1
XFILLER_56_792 VGND VGND VPWR VPWR sky130_fd_sc_hd__decap_8
XTAP_TAPCELL_ROW_46_938 VGND VPWR sky130_fd_sc_hd__tapvpwrvgnd_1
X_10974_ _03844_ _03845_ _03670_ _03672_ VGND VGND VPWR VPWR _03847_ sky130_fd_sc_hd__a211o_1
XFILLER_46_85 VGND VGND VPWR VPWR sky130_fd_sc_hd__fill_1
XFILLER_16_601 VGND VGND VPWR VPWR sky130_fd_sc_hd__fill_2
XFILLER_71_751 VGND VGND VPWR VPWR sky130_fd_sc_hd__decap_6
X_12713_ _05708_ _05741_ VGND VGND VPWR VPWR _05742_ sky130_fd_sc_hd__xor2_1
XFILLER_16_678 VGND VGND VPWR VPWR sky130_fd_sc_hd__decap_8
XTAP_TAPCELL_ROW_26_662 VGND VPWR sky130_fd_sc_hd__tapvpwrvgnd_1
XFILLER_15_199 VGND VGND VPWR VPWR sky130_fd_sc_hd__decap_8
XFILLER_31_659 VGND VGND VPWR VPWR sky130_fd_sc_hd__decap_8
X_12644_ _05517_ _05535_ _05534_ VGND VGND VPWR VPWR _05666_ sky130_fd_sc_hd__o21a_1
XFILLER_129_503 VGND VGND VPWR VPWR sky130_fd_sc_hd__fill_1
X_12575_ _05589_ _05590_ VGND VGND VPWR VPWR _05591_ sky130_fd_sc_hd__nor2_1
XFILLER_30_147 VGND VGND VPWR VPWR sky130_fd_sc_hd__decap_8
X_11526_ net401 _02251_ _03396_ VGND VGND VPWR VPWR _04449_ sky130_fd_sc_hd__o21a_1
XFILLER_7_57 VPWR VGND VPWR VGND sky130_ef_sc_hd__decap_12
XTAP_TAPCELL_ROW_133_2156 VGND VPWR sky130_fd_sc_hd__tapvpwrvgnd_1
X_11457_ _04372_ _04373_ VGND VGND VPWR VPWR _04375_ sky130_fd_sc_hd__nor2_1
XFILLER_125_753 VPWR VGND VPWR VGND sky130_ef_sc_hd__decap_12
X_10408_ net526 net648 net637 net531 VGND VGND VPWR VPWR _03228_ sky130_fd_sc_hd__a22oi_1
X_11388_ net246 _03944_ _04167_ VGND VGND VPWR VPWR _04299_ sky130_fd_sc_hd__or3_1
XFILLER_125_797 VGND VGND VPWR VPWR sky130_fd_sc_hd__decap_8
XFILLER_112_403 VPWR VGND VPWR VGND sky130_ef_sc_hd__decap_12
XFILLER_98_637 VGND VGND VPWR VPWR sky130_fd_sc_hd__fill_2
X_10339_ _03132_ _03150_ _03153_ VGND VGND VPWR VPWR _03154_ sky130_fd_sc_hd__nor3_1
X_13127_ _06192_ _06193_ VGND VGND VPWR VPWR _06195_ sky130_fd_sc_hd__nand2_1
XFILLER_98_659 VGND VGND VPWR VPWR sky130_fd_sc_hd__decap_3
X_13058_ _05891_ _06116_ VGND VGND VPWR VPWR _06119_ sky130_fd_sc_hd__and2_1
XFILLER_97_169 VGND VGND VPWR VPWR sky130_fd_sc_hd__decap_8
XFILLER_78_372 VPWR VGND VPWR VGND sky130_ef_sc_hd__decap_12
X_12009_ _04855_ _04972_ _04973_ VGND VGND VPWR VPWR _04974_ sky130_fd_sc_hd__nor3_2
XFILLER_16_3 VGND VGND VPWR VPWR sky130_fd_sc_hd__fill_1
XFILLER_66_589 VPWR VGND VPWR VGND sky130_ef_sc_hd__decap_12
X_07550_ _00288_ _00289_ VGND VGND VPWR VPWR _00290_ sky130_fd_sc_hd__nor2_1
XFILLER_81_526 VPWR VGND VPWR VGND sky130_ef_sc_hd__decap_12
XTAP_TAPCELL_ROW_66_1221 VGND VPWR sky130_fd_sc_hd__tapvpwrvgnd_1
X_09220_ _01809_ _01817_ _01816_ VGND VGND VPWR VPWR _01944_ sky130_fd_sc_hd__a21oi_1
X_07481_ net513 net41 VGND VGND VPWR VPWR _00222_ sky130_fd_sc_hd__nand2b_1
XFILLER_61_261 VPWR VGND VPWR VGND sky130_ef_sc_hd__decap_12
XFILLER_21_136 VPWR VGND VPWR VGND sky130_ef_sc_hd__decap_12
XFILLER_22_637 VGND VGND VPWR VPWR sky130_fd_sc_hd__decap_6
X_09151_ _01874_ _01875_ VGND VGND VPWR VPWR _01876_ sky130_fd_sc_hd__or2_1
X_09082_ _01805_ _01806_ VGND VGND VPWR VPWR _01807_ sky130_fd_sc_hd__nand2b_1
X_08102_ _00833_ _00837_ VGND VGND VPWR VPWR _00838_ sky130_fd_sc_hd__and2_1
XFILLER_30_681 VPWR VGND VPWR VGND sky130_ef_sc_hd__decap_12
XFILLER_135_517 VPWR VGND VPWR VGND sky130_ef_sc_hd__decap_12
X_08033_ _00769_ _00749_ VGND VGND VPWR VPWR _00770_ sky130_fd_sc_hd__and2b_1
Xinput71 w10[5] VGND VGND VPWR VPWR net71 sky130_fd_sc_hd__buf_1
Xinput60 w03[2] VGND VGND VPWR VPWR net60 sky130_fd_sc_hd__clkbuf_4
Xinput82 w12[0] VGND VGND VPWR VPWR net82 sky130_fd_sc_hd__buf_1
Xinput93 w13[3] VGND VGND VPWR VPWR net93 sky130_fd_sc_hd__buf_1
XTAP_TAPCELL_ROW_77_1372 VGND VPWR sky130_fd_sc_hd__tapvpwrvgnd_1
XFILLER_115_263 VPWR VGND VPWR VGND sky130_ef_sc_hd__decap_12
XFILLER_89_615 VGND VGND VPWR VPWR sky130_fd_sc_hd__fill_1
XTAP_TAPCELL_ROW_90_1561 VGND VPWR sky130_fd_sc_hd__tapvpwrvgnd_1
XTAP_TAPCELL_ROW_90_1550 VGND VPWR sky130_fd_sc_hd__tapvpwrvgnd_1
X_09984_ _02650_ _02669_ _02668_ VGND VGND VPWR VPWR _02769_ sky130_fd_sc_hd__o21ba_1
X_08935_ _01656_ _01659_ _01660_ VGND VGND VPWR VPWR _01661_ sky130_fd_sc_hd__nand3_1
XFILLER_76_309 VGND VGND VPWR VPWR sky130_fd_sc_hd__fill_2
XFILLER_69_361 VPWR VGND VPWR VGND sky130_ef_sc_hd__decap_12
X_08866_ _01466_ _01590_ VGND VGND VPWR VPWR _01592_ sky130_fd_sc_hd__xnor2_1
XTAP_TAPCELL_ROW_4_357 VGND VPWR sky130_fd_sc_hd__tapvpwrvgnd_1
XTAP_TAPCELL_ROW_4_346 VGND VPWR sky130_fd_sc_hd__tapvpwrvgnd_1
XFILLER_29_214 VGND VGND VPWR VPWR sky130_fd_sc_hd__decap_4
XFILLER_29_225 VGND VGND VPWR VPWR sky130_fd_sc_hd__fill_1
XFILLER_123_57 VPWR VGND VPWR VGND sky130_ef_sc_hd__decap_12
X_07817_ _00507_ _00555_ VGND VGND VPWR VPWR _00556_ sky130_fd_sc_hd__xnor2_1
X_08797_ _01520_ _01523_ VGND VGND VPWR VPWR _01524_ sky130_fd_sc_hd__xnor2_1
X_07748_ _00333_ _00483_ _00485_ VGND VGND VPWR VPWR _00487_ sky130_fd_sc_hd__or3_1
XFILLER_84_386 VGND VGND VPWR VPWR sky130_fd_sc_hd__fill_1
XFILLER_83_28 VGND VGND VPWR VPWR sky130_fd_sc_hd__decap_3
XFILLER_45_729 VGND VGND VPWR VPWR sky130_fd_sc_hd__decap_6
XFILLER_37_291 VPWR VGND VPWR VGND sky130_ef_sc_hd__decap_12
X_07679_ _00417_ _00416_ _00325_ VGND VGND VPWR VPWR _00419_ sky130_fd_sc_hd__a21o_1
XFILLER_80_570 VGND VGND VPWR VPWR sky130_fd_sc_hd__fill_1
XFILLER_53_773 VGND VGND VPWR VPWR sky130_fd_sc_hd__decap_8
X_09418_ _02147_ _02154_ VGND VGND VPWR VPWR _02155_ sky130_fd_sc_hd__xnor2_1
XFILLER_53_795 VGND VGND VPWR VPWR sky130_fd_sc_hd__decap_8
X_10690_ _03533_ _03534_ VGND VGND VPWR VPWR _03536_ sky130_fd_sc_hd__xor2_1
XTAP_TAPCELL_ROW_23_610 VGND VPWR sky130_fd_sc_hd__tapvpwrvgnd_1
XTAP_TAPCELL_ROW_23_621 VGND VPWR sky130_fd_sc_hd__tapvpwrvgnd_1
X_09349_ _01914_ _01917_ _01913_ VGND VGND VPWR VPWR _02080_ sky130_fd_sc_hd__o21ba_4
X_12360_ _05011_ _05172_ _05171_ VGND VGND VPWR VPWR _05356_ sky130_fd_sc_hd__o21a_1
XFILLER_21_692 VGND VGND VPWR VPWR sky130_fd_sc_hd__decap_8
XFILLER_40_489 VPWR VGND VPWR VGND sky130_ef_sc_hd__decap_12
X_11311_ _04208_ _04214_ VGND VGND VPWR VPWR _04215_ sky130_fd_sc_hd__xor2_1
XFILLER_119_591 VPWR VGND VPWR VGND sky130_ef_sc_hd__decap_12
X_12291_ net733 _05279_ VGND VGND VPWR VPWR _05281_ sky130_fd_sc_hd__xnor2_1
XFILLER_4_357 VGND VGND VPWR VPWR sky130_fd_sc_hd__decap_6
X_11242_ _04109_ _04138_ VGND VGND VPWR VPWR _04140_ sky130_fd_sc_hd__xor2_1
XFILLER_122_723 VPWR VGND VPWR VGND sky130_ef_sc_hd__decap_12
XFILLER_107_797 VPWR VGND VPWR VGND sky130_ef_sc_hd__decap_12
X_11173_ _04025_ _04062_ VGND VGND VPWR VPWR _04064_ sky130_fd_sc_hd__xnor2_2
XFILLER_106_285 VGND VGND VPWR VPWR sky130_fd_sc_hd__fill_2
X_10124_ _02884_ _02908_ _02917_ VGND VGND VPWR VPWR _02918_ sky130_fd_sc_hd__or3_1
XFILLER_122_789 VGND VGND VPWR VPWR sky130_fd_sc_hd__fill_2
XFILLER_79_169 VGND VGND VPWR VPWR sky130_fd_sc_hd__decap_8
XTAP_TAPCELL_ROW_50_1000 VGND VPWR sky130_fd_sc_hd__tapvpwrvgnd_1
XFILLER_0_552 VGND VGND VPWR VPWR sky130_fd_sc_hd__decap_8
X_10055_ _02800_ _02842_ _02841_ VGND VGND VPWR VPWR _02843_ sky130_fd_sc_hd__o21a_1
XFILLER_48_545 VGND VGND VPWR VPWR sky130_fd_sc_hd__decap_8
XFILLER_75_331 VGND VGND VPWR VPWR sky130_fd_sc_hd__decap_4
XFILLER_48_567 VPWR VGND VPWR VGND sky130_ef_sc_hd__decap_12
XFILLER_63_537 VGND VGND VPWR VPWR sky130_fd_sc_hd__decap_6
XFILLER_48_589 VGND VGND VPWR VPWR sky130_fd_sc_hd__decap_4
XFILLER_90_334 VGND VGND VPWR VPWR sky130_fd_sc_hd__fill_2
XFILLER_28_291 VPWR VGND VPWR VGND sky130_ef_sc_hd__decap_12
XTAP_TAPCELL_ROW_102_1719 VGND VPWR sky130_fd_sc_hd__tapvpwrvgnd_1
XFILLER_73_72 VPWR VGND VPWR VGND sky130_ef_sc_hd__decap_12
XFILLER_50_209 VPWR VGND VPWR VGND sky130_ef_sc_hd__decap_12
XFILLER_16_464 VGND VGND VPWR VPWR sky130_fd_sc_hd__decap_4
X_10957_ _03821_ _03826_ VGND VGND VPWR VPWR _03829_ sky130_fd_sc_hd__xor2_1
XFILLER_85_6 VGND VGND VPWR VPWR sky130_fd_sc_hd__decap_3
XTAP_TAPCELL_ROW_61_1151 VGND VPWR sky130_fd_sc_hd__tapvpwrvgnd_1
X_12627_ _05645_ _05646_ _05469_ _05471_ VGND VGND VPWR VPWR _05649_ sky130_fd_sc_hd__a211o_1
X_10888_ net482 net475 net652 net650 VGND VGND VPWR VPWR _03753_ sky130_fd_sc_hd__and4_1
X_12558_ _05572_ _05570_ VGND VGND VPWR VPWR _05573_ sky130_fd_sc_hd__nand2b_1
XFILLER_129_388 VGND VGND VPWR VPWR sky130_fd_sc_hd__decap_4
XFILLER_117_528 VPWR VGND VPWR VGND sky130_ef_sc_hd__decap_12
XFILLER_8_685 VPWR VGND VPWR VGND sky130_ef_sc_hd__decap_12
XFILLER_7_162 VGND VGND VPWR VPWR sky130_fd_sc_hd__decap_6
X_11509_ _04418_ _04429_ VGND VGND VPWR VPWR _04431_ sky130_fd_sc_hd__xor2_1
X_12489_ _05365_ _05401_ _05400_ VGND VGND VPWR VPWR _05497_ sky130_fd_sc_hd__a21o_1
XFILLER_125_561 VPWR VGND VPWR VGND sky130_ef_sc_hd__decap_12
XFILLER_98_445 VPWR VGND VPWR VGND sky130_ef_sc_hd__decap_12
Xfanout609 net132 VGND VGND VPWR VPWR net609 sky130_fd_sc_hd__buf_2
XFILLER_112_244 VGND VGND VPWR VPWR sky130_fd_sc_hd__decap_8
X_06981_ _03904_ _05308_ VGND VGND VPWR VPWR _05319_ sky130_fd_sc_hd__and2_1
XFILLER_98_467 VGND VGND VPWR VPWR sky130_fd_sc_hd__fill_2
X_08720_ _01326_ _01330_ _01325_ VGND VGND VPWR VPWR _01448_ sky130_fd_sc_hd__a21o_1
X_08651_ net493 net633 VGND VGND VPWR VPWR _01379_ sky130_fd_sc_hd__and2_1
XFILLER_82_802 VGND VGND VPWR VPWR sky130_fd_sc_hd__fill_2
XTAP_TAPCELL_ROW_1_305 VGND VPWR sky130_fd_sc_hd__tapvpwrvgnd_1
XFILLER_39_578 VGND VGND VPWR VPWR sky130_fd_sc_hd__decap_8
X_07602_ _00340_ _00341_ VGND VGND VPWR VPWR _00342_ sky130_fd_sc_hd__nand2b_1
XFILLER_27_729 VPWR VGND VPWR VGND sky130_ef_sc_hd__decap_12
X_08582_ _01307_ _01309_ _01310_ VGND VGND VPWR VPWR _01311_ sky130_fd_sc_hd__nor3_1
XFILLER_26_239 VPWR VGND VPWR VGND sky130_ef_sc_hd__decap_12
X_07533_ _06503_ _00272_ _00273_ VGND VGND VPWR VPWR _00274_ sky130_fd_sc_hd__nor3_1
XFILLER_81_378 VPWR VGND VPWR VGND sky130_ef_sc_hd__decap_12
X_07464_ _00203_ _00204_ VGND VGND VPWR VPWR _00205_ sky130_fd_sc_hd__xnor2_1
XFILLER_50_732 VGND VGND VPWR VPWR sky130_fd_sc_hd__decap_3
X_09203_ _01925_ _01926_ VGND VGND VPWR VPWR _01927_ sky130_fd_sc_hd__and2b_1
XFILLER_22_445 VGND VGND VPWR VPWR sky130_fd_sc_hd__decap_8
X_07395_ _06516_ _06524_ _06523_ VGND VGND VPWR VPWR _00136_ sky130_fd_sc_hd__a21bo_1
XTAP_TAPCELL_ROW_79_1401 VGND VPWR sky130_fd_sc_hd__tapvpwrvgnd_1
X_09134_ net516 net65 VGND VGND VPWR VPWR _01859_ sky130_fd_sc_hd__and2b_1
Xrebuffer204 net905 VGND VGND VPWR VPWR net904 sky130_fd_sc_hd__dlymetal6s2s_1
Xrebuffer215 _06172_ VGND VGND VPWR VPWR net915 sky130_fd_sc_hd__buf_2
Xrebuffer237 _06128_ VGND VGND VPWR VPWR net937 sky130_fd_sc_hd__dlymetal6s2s_1
X_09065_ _01491_ _01620_ _01621_ VGND VGND VPWR VPWR _01790_ sky130_fd_sc_hd__o21bai_1
XPHY_EDGE_ROW_62_Left_199 VGND VGND VPWR VPWR sky130_fd_sc_hd__decap_3
X_08016_ _00751_ _00752_ VGND VGND VPWR VPWR _00753_ sky130_fd_sc_hd__nand2b_1
XTAP_TAPCELL_ROW_9_416 VGND VPWR sky130_fd_sc_hd__tapvpwrvgnd_1
XFILLER_89_412 VPWR VGND VPWR VGND sky130_ef_sc_hd__decap_12
XTAP_TAPCELL_ROW_9_427 VGND VPWR sky130_fd_sc_hd__tapvpwrvgnd_1
XFILLER_1_305 VPWR VGND VPWR VGND sky130_ef_sc_hd__decap_12
XFILLER_1_349 VGND VGND VPWR VPWR sky130_fd_sc_hd__decap_8
XFILLER_131_553 VGND VGND VPWR VPWR sky130_fd_sc_hd__decap_6
XFILLER_104_778 VGND VGND VPWR VPWR sky130_fd_sc_hd__fill_1
X_09967_ _02746_ _02749_ VGND VGND VPWR VPWR _02751_ sky130_fd_sc_hd__xnor2_1
XFILLER_77_629 VPWR VGND VPWR VGND sky130_ef_sc_hd__decap_12
XFILLER_49_309 VPWR VGND VPWR VGND sky130_ef_sc_hd__decap_12
XFILLER_131_597 VPWR VGND VPWR VGND sky130_ef_sc_hd__decap_12
X_08918_ _01496_ _01643_ VGND VGND VPWR VPWR _01644_ sky130_fd_sc_hd__xnor2_1
X_09898_ _02602_ _02604_ VGND VGND VPWR VPWR _02677_ sky130_fd_sc_hd__nand2_1
XFILLER_85_640 VGND VGND VPWR VPWR sky130_fd_sc_hd__fill_1
X_08849_ _01489_ _01574_ net734 VGND VGND VPWR VPWR _01576_ sky130_fd_sc_hd__nand3_1
XFILLER_85_673 VPWR VGND VPWR VGND sky130_ef_sc_hd__decap_12
XFILLER_84_161 VGND VGND VPWR VPWR sky130_fd_sc_hd__decap_8
XFILLER_45_526 VGND VGND VPWR VPWR sky130_fd_sc_hd__fill_2
X_11860_ _04809_ _04805_ _04810_ VGND VGND VPWR VPWR _04811_ sky130_fd_sc_hd__or3_4
XFILLER_45_559 VGND VGND VPWR VPWR sky130_fd_sc_hd__fill_1
XFILLER_17_239 VGND VGND VPWR VPWR sky130_fd_sc_hd__fill_1
XFILLER_72_389 VPWR VGND VPWR VGND sky130_ef_sc_hd__decap_12
X_11791_ _04733_ _04732_ VGND VGND VPWR VPWR _04735_ sky130_fd_sc_hd__and2b_1
X_10811_ _03486_ _03484_ _03667_ _03668_ VGND VGND VPWR VPWR _03669_ sky130_fd_sc_hd__a211o_4
XFILLER_26_795 VPWR VGND VPWR VGND sky130_ef_sc_hd__decap_12
X_10742_ _03584_ _03591_ VGND VGND VPWR VPWR _03593_ sky130_fd_sc_hd__xor2_1
XFILLER_9_405 VPWR VGND VPWR VGND sky130_ef_sc_hd__decap_12
XFILLER_40_253 VGND VGND VPWR VPWR sky130_fd_sc_hd__decap_6
XFILLER_43_53 VGND VGND VPWR VPWR sky130_fd_sc_hd__decap_3
X_10673_ _03514_ _03515_ VGND VGND VPWR VPWR _03517_ sky130_fd_sc_hd__and2_1
XFILLER_13_478 VPWR VGND VPWR VGND sky130_ef_sc_hd__decap_12
XFILLER_41_798 VGND VGND VPWR VPWR sky130_fd_sc_hd__decap_8
X_13392_ clknet_3_0__leaf_clk _00021_ _00102_ VGND VGND VPWR VPWR net206 sky130_fd_sc_hd__dfrtp_1
X_12412_ net420 net587 _05410_ _05411_ VGND VGND VPWR VPWR _05413_ sky130_fd_sc_hd__nand4_1
X_12343_ _05027_ _05168_ _05169_ _05163_ VGND VGND VPWR VPWR _05337_ sky130_fd_sc_hd__a22oi_2
XTAP_TAPCELL_ROW_130_2115 VGND VPWR sky130_fd_sc_hd__tapvpwrvgnd_1
XFILLER_4_121 VPWR VGND VPWR VGND sky130_ef_sc_hd__decap_12
X_12274_ _05260_ _05261_ VGND VGND VPWR VPWR _05262_ sky130_fd_sc_hd__nor2_1
XFILLER_107_561 VPWR VGND VPWR VGND sky130_ef_sc_hd__decap_12
XFILLER_4_165 VPWR VGND VPWR VGND sky130_ef_sc_hd__decap_12
X_11225_ _04116_ _04118_ VGND VGND VPWR VPWR _04121_ sky130_fd_sc_hd__xnor2_1
XFILLER_122_531 VGND VGND VPWR VPWR sky130_fd_sc_hd__fill_1
XFILLER_68_629 VPWR VGND VPWR VGND sky130_ef_sc_hd__decap_12
X_11156_ _03878_ _04044_ VGND VGND VPWR VPWR _04045_ sky130_fd_sc_hd__xnor2_1
XFILLER_67_117 VPWR VGND VPWR VGND sky130_ef_sc_hd__decap_12
X_10107_ _02897_ _02898_ net664 net279 VGND VGND VPWR VPWR _02900_ sky130_fd_sc_hd__and4bb_1
XFILLER_48_320 VGND VGND VPWR VPWR sky130_fd_sc_hd__fill_1
X_11087_ _03787_ _03796_ _03794_ VGND VGND VPWR VPWR _03971_ sky130_fd_sc_hd__o21ai_2
X_10038_ _02822_ _02824_ VGND VGND VPWR VPWR _02825_ sky130_fd_sc_hd__and2b_1
XFILLER_48_331 VPWR VGND VPWR VGND sky130_ef_sc_hd__decap_12
XFILLER_0_393 VGND VGND VPWR VPWR sky130_fd_sc_hd__fill_2
XTAP_TAPCELL_ROW_128_2088 VGND VPWR sky130_fd_sc_hd__tapvpwrvgnd_1
XFILLER_91_621 VPWR VGND VPWR VGND sky130_ef_sc_hd__decap_12
XFILLER_36_504 VGND VGND VPWR VPWR sky130_fd_sc_hd__fill_1
XFILLER_63_334 VGND VGND VPWR VPWR sky130_fd_sc_hd__fill_2
XFILLER_91_698 VGND VGND VPWR VPWR sky130_fd_sc_hd__fill_2
XFILLER_63_356 VPWR VGND VPWR VGND sky130_ef_sc_hd__decap_12
X_11989_ net716 VGND VGND VPWR VPWR _04952_ sky130_fd_sc_hd__inv_2
XFILLER_44_570 VPWR VGND VPWR VGND sky130_ef_sc_hd__decap_12
XFILLER_83_3 VGND VGND VPWR VPWR sky130_fd_sc_hd__decap_6
XFILLER_32_787 VPWR VGND VPWR VGND sky130_ef_sc_hd__decap_12
X_07180_ _06463_ _06470_ _06471_ VGND VGND VPWR VPWR _06472_ sky130_fd_sc_hd__nand3_1
XTAP_TAPCELL_ROW_14_484 VGND VPWR sky130_fd_sc_hd__tapvpwrvgnd_1
XTAP_TAPCELL_ROW_14_495 VGND VPWR sky130_fd_sc_hd__tapvpwrvgnd_1
XFILLER_129_174 VPWR VGND VPWR VGND sky130_ef_sc_hd__decap_12
XFILLER_117_325 VGND VGND VPWR VPWR sky130_fd_sc_hd__decap_4
XTAP_TAPCELL_ROW_74_1331 VGND VPWR sky130_fd_sc_hd__tapvpwrvgnd_1
XFILLER_125_391 VGND VGND VPWR VPWR sky130_fd_sc_hd__fill_1
XFILLER_113_542 VGND VGND VPWR VPWR sky130_fd_sc_hd__decap_4
XFILLER_113_575 VGND VGND VPWR VPWR sky130_fd_sc_hd__fill_1
X_09821_ _01949_ _02592_ VGND VGND VPWR VPWR _02593_ sky130_fd_sc_hd__xnor2_1
XFILLER_98_253 VPWR VGND VPWR VGND sky130_ef_sc_hd__decap_12
Xfanout439 net440 VGND VGND VPWR VPWR net439 sky130_fd_sc_hd__buf_2
Xfanout406 net407 VGND VGND VPWR VPWR net406 sky130_fd_sc_hd__buf_2
XFILLER_59_629 VGND VGND VPWR VPWR sky130_fd_sc_hd__decap_3
Xfanout417 net424 VGND VGND VPWR VPWR net417 sky130_fd_sc_hd__buf_2
Xfanout428 net431 VGND VGND VPWR VPWR net428 sky130_fd_sc_hd__buf_2
X_09752_ _01677_ _02516_ VGND VGND VPWR VPWR _02517_ sky130_fd_sc_hd__xnor2_1
XFILLER_58_139 VGND VGND VPWR VPWR sky130_fd_sc_hd__fill_1
X_06964_ _05112_ _05123_ VGND VGND VPWR VPWR _05133_ sky130_fd_sc_hd__xnor2_1
X_08703_ _01427_ _01429_ _01277_ _01279_ VGND VGND VPWR VPWR _01431_ sky130_fd_sc_hd__o211a_1
X_09683_ _02418_ _02440_ VGND VGND VPWR VPWR _02442_ sky130_fd_sc_hd__xnor2_1
X_06895_ _04287_ _04363_ net940 VGND VGND VPWR VPWR _04385_ sky130_fd_sc_hd__a21oi_1
XFILLER_73_109 VGND VGND VPWR VPWR sky130_fd_sc_hd__decap_3
XFILLER_67_673 VPWR VGND VPWR VGND sky130_ef_sc_hd__decap_12
X_08634_ _01230_ _01361_ VGND VGND VPWR VPWR _01362_ sky130_fd_sc_hd__and2_1
XFILLER_82_687 VGND VGND VPWR VPWR sky130_fd_sc_hd__fill_1
X_08565_ _01285_ _01131_ _01293_ VGND VGND VPWR VPWR _01294_ sky130_fd_sc_hd__and3_1
X_07516_ _00256_ VGND VGND VPWR VPWR _00257_ sky130_fd_sc_hd__inv_2
XTAP_TAPCELL_ROW_85_1482 VGND VPWR sky130_fd_sc_hd__tapvpwrvgnd_1
XFILLER_82_698 VGND VGND VPWR VPWR sky130_fd_sc_hd__fill_2
XFILLER_81_197 VPWR VGND VPWR VGND sky130_ef_sc_hd__decap_12
XFILLER_54_389 VGND VGND VPWR VPWR sky130_fd_sc_hd__decap_6
X_08496_ _01170_ _01224_ VGND VGND VPWR VPWR _01225_ sky130_fd_sc_hd__nand2b_1
X_07447_ _00185_ _00187_ VGND VGND VPWR VPWR _00188_ sky130_fd_sc_hd__xnor2_1
XTAP_TAPCELL_ROW_33_760 VGND VPWR sky130_fd_sc_hd__tapvpwrvgnd_1
X_07378_ _06508_ _06510_ _06507_ VGND VGND VPWR VPWR _06668_ sky130_fd_sc_hd__a21oi_1
XPHY_EDGE_ROW_70_Left_207 VGND VGND VPWR VPWR sky130_fd_sc_hd__decap_3
XFILLER_136_623 VPWR VGND VPWR VGND sky130_ef_sc_hd__decap_12
XFILLER_135_111 VGND VGND VPWR VPWR sky130_fd_sc_hd__fill_1
XFILLER_108_303 VGND VGND VPWR VPWR sky130_fd_sc_hd__decap_4
X_09117_ net456 net538 VGND VGND VPWR VPWR _01842_ sky130_fd_sc_hd__nand2_1
XFILLER_6_419 VGND VGND VPWR VPWR sky130_fd_sc_hd__fill_1
XFILLER_13_78 VGND VGND VPWR VPWR sky130_fd_sc_hd__fill_2
XFILLER_136_645 VGND VGND VPWR VPWR sky130_fd_sc_hd__fill_2
X_09048_ _01771_ _01772_ VGND VGND VPWR VPWR _01773_ sky130_fd_sc_hd__nand2_1
XFILLER_136_678 VGND VGND VPWR VPWR sky130_fd_sc_hd__decap_4
XFILLER_123_317 VGND VGND VPWR VPWR sky130_fd_sc_hd__decap_8
XFILLER_116_380 VPWR VGND VPWR VGND sky130_ef_sc_hd__decap_12
XFILLER_1_113 VPWR VGND VPWR VGND sky130_ef_sc_hd__decap_12
XFILLER_2_625 VPWR VGND VPWR VGND sky130_ef_sc_hd__decap_12
XFILLER_89_264 VGND VGND VPWR VPWR sky130_fd_sc_hd__fill_1
XFILLER_89_242 VGND VGND VPWR VPWR sky130_fd_sc_hd__decap_3
XFILLER_2_669 VPWR VGND VPWR VGND sky130_ef_sc_hd__decap_12
X_11010_ _03708_ _03885_ VGND VGND VPWR VPWR _03886_ sky130_fd_sc_hd__xnor2_1
XFILLER_49_128 VGND VGND VPWR VPWR sky130_fd_sc_hd__fill_1
XFILLER_92_418 VGND VGND VPWR VPWR sky130_fd_sc_hd__fill_2
XFILLER_58_695 VGND VGND VPWR VPWR sky130_fd_sc_hd__decap_4
X_12961_ _02087_ net657 VGND VGND VPWR VPWR _06013_ sky130_fd_sc_hd__and2_1
XFILLER_85_481 VGND VGND VPWR VPWR sky130_fd_sc_hd__fill_1
X_11912_ net593 net301 net299 net618 VGND VGND VPWR VPWR _04867_ sky130_fd_sc_hd__a22o_1
X_12892_ _05906_ _05937_ VGND VGND VPWR VPWR _05938_ sky130_fd_sc_hd__xnor2_1
X_11843_ _04620_ _04784_ _04791_ VGND VGND VPWR VPWR _04792_ sky130_fd_sc_hd__nand3_2
XFILLER_33_518 VGND VGND VPWR VPWR sky130_fd_sc_hd__decap_6
XFILLER_72_197 VGND VGND VPWR VPWR sky130_fd_sc_hd__decap_4
X_11774_ net524 net675 net672 net529 VGND VGND VPWR VPWR _04716_ sky130_fd_sc_hd__a22oi_1
XFILLER_14_754 VGND VGND VPWR VPWR sky130_fd_sc_hd__fill_2
XFILLER_14_765 VGND VGND VPWR VPWR sky130_fd_sc_hd__decap_3
XPHY_EDGE_ROW_109_Left_246 VGND VGND VPWR VPWR sky130_fd_sc_hd__decap_3
XFILLER_9_213 VGND VGND VPWR VPWR sky130_fd_sc_hd__decap_8
X_10725_ net482 net652 net650 net489 VGND VGND VPWR VPWR _03574_ sky130_fd_sc_hd__a22o_1
X_10656_ _03497_ _03498_ VGND VGND VPWR VPWR _03499_ sky130_fd_sc_hd__nand2_1
XTAP_TAPCELL_ROW_11_454 VGND VPWR sky130_fd_sc_hd__tapvpwrvgnd_1
XTAP_TAPCELL_ROW_11_443 VGND VPWR sky130_fd_sc_hd__tapvpwrvgnd_1
XFILLER_127_656 VPWR VGND VPWR VGND sky130_ef_sc_hd__decap_12
X_13375_ clknet_3_4__leaf_clk _00033_ _00085_ VGND VGND VPWR VPWR net189 sky130_fd_sc_hd__dfrtp_1
X_10587_ _03385_ _03422_ VGND VGND VPWR VPWR _03424_ sky130_fd_sc_hd__xnor2_1
XFILLER_126_166 VGND VGND VPWR VPWR sky130_fd_sc_hd__fill_1
XFILLER_5_441 VGND VGND VPWR VPWR sky130_fd_sc_hd__decap_6
X_12326_ net690 net665 net285 net81 VGND VGND VPWR VPWR _05318_ sky130_fd_sc_hd__and4b_1
XFILLER_107_391 VGND VGND VPWR VPWR sky130_fd_sc_hd__fill_1
XFILLER_5_485 VPWR VGND VPWR VGND sky130_ef_sc_hd__decap_12
X_12257_ _05241_ _05242_ VGND VGND VPWR VPWR _05244_ sky130_fd_sc_hd__nand2_1
XPHY_EDGE_ROW_118_Left_255 VGND VGND VPWR VPWR sky130_fd_sc_hd__decap_3
XTAP_TAPCELL_ROW_110_1829 VGND VPWR sky130_fd_sc_hd__tapvpwrvgnd_1
XTAP_TAPCELL_ROW_56_1083 VGND VPWR sky130_fd_sc_hd__tapvpwrvgnd_1
XTAP_TAPCELL_ROW_56_1072 VGND VPWR sky130_fd_sc_hd__tapvpwrvgnd_1
X_12188_ _05165_ _05167_ VGND VGND VPWR VPWR _05168_ sky130_fd_sc_hd__nand2b_1
X_11208_ _04091_ _04102_ VGND VGND VPWR VPWR _04103_ sky130_fd_sc_hd__nand2b_1
XFILLER_122_372 VGND VGND VPWR VPWR sky130_fd_sc_hd__fill_2
XFILLER_95_223 VGND VGND VPWR VPWR sky130_fd_sc_hd__fill_1
XFILLER_68_437 VPWR VGND VPWR VGND sky130_ef_sc_hd__decap_12
XFILLER_110_545 VPWR VGND VPWR VGND sky130_ef_sc_hd__decap_12
X_11139_ net277 net275 net540 VGND VGND VPWR VPWR _04027_ sky130_fd_sc_hd__o21ai_1
XFILLER_110_589 VGND VGND VPWR VPWR sky130_fd_sc_hd__decap_8
XFILLER_95_289 VGND VGND VPWR VPWR sky130_fd_sc_hd__decap_3
XFILLER_49_673 VPWR VGND VPWR VGND sky130_ef_sc_hd__decap_12
X_06680_ net521 VGND VGND VPWR VPWR _02044_ sky130_fd_sc_hd__clkinv_4
XFILLER_64_643 VGND VGND VPWR VPWR sky130_fd_sc_hd__fill_1
XFILLER_63_153 VGND VGND VPWR VPWR sky130_fd_sc_hd__decap_3
XTAP_TAPCELL_ROW_19_554 VGND VPWR sky130_fd_sc_hd__tapvpwrvgnd_1
XTAP_TAPCELL_ROW_19_565 VGND VPWR sky130_fd_sc_hd__tapvpwrvgnd_1
X_08350_ _01036_ _01083_ VGND VGND VPWR VPWR _00044_ sky130_fd_sc_hd__xnor2_1
XFILLER_91_495 VGND VGND VPWR VPWR sky130_fd_sc_hd__decap_8
XPHY_EDGE_ROW_127_Left_264 VGND VGND VPWR VPWR sky130_fd_sc_hd__decap_3
X_07301_ _06439_ _06591_ VGND VGND VPWR VPWR _06592_ sky130_fd_sc_hd__xnor2_1
XFILLER_32_540 VGND VGND VPWR VPWR sky130_fd_sc_hd__decap_6
X_08281_ _00988_ _01014_ VGND VGND VPWR VPWR _01016_ sky130_fd_sc_hd__xnor2_1
X_07232_ _06522_ _06521_ VGND VGND VPWR VPWR _06523_ sky130_fd_sc_hd__nand2b_1
X_07163_ net695 net614 net374 net411 VGND VGND VPWR VPWR _06455_ sky130_fd_sc_hd__and4_1
XFILLER_118_645 VGND VGND VPWR VPWR sky130_fd_sc_hd__decap_8
XFILLER_133_615 VGND VGND VPWR VPWR sky130_fd_sc_hd__fill_1
XFILLER_117_177 VGND VGND VPWR VPWR sky130_fd_sc_hd__fill_1
X_07094_ _06384_ _06385_ VGND VGND VPWR VPWR _06386_ sky130_fd_sc_hd__and2b_1
XPHY_EDGE_ROW_136_Left_273 VGND VGND VPWR VPWR sky130_fd_sc_hd__decap_3
XFILLER_99_573 VPWR VGND VPWR VGND sky130_ef_sc_hd__decap_12
X_09804_ _02571_ _02572_ VGND VGND VPWR VPWR _02574_ sky130_fd_sc_hd__xnor2_1
Xfanout247 _03725_ VGND VGND VPWR VPWR net247 sky130_fd_sc_hd__clkbuf_4
Xfanout258 net93 VGND VGND VPWR VPWR net258 sky130_fd_sc_hd__buf_2
XFILLER_115_47 VGND VGND VPWR VPWR sky130_fd_sc_hd__fill_2
X_07996_ net605 net603 net402 VGND VGND VPWR VPWR _00733_ sky130_fd_sc_hd__and3_1
Xfanout269 net271 VGND VGND VPWR VPWR net269 sky130_fd_sc_hd__buf_2
X_06947_ _04927_ _04938_ VGND VGND VPWR VPWR _04949_ sky130_fd_sc_hd__nand2_1
X_09735_ _02496_ _02497_ VGND VGND VPWR VPWR _02499_ sky130_fd_sc_hd__xnor2_1
XTAP_TAPCELL_ROW_87_1511 VGND VPWR sky130_fd_sc_hd__tapvpwrvgnd_1
X_09666_ _02087_ net624 _02422_ VGND VGND VPWR VPWR _02423_ sky130_fd_sc_hd__a21oi_1
XFILLER_27_312 VGND VGND VPWR VPWR sky130_fd_sc_hd__decap_8
XFILLER_27_334 VGND VGND VPWR VPWR sky130_fd_sc_hd__fill_2
XTAP_TAPCELL_ROW_38_830 VGND VPWR sky130_fd_sc_hd__tapvpwrvgnd_1
XFILLER_131_57 VPWR VGND VPWR VGND sky130_ef_sc_hd__decap_12
X_08617_ _01343_ _01344_ VGND VGND VPWR VPWR _01345_ sky130_fd_sc_hd__xnor2_1
XFILLER_70_602 VGND VGND VPWR VPWR sky130_fd_sc_hd__fill_1
X_06878_ net427 net387 VGND VGND VPWR VPWR _04199_ sky130_fd_sc_hd__and2_1
XFILLER_54_153 VPWR VGND VPWR VGND sky130_ef_sc_hd__decap_12
X_09597_ _02336_ _02348_ VGND VGND VPWR VPWR _02350_ sky130_fd_sc_hd__xor2_1
XFILLER_91_28 VGND VGND VPWR VPWR sky130_fd_sc_hd__fill_1
XFILLER_70_613 VGND VGND VPWR VPWR sky130_fd_sc_hd__decap_4
XFILLER_54_197 VGND VGND VPWR VPWR sky130_fd_sc_hd__decap_4
X_08548_ _01269_ _01270_ _01276_ VGND VGND VPWR VPWR _01277_ sky130_fd_sc_hd__nand3_2
XFILLER_42_359 VGND VGND VPWR VPWR sky130_fd_sc_hd__decap_4
X_08479_ _01200_ _01207_ VGND VGND VPWR VPWR _01208_ sky130_fd_sc_hd__or2_1
XFILLER_11_702 VPWR VGND VPWR VGND sky130_ef_sc_hd__decap_12
XFILLER_10_201 VPWR VGND VPWR VGND sky130_ef_sc_hd__decap_12
X_10510_ net663 net87 net273 net686 VGND VGND VPWR VPWR _03339_ sky130_fd_sc_hd__a22o_1
X_11490_ _04163_ _04410_ VGND VGND VPWR VPWR _04411_ sky130_fd_sc_hd__xnor2_1
X_10441_ net434 net417 net577 net576 VGND VGND VPWR VPWR _03264_ sky130_fd_sc_hd__and4_1
XFILLER_10_267 VGND VGND VPWR VPWR sky130_fd_sc_hd__fill_2
XFILLER_10_245 VGND VGND VPWR VPWR sky130_fd_sc_hd__decap_6
XFILLER_109_667 VGND VGND VPWR VPWR sky130_fd_sc_hd__decap_4
XTAP_TAPCELL_ROW_98_1673 VGND VPWR sky130_fd_sc_hd__tapvpwrvgnd_1
XTAP_TAPCELL_ROW_98_1662 VGND VPWR sky130_fd_sc_hd__tapvpwrvgnd_1
XFILLER_124_626 VPWR VGND VPWR VGND sky130_ef_sc_hd__decap_12
X_10372_ net639 net278 net276 net663 VGND VGND VPWR VPWR _03189_ sky130_fd_sc_hd__a22oi_1
X_13160_ _06097_ _06229_ VGND VGND VPWR VPWR _06230_ sky130_fd_sc_hd__xor2_1
X_12111_ net515 net362 VGND VGND VPWR VPWR _05084_ sky130_fd_sc_hd__nand2_1
X_13091_ _06154_ _06132_ VGND VGND VPWR VPWR _06155_ sky130_fd_sc_hd__and2b_1
XFILLER_78_713 VGND VGND VPWR VPWR sky130_fd_sc_hd__fill_1
X_12042_ _05007_ _05008_ VGND VGND VPWR VPWR _05009_ sky130_fd_sc_hd__xnor2_1
XFILLER_2_433 VPWR VGND VPWR VGND sky130_ef_sc_hd__decap_12
XFILLER_132_681 VPWR VGND VPWR VGND sky130_ef_sc_hd__decap_12
XFILLER_77_223 VGND VGND VPWR VPWR sky130_fd_sc_hd__fill_1
XFILLER_49_41 VGND VGND VPWR VPWR sky130_fd_sc_hd__decap_3
XFILLER_2_477 VPWR VGND VPWR VGND sky130_ef_sc_hd__decap_12
XFILLER_78_757 VGND VGND VPWR VPWR sky130_fd_sc_hd__fill_2
XFILLER_77_245 VGND VGND VPWR VPWR sky130_fd_sc_hd__fill_2
XFILLER_1_15 VPWR VGND VPWR VGND sky130_ef_sc_hd__decap_12
XTAP_TAPCELL_ROW_125_2047 VGND VPWR sky130_fd_sc_hd__tapvpwrvgnd_1
XFILLER_58_492 VGND VGND VPWR VPWR sky130_fd_sc_hd__fill_1
X_12944_ net581 _05992_ VGND VGND VPWR VPWR _05994_ sky130_fd_sc_hd__and2_1
XFILLER_73_462 VGND VGND VPWR VPWR sky130_fd_sc_hd__fill_2
XFILLER_45_153 VPWR VGND VPWR VGND sky130_ef_sc_hd__decap_12
XFILLER_45_186 VGND VGND VPWR VPWR sky130_fd_sc_hd__fill_1
XTAP_TAPCELL_ROW_16_513 VGND VPWR sky130_fd_sc_hd__tapvpwrvgnd_1
XTAP_TAPCELL_ROW_16_524 VGND VPWR sky130_fd_sc_hd__tapvpwrvgnd_1
XFILLER_18_389 VGND VGND VPWR VPWR sky130_fd_sc_hd__decap_8
X_12875_ _05915_ _05917_ VGND VGND VPWR VPWR _05919_ sky130_fd_sc_hd__xnor2_1
XFILLER_33_337 VPWR VGND VPWR VGND sky130_ef_sc_hd__decap_12
XTAP_TAPCELL_ROW_107_1791 VGND VPWR sky130_fd_sc_hd__tapvpwrvgnd_1
XFILLER_61_679 VGND VGND VPWR VPWR sky130_fd_sc_hd__fill_1
X_11826_ _04771_ _04770_ _04772_ VGND VGND VPWR VPWR _04773_ sky130_fd_sc_hd__or3_4
XFILLER_121_90 VPWR VGND VPWR VGND sky130_ef_sc_hd__decap_12
X_11757_ _04688_ _04696_ VGND VGND VPWR VPWR _04698_ sky130_fd_sc_hd__and2b_1
XTAP_TAPCELL_ROW_120_1980 VGND VPWR sky130_fd_sc_hd__tapvpwrvgnd_1
X_10708_ _03538_ _03555_ VGND VGND VPWR VPWR _03556_ sky130_fd_sc_hd__xor2_1
X_11688_ net456 net600 VGND VGND VPWR VPWR _04623_ sky130_fd_sc_hd__nand2_1
XTAP_TAPCELL_ROW_58_1101 VGND VPWR sky130_fd_sc_hd__tapvpwrvgnd_1
X_10639_ _03448_ _03480_ VGND VGND VPWR VPWR _03481_ sky130_fd_sc_hd__nand2_1
XTAP_TAPCELL_ROW_136_2198 VGND VPWR sky130_fd_sc_hd__tapvpwrvgnd_1
X_13358_ clknet_3_3__leaf_clk _00045_ _00068_ VGND VGND VPWR VPWR net172 sky130_fd_sc_hd__dfrtp_1
XTAP_TAPCELL_ROW_58_1112 VGND VPWR sky130_fd_sc_hd__tapvpwrvgnd_1
XFILLER_127_497 VGND VGND VPWR VPWR sky130_fd_sc_hd__decap_6
X_12309_ _05119_ _05121_ _05297_ VGND VGND VPWR VPWR _05301_ sky130_fd_sc_hd__and3_1
XFILLER_102_309 VGND VGND VPWR VPWR sky130_fd_sc_hd__fill_1
XFILLER_5_293 VPWR VGND VPWR VGND sky130_ef_sc_hd__decap_12
X_13289_ _06319_ _06369_ VGND VGND VPWR VPWR _00031_ sky130_fd_sc_hd__xnor2_1
XPHY_EDGE_ROW_18_Right_18 VGND VGND VPWR VPWR sky130_fd_sc_hd__decap_3
XFILLER_122_191 VGND VGND VPWR VPWR sky130_fd_sc_hd__decap_4
X_07850_ net620 net594 net303 net73 VGND VGND VPWR VPWR _00588_ sky130_fd_sc_hd__and4b_1
XFILLER_68_234 VPWR VGND VPWR VGND sky130_ef_sc_hd__decap_12
X_06801_ net267 net317 VGND VGND VPWR VPWR _03357_ sky130_fd_sc_hd__nand2_1
XFILLER_96_587 VGND VGND VPWR VPWR sky130_fd_sc_hd__fill_1
X_07781_ net749 net381 _00379_ _00378_ VGND VGND VPWR VPWR _00520_ sky130_fd_sc_hd__a31o_1
XFILLER_68_289 VGND VGND VPWR VPWR sky130_fd_sc_hd__fill_1
X_06732_ _02522_ _02588_ VGND VGND VPWR VPWR _02610_ sky130_fd_sc_hd__or2_1
X_09520_ _02111_ _02265_ VGND VGND VPWR VPWR _02266_ sky130_fd_sc_hd__nand2_1
Xinput3 in0[2] VGND VGND VPWR VPWR net3 sky130_fd_sc_hd__buf_6
XTAP_TAPCELL_ROW_69_1263 VGND VPWR sky130_fd_sc_hd__tapvpwrvgnd_1
XFILLER_25_805 VGND VGND VPWR VPWR sky130_fd_sc_hd__decap_3
XFILLER_36_131 VGND VGND VPWR VPWR sky130_fd_sc_hd__decap_8
XFILLER_36_153 VGND VGND VPWR VPWR sky130_fd_sc_hd__decap_4
XFILLER_37_665 VGND VGND VPWR VPWR sky130_fd_sc_hd__decap_6
XFILLER_91_281 VGND VGND VPWR VPWR sky130_fd_sc_hd__decap_4
X_09451_ _02006_ _02015_ _02014_ VGND VGND VPWR VPWR _02191_ sky130_fd_sc_hd__o21ai_2
XFILLER_37_687 VGND VGND VPWR VPWR sky130_fd_sc_hd__fill_1
XFILLER_37_698 VPWR VGND VPWR VGND sky130_ef_sc_hd__decap_12
X_09382_ _02111_ _02113_ VGND VGND VPWR VPWR _02115_ sky130_fd_sc_hd__xnor2_1
XFILLER_101_49 VGND VGND VPWR VPWR sky130_fd_sc_hd__decap_6
XTAP_TAPCELL_ROW_82_1441 VGND VPWR sky130_fd_sc_hd__tapvpwrvgnd_1
X_08402_ _01129_ _01130_ VGND VGND VPWR VPWR _01132_ sky130_fd_sc_hd__xnor2_1
XPHY_EDGE_ROW_27_Right_27 VGND VGND VPWR VPWR sky130_fd_sc_hd__decap_3
XFILLER_40_808 VGND VGND VPWR VPWR sky130_fd_sc_hd__decap_3
X_08333_ _01060_ _01066_ VGND VGND VPWR VPWR _01067_ sky130_fd_sc_hd__xnor2_1
X_08264_ _00750_ _00867_ _00669_ VGND VGND VPWR VPWR _00999_ sky130_fd_sc_hd__o21ai_1
XFILLER_20_565 VGND VGND VPWR VPWR sky130_fd_sc_hd__decap_8
X_08195_ _00929_ _00930_ VGND VGND VPWR VPWR _00931_ sky130_fd_sc_hd__and2b_1
X_07215_ _06403_ _06430_ _06428_ VGND VGND VPWR VPWR _06506_ sky130_fd_sc_hd__o21a_1
XFILLER_118_475 VGND VGND VPWR VPWR sky130_fd_sc_hd__fill_1
X_07146_ net445 net608 VGND VGND VPWR VPWR _06438_ sky130_fd_sc_hd__nand2_1
X_07077_ net642 net317 net307 net667 VGND VGND VPWR VPWR _06367_ sky130_fd_sc_hd__a22oi_1
XFILLER_10_46 VGND VGND VPWR VPWR sky130_fd_sc_hd__decap_8
XFILLER_105_169 VPWR VGND VPWR VGND sky130_ef_sc_hd__decap_12
XPHY_EDGE_ROW_36_Right_36 VGND VGND VPWR VPWR sky130_fd_sc_hd__decap_3
XTAP_TAPCELL_ROW_93_1592 VGND VPWR sky130_fd_sc_hd__tapvpwrvgnd_1
XFILLER_101_375 VGND VGND VPWR VPWR sky130_fd_sc_hd__decap_6
XFILLER_101_342 VGND VGND VPWR VPWR sky130_fd_sc_hd__decap_6
XFILLER_59_278 VGND VGND VPWR VPWR sky130_fd_sc_hd__fill_2
XFILLER_47_429 VGND VGND VPWR VPWR sky130_fd_sc_hd__decap_8
XFILLER_19_55 VGND VGND VPWR VPWR sky130_fd_sc_hd__fill_1
XFILLER_19_109 VGND VGND VPWR VPWR sky130_fd_sc_hd__decap_3
X_09718_ _02450_ _02478_ VGND VGND VPWR VPWR _02481_ sky130_fd_sc_hd__xor2_1
X_07979_ _00713_ _00714_ VGND VGND VPWR VPWR _00716_ sky130_fd_sc_hd__xor2_1
XFILLER_74_237 VPWR VGND VPWR VGND sky130_ef_sc_hd__decap_12
XFILLER_90_708 VGND VGND VPWR VPWR sky130_fd_sc_hd__fill_2
X_10990_ _03738_ _03741_ _03862_ VGND VGND VPWR VPWR _03864_ sky130_fd_sc_hd__and3_1
XFILLER_16_805 VGND VGND VPWR VPWR sky130_fd_sc_hd__decap_6
X_09649_ net537 _02403_ VGND VGND VPWR VPWR _02405_ sky130_fd_sc_hd__and2_1
XFILLER_70_421 VGND VGND VPWR VPWR sky130_fd_sc_hd__fill_2
XFILLER_55_473 VGND VGND VPWR VPWR sky130_fd_sc_hd__decap_8
XPHY_EDGE_ROW_45_Right_45 VGND VGND VPWR VPWR sky130_fd_sc_hd__decap_3
XFILLER_43_624 VGND VGND VPWR VPWR sky130_fd_sc_hd__fill_1
XFILLER_15_304 VGND VGND VPWR VPWR sky130_fd_sc_hd__decap_8
XFILLER_15_326 VGND VGND VPWR VPWR sky130_fd_sc_hd__decap_4
XFILLER_82_292 VPWR VGND VPWR VGND sky130_ef_sc_hd__decap_12
XFILLER_70_443 VGND VGND VPWR VPWR sky130_fd_sc_hd__decap_8
XFILLER_15_337 VGND VGND VPWR VPWR sky130_fd_sc_hd__fill_1
X_12660_ _05682_ _05683_ VGND VGND VPWR VPWR _05684_ sky130_fd_sc_hd__nor2_1
X_11611_ _04528_ _04541_ VGND VGND VPWR VPWR _04542_ sky130_fd_sc_hd__xnor2_1
X_12591_ net290 net44 VGND VGND VPWR VPWR _05609_ sky130_fd_sc_hd__and2_1
XFILLER_129_729 VPWR VGND VPWR VGND sky130_ef_sc_hd__decap_12
X_11542_ _04331_ _04357_ _04329_ VGND VGND VPWR VPWR _04467_ sky130_fd_sc_hd__o21ba_1
XTAP_TAPCELL_ROW_41_869 VGND VPWR sky130_fd_sc_hd__tapvpwrvgnd_1
X_11473_ _04390_ _04391_ VGND VGND VPWR VPWR _04392_ sky130_fd_sc_hd__nand2_1
XTAP_TAPCELL_ROW_21_582 VGND VPWR sky130_fd_sc_hd__tapvpwrvgnd_1
X_10424_ _03243_ _03244_ VGND VGND VPWR VPWR _03245_ sky130_fd_sc_hd__or2_1
X_13212_ _05688_ _06286_ VGND VGND VPWR VPWR _06287_ sky130_fd_sc_hd__xnor2_1
XTAP_TAPCELL_ROW_21_593 VGND VPWR sky130_fd_sc_hd__tapvpwrvgnd_1
XPHY_EDGE_ROW_54_Right_54 VGND VGND VPWR VPWR sky130_fd_sc_hd__decap_3
X_13143_ _06211_ _06210_ VGND VGND VPWR VPWR _06212_ sky130_fd_sc_hd__nand2b_1
XFILLER_124_445 VPWR VGND VPWR VGND sky130_ef_sc_hd__decap_12
X_10355_ _03032_ _03034_ _03169_ net899 VGND VGND VPWR VPWR _03171_ sky130_fd_sc_hd__a211oi_4
XFILLER_3_753 VPWR VGND VPWR VGND sky130_ef_sc_hd__decap_12
XFILLER_78_510 VGND VGND VPWR VPWR sky130_fd_sc_hd__decap_6
X_10286_ _03092_ _03093_ _03094_ VGND VGND VPWR VPWR _03095_ sky130_fd_sc_hd__and3_1
XTAP_TAPCELL_ROW_53_1031 VGND VPWR sky130_fd_sc_hd__tapvpwrvgnd_1
XFILLER_3_797 VPWR VGND VPWR VGND sky130_ef_sc_hd__decap_12
X_13074_ net250 net113 _06134_ VGND VGND VPWR VPWR _06136_ sky130_fd_sc_hd__a21oi_1
XTAP_TAPCELL_ROW_53_1042 VGND VPWR sky130_fd_sc_hd__tapvpwrvgnd_1
X_12025_ net690 net293 VGND VGND VPWR VPWR _04990_ sky130_fd_sc_hd__nand2_1
XFILLER_93_502 VGND VGND VPWR VPWR sky130_fd_sc_hd__fill_2
XFILLER_78_576 VPWR VGND VPWR VGND sky130_ef_sc_hd__decap_12
XFILLER_38_407 VPWR VGND VPWR VGND sky130_ef_sc_hd__decap_12
XTAP_TAPCELL_ROW_109_1820 VGND VPWR sky130_fd_sc_hd__tapvpwrvgnd_1
XFILLER_93_524 VPWR VGND VPWR VGND sky130_ef_sc_hd__decap_12
XFILLER_65_237 VPWR VGND VPWR VGND sky130_ef_sc_hd__decap_12
XFILLER_19_621 VPWR VGND VPWR VGND sky130_ef_sc_hd__decap_12
XFILLER_65_259 VGND VGND VPWR VPWR sky130_fd_sc_hd__fill_1
XPHY_EDGE_ROW_63_Right_63 VGND VGND VPWR VPWR sky130_fd_sc_hd__decap_3
XFILLER_74_793 VPWR VGND VPWR VGND sky130_ef_sc_hd__decap_12
X_12927_ _05973_ _05974_ VGND VGND VPWR VPWR _05976_ sky130_fd_sc_hd__nor2_1
XFILLER_18_153 VGND VGND VPWR VPWR sky130_fd_sc_hd__fill_2
XFILLER_73_292 VGND VGND VPWR VPWR sky130_fd_sc_hd__fill_1
X_12858_ _05889_ _05900_ VGND VGND VPWR VPWR _05901_ sky130_fd_sc_hd__nand2b_1
XFILLER_33_145 VPWR VGND VPWR VGND sky130_ef_sc_hd__decap_12
XFILLER_34_657 VPWR VGND VPWR VGND sky130_ef_sc_hd__decap_12
XFILLER_92_82 VGND VGND VPWR VPWR sky130_fd_sc_hd__fill_2
XFILLER_61_487 VPWR VGND VPWR VGND sky130_ef_sc_hd__decap_12
X_11809_ _04628_ _04754_ VGND VGND VPWR VPWR _04755_ sky130_fd_sc_hd__and2_1
XTAP_TAPCELL_ROW_64_1193 VGND VPWR sky130_fd_sc_hd__tapvpwrvgnd_1
X_12789_ _05668_ _05824_ VGND VGND VPWR VPWR _05825_ sky130_fd_sc_hd__nor2_1
XFILLER_134_209 VPWR VGND VPWR VGND sky130_ef_sc_hd__decap_12
X_07000_ _03817_ _05505_ _05516_ VGND VGND VPWR VPWR _05527_ sky130_fd_sc_hd__a21o_1
XPHY_EDGE_ROW_72_Right_72 VGND VGND VPWR VPWR sky130_fd_sc_hd__decap_3
XFILLER_115_423 VGND VGND VPWR VPWR sky130_fd_sc_hd__fill_2
X_08951_ net407 net557 VGND VGND VPWR VPWR _01677_ sky130_fd_sc_hd__nand2_2
X_08882_ _01605_ _01606_ VGND VGND VPWR VPWR _01608_ sky130_fd_sc_hd__xnor2_1
X_07902_ _00636_ _00637_ VGND VGND VPWR VPWR _00640_ sky130_fd_sc_hd__xnor2_1
X_07833_ _00568_ _00569_ VGND VGND VPWR VPWR _00572_ sky130_fd_sc_hd__xnor2_1
XPHY_EDGE_ROW_81_Right_81 VGND VGND VPWR VPWR sky130_fd_sc_hd__decap_3
XFILLER_112_15 VPWR VGND VPWR VGND sky130_ef_sc_hd__decap_12
X_07764_ _00500_ _00501_ VGND VGND VPWR VPWR _00503_ sky130_fd_sc_hd__xnor2_1
XFILLER_37_440 VGND VGND VPWR VPWR sky130_fd_sc_hd__decap_8
X_09503_ _02244_ _02245_ _02246_ VGND VGND VPWR VPWR _02247_ sky130_fd_sc_hd__or3_1
X_07695_ _06672_ _00303_ _00300_ VGND VGND VPWR VPWR _00434_ sky130_fd_sc_hd__a21oi_1
X_06715_ net390 net696 net516 net388 VGND VGND VPWR VPWR _02424_ sky130_fd_sc_hd__and4_1
XFILLER_65_782 VGND VGND VPWR VPWR sky130_fd_sc_hd__fill_2
XFILLER_25_613 VGND VGND VPWR VPWR sky130_fd_sc_hd__decap_3
X_09434_ _02025_ _02032_ _02030_ VGND VGND VPWR VPWR _02172_ sky130_fd_sc_hd__a21o_1
X_09365_ _02094_ _02095_ VGND VGND VPWR VPWR _02096_ sky130_fd_sc_hd__and2_1
XFILLER_40_638 VGND VGND VPWR VPWR sky130_fd_sc_hd__fill_1
X_08316_ _01043_ _01049_ VGND VGND VPWR VPWR _01050_ sky130_fd_sc_hd__xnor2_1
X_09296_ net313 net329 net327 net336 VGND VGND VPWR VPWR _02021_ sky130_fd_sc_hd__a22o_1
XANTENNA_30 _02109_ VGND VGND VPWR VPWR sky130_fd_sc_hd__diode_2
X_08247_ _00965_ _00981_ VGND VGND VPWR VPWR _00982_ sky130_fd_sc_hd__xnor2_1
XPHY_EDGE_ROW_90_Right_90 VGND VGND VPWR VPWR sky130_fd_sc_hd__decap_3
XFILLER_119_751 VGND VGND VPWR VPWR sky130_fd_sc_hd__decap_6
XTAP_TAPCELL_ROW_95_1621 VGND VPWR sky130_fd_sc_hd__tapvpwrvgnd_1
X_08178_ _00912_ _00913_ VGND VGND VPWR VPWR _00914_ sky130_fd_sc_hd__or2_1
XFILLER_21_78 VGND VGND VPWR VPWR sky130_fd_sc_hd__fill_1
XFILLER_118_294 VGND VGND VPWR VPWR sky130_fd_sc_hd__decap_8
X_07129_ _06419_ _06420_ _05648_ VGND VGND VPWR VPWR _06421_ sky130_fd_sc_hd__a21oi_1
Xoutput170 net170 VGND VGND VPWR VPWR out0[2] sky130_fd_sc_hd__buf_2
X_10140_ _02875_ _02879_ VGND VGND VPWR VPWR _02936_ sky130_fd_sc_hd__nand2b_1
XFILLER_0_701 VPWR VGND VPWR VGND sky130_ef_sc_hd__decap_12
XFILLER_133_297 VGND VGND VPWR VPWR sky130_fd_sc_hd__decap_6
X_10071_ _02814_ _02859_ VGND VGND VPWR VPWR _02861_ sky130_fd_sc_hd__nor2_1
Xoutput192 net192 VGND VGND VPWR VPWR out1[8] sky130_fd_sc_hd__buf_2
Xoutput181 net181 VGND VGND VPWR VPWR out1[12] sky130_fd_sc_hd__buf_2
XFILLER_102_651 VGND VGND VPWR VPWR sky130_fd_sc_hd__decap_8
XFILLER_75_502 VGND VGND VPWR VPWR sky130_fd_sc_hd__fill_2
XTAP_TAPCELL_ROW_7_399 VGND VPWR sky130_fd_sc_hd__tapvpwrvgnd_1
XTAP_TAPCELL_ROW_7_388 VGND VPWR sky130_fd_sc_hd__tapvpwrvgnd_1
XFILLER_102_684 VGND VGND VPWR VPWR sky130_fd_sc_hd__fill_1
XFILLER_87_384 VGND VGND VPWR VPWR sky130_fd_sc_hd__decap_8
XFILLER_75_524 VGND VGND VPWR VPWR sky130_fd_sc_hd__decap_3
XTAP_TAPCELL_ROW_122_2006 VGND VPWR sky130_fd_sc_hd__tapvpwrvgnd_1
XTAP_TAPCELL_ROW_46_939 VGND VPWR sky130_fd_sc_hd__tapvpwrvgnd_1
X_10973_ _03670_ _03672_ _03844_ _03845_ VGND VGND VPWR VPWR _03846_ sky130_fd_sc_hd__o211ai_2
XFILLER_55_281 VPWR VGND VPWR VGND sky130_ef_sc_hd__decap_12
XFILLER_43_443 VGND VGND VPWR VPWR sky130_fd_sc_hd__decap_4
X_12712_ _05709_ _05739_ VGND VGND VPWR VPWR _05741_ sky130_fd_sc_hd__xnor2_1
XTAP_TAPCELL_ROW_104_1750 VGND VPWR sky130_fd_sc_hd__tapvpwrvgnd_1
XFILLER_102_81 VGND VGND VPWR VPWR sky130_fd_sc_hd__decap_3
XFILLER_71_785 VGND VGND VPWR VPWR sky130_fd_sc_hd__fill_2
XTAP_TAPCELL_ROW_26_652 VGND VPWR sky130_fd_sc_hd__tapvpwrvgnd_1
XTAP_TAPCELL_ROW_26_663 VGND VPWR sky130_fd_sc_hd__tapvpwrvgnd_1
XFILLER_62_52 VGND VGND VPWR VPWR sky130_fd_sc_hd__fill_1
XFILLER_62_41 VGND VGND VPWR VPWR sky130_fd_sc_hd__decap_4
XFILLER_31_649 VGND VGND VPWR VPWR sky130_fd_sc_hd__fill_1
X_12643_ _05663_ _05664_ VGND VGND VPWR VPWR _05665_ sky130_fd_sc_hd__nor2_1
XFILLER_62_85 VGND VGND VPWR VPWR sky130_fd_sc_hd__decap_3
X_12574_ net599 net588 net404 VGND VGND VPWR VPWR _05590_ sky130_fd_sc_hd__o21ai_4
X_11525_ _04096_ _04194_ VGND VGND VPWR VPWR _04448_ sky130_fd_sc_hd__or2_1
XFILLER_116_209 VGND VGND VPWR VPWR sky130_fd_sc_hd__fill_1
XFILLER_7_69 VGND VGND VPWR VPWR sky130_fd_sc_hd__decap_6
XTAP_TAPCELL_ROW_133_2157 VGND VPWR sky130_fd_sc_hd__tapvpwrvgnd_1
XFILLER_125_721 VGND VGND VPWR VPWR sky130_fd_sc_hd__decap_6
X_11456_ _04371_ _04370_ VGND VGND VPWR VPWR _04373_ sky130_fd_sc_hd__and2b_1
XFILLER_125_765 VPWR VGND VPWR VGND sky130_ef_sc_hd__decap_12
X_10407_ net531 net526 net648 net636 VGND VGND VPWR VPWR _03227_ sky130_fd_sc_hd__and4_1
X_11387_ net246 _04167_ VGND VGND VPWR VPWR _04298_ sky130_fd_sc_hd__nand2_1
XFILLER_112_415 VGND VGND VPWR VPWR sky130_fd_sc_hd__decap_4
X_10338_ _03147_ _03148_ _03149_ VGND VGND VPWR VPWR _03153_ sky130_fd_sc_hd__a21oi_1
XFILLER_3_561 VPWR VGND VPWR VGND sky130_ef_sc_hd__decap_12
X_13126_ _06190_ _06191_ _06177_ VGND VGND VPWR VPWR _06193_ sky130_fd_sc_hd__o21ai_1
X_13057_ _05891_ _06116_ VGND VGND VPWR VPWR _06118_ sky130_fd_sc_hd__nor2_1
XFILLER_97_159 VGND VGND VPWR VPWR sky130_fd_sc_hd__decap_8
X_12008_ _04969_ _04970_ _04826_ _04830_ VGND VGND VPWR VPWR _04973_ sky130_fd_sc_hd__o211a_1
X_10269_ _03072_ _03073_ VGND VGND VPWR VPWR _03077_ sky130_fd_sc_hd__xnor2_1
XFILLER_39_716 VGND VGND VPWR VPWR sky130_fd_sc_hd__fill_1
XFILLER_39_727 VGND VGND VPWR VPWR sky130_fd_sc_hd__fill_1
XFILLER_78_384 VPWR VGND VPWR VGND sky130_ef_sc_hd__decap_12
XFILLER_81_538 VPWR VGND VPWR VGND sky130_ef_sc_hd__decap_12
XFILLER_47_793 VGND VGND VPWR VPWR sky130_fd_sc_hd__fill_1
XFILLER_47_782 VGND VGND VPWR VPWR sky130_fd_sc_hd__fill_2
X_07480_ _06618_ _06620_ VGND VGND VPWR VPWR _00221_ sky130_fd_sc_hd__or2_1
XTAP_TAPCELL_ROW_66_1222 VGND VPWR sky130_fd_sc_hd__tapvpwrvgnd_1
XFILLER_62_741 VPWR VGND VPWR VGND sky130_ef_sc_hd__decap_12
XFILLER_34_421 VGND VGND VPWR VPWR sky130_fd_sc_hd__decap_8
X_09150_ net335 net329 net327 net766 VGND VGND VPWR VPWR _01875_ sky130_fd_sc_hd__a22oi_1
XFILLER_21_148 VGND VGND VPWR VPWR sky130_fd_sc_hd__fill_1
X_09081_ net509 net627 net128 net523 VGND VGND VPWR VPWR _01806_ sky130_fd_sc_hd__a22o_1
X_08101_ _06588_ _00836_ VGND VGND VPWR VPWR _00837_ sky130_fd_sc_hd__xnor2_1
XFILLER_107_209 VGND VGND VPWR VPWR sky130_fd_sc_hd__decap_4
X_08032_ _00757_ _00768_ VGND VGND VPWR VPWR _00769_ sky130_fd_sc_hd__xnor2_1
XFILLER_30_693 VGND VGND VPWR VPWR sky130_fd_sc_hd__decap_6
Xinput72 w10[6] VGND VGND VPWR VPWR net72 sky130_fd_sc_hd__clkbuf_1
XFILLER_135_529 VPWR VGND VPWR VGND sky130_ef_sc_hd__decap_12
Xinput61 w03[3] VGND VGND VPWR VPWR net61 sky130_fd_sc_hd__buf_1
Xinput50 w02[0] VGND VGND VPWR VPWR net50 sky130_fd_sc_hd__clkbuf_1
Xinput94 w13[4] VGND VGND VPWR VPWR net94 sky130_fd_sc_hd__buf_1
XFILLER_115_220 VGND VGND VPWR VPWR sky130_fd_sc_hd__decap_4
XTAP_TAPCELL_ROW_77_1373 VGND VPWR sky130_fd_sc_hd__tapvpwrvgnd_1
Xinput83 w12[1] VGND VGND VPWR VPWR net83 sky130_fd_sc_hd__buf_1
XFILLER_115_275 VGND VGND VPWR VPWR sky130_fd_sc_hd__decap_4
X_09983_ _02687_ _02700_ _02699_ VGND VGND VPWR VPWR _02768_ sky130_fd_sc_hd__o21bai_1
XFILLER_107_15 VPWR VGND VPWR VGND sky130_ef_sc_hd__decap_12
XFILLER_130_212 VGND VGND VPWR VPWR sky130_fd_sc_hd__decap_6
XTAP_TAPCELL_ROW_90_1551 VGND VPWR sky130_fd_sc_hd__tapvpwrvgnd_1
X_08934_ net456 net549 _01657_ _01658_ VGND VGND VPWR VPWR _01660_ sky130_fd_sc_hd__nand4_1
XFILLER_67_19 VGND VGND VPWR VPWR sky130_fd_sc_hd__decap_8
XFILLER_111_470 VGND VGND VPWR VPWR sky130_fd_sc_hd__fill_1
X_08865_ _01346_ _01465_ _01590_ VGND VGND VPWR VPWR _01591_ sky130_fd_sc_hd__or3_1
XFILLER_69_373 VGND VGND VPWR VPWR sky130_fd_sc_hd__decap_8
XTAP_TAPCELL_ROW_4_347 VGND VPWR sky130_fd_sc_hd__tapvpwrvgnd_1
X_07816_ _00552_ _00553_ VGND VGND VPWR VPWR _00555_ sky130_fd_sc_hd__xnor2_1
X_08796_ _01521_ _01522_ VGND VGND VPWR VPWR _01523_ sky130_fd_sc_hd__and2b_1
XFILLER_72_505 VPWR VGND VPWR VGND sky130_ef_sc_hd__decap_12
XFILLER_57_568 VPWR VGND VPWR VGND sky130_ef_sc_hd__decap_12
XFILLER_57_557 VGND VGND VPWR VPWR sky130_fd_sc_hd__decap_3
XFILLER_123_69 VPWR VGND VPWR VGND sky130_ef_sc_hd__decap_12
X_07747_ _00333_ _00483_ _00485_ VGND VGND VPWR VPWR _00486_ sky130_fd_sc_hd__o21ai_1
XFILLER_44_229 VPWR VGND VPWR VGND sky130_ef_sc_hd__decap_12
XFILLER_16_23 VGND VGND VPWR VPWR sky130_fd_sc_hd__decap_4
XFILLER_37_270 VGND VGND VPWR VPWR sky130_fd_sc_hd__decap_3
X_07678_ _00325_ _00416_ _00417_ VGND VGND VPWR VPWR _00418_ sky130_fd_sc_hd__nand3_1
XFILLER_53_785 VGND VGND VPWR VPWR sky130_fd_sc_hd__fill_2
XFILLER_52_251 VGND VGND VPWR VPWR sky130_fd_sc_hd__fill_1
XPHY_EDGE_ROW_0_Right_0 VGND VGND VPWR VPWR sky130_fd_sc_hd__decap_3
X_09417_ _02148_ _02151_ VGND VGND VPWR VPWR _02154_ sky130_fd_sc_hd__xnor2_1
XTAP_TAPCELL_ROW_23_611 VGND VPWR sky130_fd_sc_hd__tapvpwrvgnd_1
XTAP_TAPCELL_ROW_23_622 VGND VPWR sky130_fd_sc_hd__tapvpwrvgnd_1
X_09348_ _02078_ VGND VGND VPWR VPWR _02079_ sky130_fd_sc_hd__inv_2
XFILLER_32_55 VPWR VGND VPWR VGND sky130_ef_sc_hd__decap_12
X_09279_ net422 net550 net548 net438 VGND VGND VPWR VPWR _02003_ sky130_fd_sc_hd__a22oi_1
XFILLER_20_170 VGND VGND VPWR VPWR sky130_fd_sc_hd__fill_1
X_11310_ _04212_ _04213_ VGND VGND VPWR VPWR _04214_ sky130_fd_sc_hd__xnor2_1
XFILLER_113_3 VPWR VGND VPWR VGND sky130_ef_sc_hd__decap_12
X_12290_ _05247_ _05279_ VGND VGND VPWR VPWR _05280_ sky130_fd_sc_hd__nand2_1
X_11241_ _04109_ _04138_ VGND VGND VPWR VPWR _04139_ sky130_fd_sc_hd__nor2_1
XFILLER_106_253 VGND VGND VPWR VPWR sky130_fd_sc_hd__decap_3
X_11172_ _04025_ _04062_ VGND VGND VPWR VPWR _04063_ sky130_fd_sc_hd__and2b_1
XFILLER_122_757 VPWR VGND VPWR VGND sky130_ef_sc_hd__decap_12
XFILLER_122_735 VGND VGND VPWR VPWR sky130_fd_sc_hd__fill_2
XFILLER_121_223 VGND VGND VPWR VPWR sky130_fd_sc_hd__fill_1
X_10123_ _02860_ _02907_ VGND VGND VPWR VPWR _02917_ sky130_fd_sc_hd__nor2_1
XFILLER_0_531 VGND VGND VPWR VPWR sky130_fd_sc_hd__fill_1
XTAP_TAPCELL_ROW_50_1001 VGND VPWR sky130_fd_sc_hd__tapvpwrvgnd_1
X_10054_ net520 net654 VGND VGND VPWR VPWR _02842_ sky130_fd_sc_hd__nand2_1
XFILLER_87_192 VGND VGND VPWR VPWR sky130_fd_sc_hd__fill_1
XFILLER_57_85 VGND VGND VPWR VPWR sky130_fd_sc_hd__fill_2
XFILLER_48_579 VGND VGND VPWR VPWR sky130_fd_sc_hd__fill_1
XFILLER_35_229 VGND VGND VPWR VPWR sky130_fd_sc_hd__fill_1
XPHY_EDGE_ROW_121_Right_121 VGND VGND VPWR VPWR sky130_fd_sc_hd__decap_3
XFILLER_113_80 VGND VGND VPWR VPWR sky130_fd_sc_hd__fill_1
XFILLER_16_421 VPWR VGND VPWR VGND sky130_ef_sc_hd__decap_12
X_10956_ _03821_ _03826_ VGND VGND VPWR VPWR _03827_ sky130_fd_sc_hd__nand2_1
XFILLER_73_84 VGND VGND VPWR VPWR sky130_fd_sc_hd__decap_8
X_10887_ net475 net652 net650 VGND VGND VPWR VPWR _03752_ sky130_fd_sc_hd__and3_1
X_12626_ _05469_ _05471_ _05645_ _05646_ VGND VGND VPWR VPWR _05647_ sky130_fd_sc_hd__o211ai_2
XTAP_TAPCELL_ROW_61_1152 VGND VPWR sky130_fd_sc_hd__tapvpwrvgnd_1
XFILLER_8_620 VPWR VGND VPWR VGND sky130_ef_sc_hd__decap_12
XFILLER_78_6 VPWR VGND VPWR VGND sky130_ef_sc_hd__decap_12
XFILLER_8_653 VGND VGND VPWR VPWR sky130_fd_sc_hd__fill_2
X_12557_ _05382_ _05392_ _05391_ VGND VGND VPWR VPWR _05572_ sky130_fd_sc_hd__a21oi_1
XTAP_TAPCELL_ROW_117_1930 VGND VPWR sky130_fd_sc_hd__tapvpwrvgnd_1
X_12488_ _05357_ _05359_ VGND VGND VPWR VPWR _05496_ sky130_fd_sc_hd__nand2_1
XFILLER_8_697 VGND VGND VPWR VPWR sky130_fd_sc_hd__decap_3
X_11508_ _04418_ _04429_ VGND VGND VPWR VPWR _04430_ sky130_fd_sc_hd__and2_1
X_11439_ _04333_ _04353_ VGND VGND VPWR VPWR _04355_ sky130_fd_sc_hd__xnor2_1
XFILLER_125_573 VPWR VGND VPWR VGND sky130_ef_sc_hd__decap_12
XFILLER_112_201 VPWR VGND VPWR VGND sky130_ef_sc_hd__decap_12
XFILLER_98_457 VGND VGND VPWR VPWR sky130_fd_sc_hd__decap_3
X_13109_ _06173_ _06171_ VGND VGND VPWR VPWR _06175_ sky130_fd_sc_hd__and2b_1
X_06980_ _05166_ _05298_ VGND VGND VPWR VPWR _05308_ sky130_fd_sc_hd__xnor2_1
XFILLER_3_391 VGND VGND VPWR VPWR sky130_fd_sc_hd__fill_1
XFILLER_94_630 VGND VGND VPWR VPWR sky130_fd_sc_hd__decap_3
XFILLER_79_671 VGND VGND VPWR VPWR sky130_fd_sc_hd__fill_1
XFILLER_66_321 VPWR VGND VPWR VGND sky130_ef_sc_hd__decap_12
X_08650_ net493 net634 VGND VGND VPWR VPWR _01378_ sky130_fd_sc_hd__nand2_1
XFILLER_93_140 VPWR VGND VPWR VGND sky130_ef_sc_hd__decap_12
XTAP_TAPCELL_ROW_1_306 VGND VPWR sky130_fd_sc_hd__tapvpwrvgnd_1
XFILLER_39_546 VPWR VGND VPWR VGND sky130_ef_sc_hd__decap_12
X_07601_ _00337_ _00338_ _00339_ VGND VGND VPWR VPWR _00341_ sky130_fd_sc_hd__a21o_1
XFILLER_66_365 VGND VGND VPWR VPWR sky130_fd_sc_hd__decap_3
XFILLER_93_184 VGND VGND VPWR VPWR sky130_fd_sc_hd__fill_1
X_08581_ _01299_ _01306_ _01305_ VGND VGND VPWR VPWR _01310_ sky130_fd_sc_hd__a21oi_1
XFILLER_19_281 VGND VGND VPWR VPWR sky130_fd_sc_hd__decap_8
XFILLER_35_741 VGND VGND VPWR VPWR sky130_fd_sc_hd__decap_6
X_07532_ _00271_ _00270_ _06650_ _06652_ VGND VGND VPWR VPWR _00273_ sky130_fd_sc_hd__o211a_1
X_07463_ net453 net136 VGND VGND VPWR VPWR _00204_ sky130_fd_sc_hd__nand2_1
XFILLER_34_262 VPWR VGND VPWR VGND sky130_ef_sc_hd__decap_12
XFILLER_35_785 VGND VGND VPWR VPWR sky130_fd_sc_hd__decap_6
X_09202_ net572 net258 net256 net596 VGND VGND VPWR VPWR _01926_ sky130_fd_sc_hd__a22o_1
XFILLER_50_777 VGND VGND VPWR VPWR sky130_fd_sc_hd__fill_1
XFILLER_10_608 VGND VGND VPWR VPWR sky130_fd_sc_hd__fill_1
X_07394_ _00133_ _00134_ VGND VGND VPWR VPWR _00135_ sky130_fd_sc_hd__nand2_1
X_09133_ _01707_ _01709_ VGND VGND VPWR VPWR _01858_ sky130_fd_sc_hd__or2_1
Xrebuffer205 _02996_ VGND VGND VPWR VPWR net905 sky130_fd_sc_hd__buf_1
Xrebuffer216 net915 VGND VGND VPWR VPWR net916 sky130_fd_sc_hd__clkdlybuf4s18_2
Xrebuffer238 _06063_ VGND VGND VPWR VPWR net938 sky130_fd_sc_hd__buf_1
XTAP_TAPCELL_ROW_79_1402 VGND VPWR sky130_fd_sc_hd__tapvpwrvgnd_1
X_09064_ _01780_ _01786_ VGND VGND VPWR VPWR _01789_ sky130_fd_sc_hd__xor2_1
XFILLER_135_337 VPWR VGND VPWR VGND sky130_ef_sc_hd__decap_12
X_08015_ net483 net678 net476 net679 VGND VGND VPWR VPWR _00752_ sky130_fd_sc_hd__a22o_1
XFILLER_78_29 VGND VGND VPWR VPWR sky130_fd_sc_hd__decap_4
XFILLER_78_18 VGND VGND VPWR VPWR sky130_fd_sc_hd__decap_8
XTAP_TAPCELL_ROW_9_417 VGND VPWR sky130_fd_sc_hd__tapvpwrvgnd_1
XFILLER_89_424 VGND VGND VPWR VPWR sky130_fd_sc_hd__decap_8
XFILLER_1_317 VPWR VGND VPWR VGND sky130_ef_sc_hd__decap_12
XFILLER_103_267 VPWR VGND VPWR VGND sky130_ef_sc_hd__decap_12
X_09966_ _02747_ _02748_ VGND VGND VPWR VPWR _02749_ sky130_fd_sc_hd__xnor2_1
X_09897_ _02672_ _02673_ VGND VGND VPWR VPWR _02676_ sky130_fd_sc_hd__xor2_1
X_08917_ _01641_ _01642_ VGND VGND VPWR VPWR _01643_ sky130_fd_sc_hd__and2b_1
X_08848_ _01573_ _01572_ _01434_ _01436_ VGND VGND VPWR VPWR _01575_ sky130_fd_sc_hd__a211o_1
XFILLER_57_354 VGND VGND VPWR VPWR sky130_fd_sc_hd__fill_1
XFILLER_85_685 VGND VGND VPWR VPWR sky130_fd_sc_hd__fill_2
XFILLER_57_365 VPWR VGND VPWR VGND sky130_ef_sc_hd__decap_12
XFILLER_45_505 VGND VGND VPWR VPWR sky130_fd_sc_hd__decap_8
X_08779_ net487 net634 _01379_ VGND VGND VPWR VPWR _01506_ sky130_fd_sc_hd__a21o_1
XFILLER_84_195 VGND VGND VPWR VPWR sky130_fd_sc_hd__fill_1
X_11790_ _04732_ _04733_ VGND VGND VPWR VPWR _04734_ sky130_fd_sc_hd__and2b_1
X_10810_ _03663_ _03666_ _03603_ VGND VGND VPWR VPWR _03668_ sky130_fd_sc_hd__a21oi_1
XFILLER_13_402 VGND VGND VPWR VPWR sky130_fd_sc_hd__fill_2
XFILLER_25_262 VPWR VGND VPWR VGND sky130_ef_sc_hd__decap_12
X_10741_ _03584_ _03591_ VGND VGND VPWR VPWR _03592_ sky130_fd_sc_hd__and2_1
XFILLER_9_417 VGND VGND VPWR VPWR sky130_fd_sc_hd__decap_6
XFILLER_13_457 VGND VGND VPWR VPWR sky130_fd_sc_hd__fill_2
XFILLER_40_221 VPWR VGND VPWR VGND sky130_ef_sc_hd__decap_12
X_10672_ _03514_ _03515_ VGND VGND VPWR VPWR _03516_ sky130_fd_sc_hd__nor2_1
X_12411_ net420 net587 _05410_ _05411_ VGND VGND VPWR VPWR _05412_ sky130_fd_sc_hd__a22o_1
XFILLER_41_788 VGND VGND VPWR VPWR sky130_fd_sc_hd__decap_4
XFILLER_43_98 VPWR VGND VPWR VGND sky130_ef_sc_hd__decap_12
X_13391_ clknet_3_0__leaf_clk _00020_ _00101_ VGND VGND VPWR VPWR net205 sky130_fd_sc_hd__dfrtp_1
Xclone86 net379 VGND VGND VPWR VPWR net786 sky130_fd_sc_hd__clkbuf_2
X_12342_ _05317_ _05335_ VGND VGND VPWR VPWR _05336_ sky130_fd_sc_hd__xnor2_1
XTAP_TAPCELL_ROW_130_2116 VGND VPWR sky130_fd_sc_hd__tapvpwrvgnd_1
XFILLER_4_133 VGND VGND VPWR VPWR sky130_fd_sc_hd__decap_6
X_12273_ _05258_ _05259_ net312 net369 VGND VGND VPWR VPWR _05261_ sky130_fd_sc_hd__and4bb_1
XFILLER_107_573 VGND VGND VPWR VPWR sky130_fd_sc_hd__decap_4
XFILLER_4_15 VPWR VGND VPWR VGND sky130_ef_sc_hd__decap_12
X_11224_ net649 _03752_ VGND VGND VPWR VPWR _04120_ sky130_fd_sc_hd__nand2_1
XFILLER_4_177 VPWR VGND VPWR VGND sky130_ef_sc_hd__decap_12
XTAP_TAPCELL_ROW_112_1860 VGND VPWR sky130_fd_sc_hd__tapvpwrvgnd_1
X_11155_ _04041_ _04042_ VGND VGND VPWR VPWR _04044_ sky130_fd_sc_hd__xnor2_1
XFILLER_122_587 VGND VGND VPWR VPWR sky130_fd_sc_hd__fill_1
XFILLER_95_449 VPWR VGND VPWR VGND sky130_ef_sc_hd__decap_12
XFILLER_67_129 VPWR VGND VPWR VGND sky130_ef_sc_hd__decap_12
X_10106_ net615 net283 net281 net638 VGND VGND VPWR VPWR _02898_ sky130_fd_sc_hd__a22oi_1
XFILLER_0_361 VGND VGND VPWR VPWR sky130_fd_sc_hd__decap_3
X_11086_ _03966_ _03967_ VGND VGND VPWR VPWR _03969_ sky130_fd_sc_hd__xnor2_2
XFILLER_76_641 VGND VGND VPWR VPWR sky130_fd_sc_hd__decap_3
X_10037_ net944 net353 net350 net513 VGND VGND VPWR VPWR _02824_ sky130_fd_sc_hd__a22o_1
XFILLER_48_343 VGND VGND VPWR VPWR sky130_fd_sc_hd__decap_4
XTAP_TAPCELL_ROW_128_2089 VGND VPWR sky130_fd_sc_hd__tapvpwrvgnd_1
XFILLER_91_600 VPWR VGND VPWR VGND sky130_ef_sc_hd__decap_12
XFILLER_84_50 VGND VGND VPWR VPWR sky130_fd_sc_hd__fill_2
XFILLER_63_302 VGND VGND VPWR VPWR sky130_fd_sc_hd__decap_3
XFILLER_48_365 VPWR VGND VPWR VGND sky130_ef_sc_hd__decap_12
XFILLER_91_633 VPWR VGND VPWR VGND sky130_ef_sc_hd__decap_12
XFILLER_84_83 VGND VGND VPWR VPWR sky130_fd_sc_hd__fill_1
XFILLER_84_61 VGND VGND VPWR VPWR sky130_fd_sc_hd__fill_1
XFILLER_63_368 VPWR VGND VPWR VGND sky130_ef_sc_hd__decap_12
X_11988_ _04947_ _04950_ _04948_ VGND VGND VPWR VPWR _04951_ sky130_fd_sc_hd__and3_1
XFILLER_44_582 VGND VGND VPWR VPWR sky130_fd_sc_hd__decap_6
XFILLER_17_785 VPWR VGND VPWR VGND sky130_ef_sc_hd__decap_12
X_10939_ _03635_ _03636_ _03808_ VGND VGND VPWR VPWR _03809_ sky130_fd_sc_hd__a21oi_1
XFILLER_31_210 VPWR VGND VPWR VGND sky130_ef_sc_hd__decap_12
XFILLER_32_733 VPWR VGND VPWR VGND sky130_ef_sc_hd__decap_12
XFILLER_32_799 VGND VGND VPWR VPWR sky130_fd_sc_hd__decap_8
XFILLER_118_805 VGND VGND VPWR VPWR sky130_fd_sc_hd__decap_6
XFILLER_76_3 VGND VGND VPWR VPWR sky130_fd_sc_hd__fill_1
XTAP_TAPCELL_ROW_14_485 VGND VPWR sky130_fd_sc_hd__tapvpwrvgnd_1
XTAP_TAPCELL_ROW_14_496 VGND VPWR sky130_fd_sc_hd__tapvpwrvgnd_1
X_12609_ _05622_ _05628_ VGND VGND VPWR VPWR _05629_ sky130_fd_sc_hd__and2_1
XFILLER_129_186 VGND VGND VPWR VPWR sky130_fd_sc_hd__decap_4
XFILLER_8_461 VPWR VGND VPWR VGND sky130_ef_sc_hd__decap_12
XFILLER_125_370 VGND VGND VPWR VPWR sky130_fd_sc_hd__fill_1
XTAP_TAPCELL_ROW_74_1332 VGND VPWR sky130_fd_sc_hd__tapvpwrvgnd_1
X_09820_ net487 _02421_ _02425_ VGND VGND VPWR VPWR _02592_ sky130_fd_sc_hd__a21oi_1
XFILLER_99_766 VGND VGND VPWR VPWR sky130_fd_sc_hd__fill_1
XFILLER_98_265 VPWR VGND VPWR VGND sky130_ef_sc_hd__decap_12
Xfanout418 net424 VGND VGND VPWR VPWR net418 sky130_fd_sc_hd__buf_2
Xfanout407 net32 VGND VGND VPWR VPWR net407 sky130_fd_sc_hd__buf_2
Xfanout429 net431 VGND VGND VPWR VPWR net429 sky130_fd_sc_hd__buf_8
X_06963_ net268 net305 VGND VGND VPWR VPWR _05123_ sky130_fd_sc_hd__nand2_1
XFILLER_101_749 VGND VGND VPWR VPWR sky130_fd_sc_hd__decap_8
XFILLER_100_204 VPWR VGND VPWR VGND sky130_ef_sc_hd__decap_12
X_09751_ _02514_ _02515_ VGND VGND VPWR VPWR _02516_ sky130_fd_sc_hd__nor2_1
X_08702_ _01277_ _01279_ _01427_ _01429_ VGND VGND VPWR VPWR _01430_ sky130_fd_sc_hd__a211oi_4
X_09682_ _02440_ _02418_ VGND VGND VPWR VPWR _02441_ sky130_fd_sc_hd__and2b_1
X_06894_ _04287_ _04352_ _04363_ VGND VGND VPWR VPWR _04374_ sky130_fd_sc_hd__and3_1
XFILLER_67_685 VGND VGND VPWR VPWR sky130_fd_sc_hd__fill_2
XFILLER_27_505 VGND VGND VPWR VPWR sky130_fd_sc_hd__decap_4
X_08633_ _01348_ _01360_ VGND VGND VPWR VPWR _01361_ sky130_fd_sc_hd__xnor2_1
XFILLER_81_121 VGND VGND VPWR VPWR sky130_fd_sc_hd__fill_1
XFILLER_67_696 VGND VGND VPWR VPWR sky130_fd_sc_hd__fill_2
XFILLER_27_538 VGND VGND VPWR VPWR sky130_fd_sc_hd__decap_4
X_08564_ _01282_ _01284_ _01283_ VGND VGND VPWR VPWR _01293_ sky130_fd_sc_hd__a21o_1
XTAP_TAPCELL_ROW_85_1483 VGND VPWR sky130_fd_sc_hd__tapvpwrvgnd_1
X_07515_ _06635_ _06637_ _00255_ _00253_ VGND VGND VPWR VPWR _00256_ sky130_fd_sc_hd__a211o_1
X_08495_ _01106_ _01142_ _01170_ VGND VGND VPWR VPWR _01224_ sky130_fd_sc_hd__or3_1
XFILLER_80_19 VGND VGND VPWR VPWR sky130_fd_sc_hd__decap_4
X_07446_ net251 net476 VGND VGND VPWR VPWR _00187_ sky130_fd_sc_hd__nand2_4
XFILLER_10_416 VGND VGND VPWR VPWR sky130_fd_sc_hd__fill_1
XTAP_TAPCELL_ROW_33_750 VGND VPWR sky130_fd_sc_hd__tapvpwrvgnd_1
XTAP_TAPCELL_ROW_33_761 VGND VPWR sky130_fd_sc_hd__tapvpwrvgnd_1
X_07377_ net642 net306 _06514_ _06513_ VGND VGND VPWR VPWR _06667_ sky130_fd_sc_hd__a31oi_1
XFILLER_136_635 VGND VGND VPWR VPWR sky130_fd_sc_hd__decap_4
XFILLER_129_57 VPWR VGND VPWR VGND sky130_ef_sc_hd__decap_12
XFILLER_108_315 VGND VGND VPWR VPWR sky130_fd_sc_hd__fill_1
X_09116_ _01839_ _01840_ VGND VGND VPWR VPWR _01841_ sky130_fd_sc_hd__and2b_1
XFILLER_136_657 VGND VGND VPWR VPWR sky130_fd_sc_hd__decap_4
X_09047_ _01761_ _01762_ _01770_ VGND VGND VPWR VPWR _01772_ sky130_fd_sc_hd__o21ai_1
XFILLER_135_167 VGND VGND VPWR VPWR sky130_fd_sc_hd__fill_1
XFILLER_116_392 VGND VGND VPWR VPWR sky130_fd_sc_hd__decap_3
XFILLER_89_221 VGND VGND VPWR VPWR sky130_fd_sc_hd__decap_3
XFILLER_1_125 VPWR VGND VPWR VGND sky130_ef_sc_hd__decap_12
XFILLER_2_637 VGND VGND VPWR VPWR sky130_fd_sc_hd__decap_6
XFILLER_131_340 VPWR VGND VPWR VGND sky130_ef_sc_hd__decap_12
X_09949_ _02720_ _02722_ VGND VGND VPWR VPWR _02731_ sky130_fd_sc_hd__nor2_1
XFILLER_89_276 VGND VGND VPWR VPWR sky130_fd_sc_hd__decap_4
XFILLER_49_107 VGND VGND VPWR VPWR sky130_fd_sc_hd__decap_4
XFILLER_1_169 VPWR VGND VPWR VGND sky130_ef_sc_hd__decap_12
XFILLER_77_449 VPWR VGND VPWR VGND sky130_ef_sc_hd__decap_12
XFILLER_58_663 VGND VGND VPWR VPWR sky130_fd_sc_hd__decap_4
X_12960_ net486 _06011_ _06010_ VGND VGND VPWR VPWR _06012_ sky130_fd_sc_hd__a21oi_1
XFILLER_38_76 VGND VGND VPWR VPWR sky130_fd_sc_hd__decap_4
X_11911_ net618 net593 net301 net299 VGND VGND VPWR VPWR _04866_ sky130_fd_sc_hd__and4_1
X_12891_ _05907_ _05935_ VGND VGND VPWR VPWR _05937_ sky130_fd_sc_hd__xor2_1
XFILLER_73_688 VGND VGND VPWR VPWR sky130_fd_sc_hd__fill_2
X_11842_ _04783_ net728 _04760_ VGND VGND VPWR VPWR _04791_ sky130_fd_sc_hd__o21ai_2
X_11773_ net529 net524 net675 net672 VGND VGND VPWR VPWR _04715_ sky130_fd_sc_hd__and4_1
XFILLER_53_390 VGND VGND VPWR VPWR sky130_fd_sc_hd__fill_2
XFILLER_13_221 VGND VGND VPWR VPWR sky130_fd_sc_hd__decap_3
XFILLER_13_243 VGND VGND VPWR VPWR sky130_fd_sc_hd__fill_1
XFILLER_9_225 VGND VGND VPWR VPWR sky130_fd_sc_hd__decap_6
X_10724_ net489 net482 net652 net650 VGND VGND VPWR VPWR _03573_ sky130_fd_sc_hd__and4_1
XFILLER_41_574 VGND VGND VPWR VPWR sky130_fd_sc_hd__decap_6
X_10655_ _03334_ _03496_ VGND VGND VPWR VPWR _03498_ sky130_fd_sc_hd__or2_1
X_13374_ clknet_3_4__leaf_clk _00032_ _00084_ VGND VGND VPWR VPWR net188 sky130_fd_sc_hd__dfrtp_1
XFILLER_70_85 VPWR VGND VPWR VGND sky130_ef_sc_hd__decap_12
XTAP_TAPCELL_ROW_11_455 VGND VPWR sky130_fd_sc_hd__tapvpwrvgnd_1
XTAP_TAPCELL_ROW_11_444 VGND VPWR sky130_fd_sc_hd__tapvpwrvgnd_1
XFILLER_127_668 VGND VGND VPWR VPWR sky130_fd_sc_hd__decap_4
X_10586_ _03420_ _03421_ VGND VGND VPWR VPWR _03422_ sky130_fd_sc_hd__nand2b_1
X_12325_ _05315_ _05316_ VGND VGND VPWR VPWR _05317_ sky130_fd_sc_hd__or2_1
XFILLER_79_61 VGND VGND VPWR VPWR sky130_fd_sc_hd__fill_2
X_12256_ _05239_ _05240_ _05230_ VGND VGND VPWR VPWR _05242_ sky130_fd_sc_hd__a21o_1
XTAP_TAPCELL_ROW_56_1073 VGND VPWR sky130_fd_sc_hd__tapvpwrvgnd_1
X_12187_ net507 net110 net661 net524 VGND VGND VPWR VPWR _05167_ sky130_fd_sc_hd__a22o_1
X_11207_ _04092_ _04100_ VGND VGND VPWR VPWR _04102_ sky130_fd_sc_hd__xor2_1
XFILLER_110_502 VGND VGND VPWR VPWR sky130_fd_sc_hd__decap_4
XFILLER_68_416 VGND VGND VPWR VPWR sky130_fd_sc_hd__decap_4
XTAP_TAPCELL_ROW_56_1084 VGND VPWR sky130_fd_sc_hd__tapvpwrvgnd_1
X_11138_ _03908_ _03941_ _03940_ VGND VGND VPWR VPWR _04026_ sky130_fd_sc_hd__a21o_1
XFILLER_110_557 VPWR VGND VPWR VGND sky130_ef_sc_hd__decap_12
XFILLER_68_449 VGND VGND VPWR VPWR sky130_fd_sc_hd__fill_2
XFILLER_95_279 VGND VGND VPWR VPWR sky130_fd_sc_hd__fill_1
XFILLER_49_685 VGND VGND VPWR VPWR sky130_fd_sc_hd__fill_2
X_11069_ _03944_ _03950_ VGND VGND VPWR VPWR _03951_ sky130_fd_sc_hd__xor2_2
XFILLER_63_121 VPWR VGND VPWR VGND sky130_ef_sc_hd__decap_12
XFILLER_64_655 VGND VGND VPWR VPWR sky130_fd_sc_hd__fill_2
XTAP_TAPCELL_ROW_19_555 VGND VPWR sky130_fd_sc_hd__tapvpwrvgnd_1
XTAP_TAPCELL_ROW_19_566 VGND VPWR sky130_fd_sc_hd__tapvpwrvgnd_1
XFILLER_63_187 VPWR VGND VPWR VGND sky130_ef_sc_hd__decap_12
XFILLER_51_305 VGND VGND VPWR VPWR sky130_fd_sc_hd__decap_6
XFILLER_17_571 VGND VGND VPWR VPWR sky130_fd_sc_hd__decap_3
X_07300_ _06588_ _06589_ _06590_ VGND VGND VPWR VPWR _06591_ sky130_fd_sc_hd__a21oi_1
X_08280_ _00988_ _01014_ VGND VGND VPWR VPWR _01015_ sky130_fd_sc_hd__and2b_1
XFILLER_20_714 VGND VGND VPWR VPWR sky130_fd_sc_hd__decap_3
XFILLER_32_563 VPWR VGND VPWR VGND sky130_ef_sc_hd__decap_12
X_07231_ _06367_ _06371_ _06356_ VGND VGND VPWR VPWR _06522_ sky130_fd_sc_hd__o21ba_1
XTAP_TAPCELL_ROW_30_720 VGND VPWR sky130_fd_sc_hd__tapvpwrvgnd_1
XFILLER_32_596 VGND VGND VPWR VPWR sky130_fd_sc_hd__fill_1
X_07162_ net695 net374 net411 net614 VGND VGND VPWR VPWR _06454_ sky130_fd_sc_hd__a22oi_1
XFILLER_20_769 VPWR VGND VPWR VGND sky130_ef_sc_hd__decap_12
XFILLER_117_134 VGND VGND VPWR VPWR sky130_fd_sc_hd__fill_1
XFILLER_117_167 VGND VGND VPWR VPWR sky130_fd_sc_hd__fill_1
X_07093_ net320 net595 net571 net322 VGND VGND VPWR VPWR _06385_ sky130_fd_sc_hd__a22o_1
XFILLER_115_15 VPWR VGND VPWR VGND sky130_ef_sc_hd__decap_12
X_09803_ _02572_ _02571_ VGND VGND VPWR VPWR _02573_ sky130_fd_sc_hd__and2b_1
XFILLER_99_585 VPWR VGND VPWR VGND sky130_ef_sc_hd__decap_12
Xfanout259 net93 VGND VGND VPWR VPWR net259 sky130_fd_sc_hd__clkbuf_2
XFILLER_101_535 VGND VGND VPWR VPWR sky130_fd_sc_hd__fill_1
X_07995_ _00632_ _00634_ VGND VGND VPWR VPWR _00732_ sky130_fd_sc_hd__or2_1
X_09734_ _02494_ _02495_ _02497_ VGND VGND VPWR VPWR _02498_ sky130_fd_sc_hd__and3_1
X_06946_ _04829_ _04840_ _04916_ _04872_ VGND VGND VPWR VPWR _04938_ sky130_fd_sc_hd__a211o_1
X_09665_ net487 _02421_ _02420_ VGND VGND VPWR VPWR _02422_ sky130_fd_sc_hd__a21oi_1
XTAP_TAPCELL_ROW_87_1512 VGND VPWR sky130_fd_sc_hd__tapvpwrvgnd_1
X_06877_ _04166_ _04177_ VGND VGND VPWR VPWR _04188_ sky130_fd_sc_hd__nor2_1
XTAP_TAPCELL_ROW_38_820 VGND VPWR sky130_fd_sc_hd__tapvpwrvgnd_1
XTAP_TAPCELL_ROW_38_831 VGND VPWR sky130_fd_sc_hd__tapvpwrvgnd_1
X_08616_ net270 net255 VGND VGND VPWR VPWR _01344_ sky130_fd_sc_hd__nand2_1
XFILLER_27_346 VGND VGND VPWR VPWR sky130_fd_sc_hd__fill_2
XFILLER_27_357 VGND VGND VPWR VPWR sky130_fd_sc_hd__fill_1
XFILLER_27_368 VPWR VGND VPWR VGND sky130_ef_sc_hd__decap_12
XFILLER_131_69 VPWR VGND VPWR VGND sky130_ef_sc_hd__decap_12
X_09596_ _02345_ _02346_ VGND VGND VPWR VPWR _02348_ sky130_fd_sc_hd__xnor2_1
XFILLER_82_485 VGND VGND VPWR VPWR sky130_fd_sc_hd__decap_3
XFILLER_54_165 VPWR VGND VPWR VGND sky130_ef_sc_hd__decap_12
XFILLER_42_327 VGND VGND VPWR VPWR sky130_fd_sc_hd__decap_6
X_08547_ _01253_ _01274_ _01273_ VGND VGND VPWR VPWR _01276_ sky130_fd_sc_hd__o21bai_1
X_08478_ _01118_ _01156_ _01199_ VGND VGND VPWR VPWR _01207_ sky130_fd_sc_hd__a21oi_1
XFILLER_11_714 VPWR VGND VPWR VGND sky130_ef_sc_hd__decap_12
X_07429_ net527 _02153_ VGND VGND VPWR VPWR _00170_ sky130_fd_sc_hd__nor2_1
XFILLER_10_213 VPWR VGND VPWR VGND sky130_ef_sc_hd__decap_12
XFILLER_7_729 VPWR VGND VPWR VGND sky130_ef_sc_hd__decap_12
X_10440_ net417 net575 VGND VGND VPWR VPWR _03263_ sky130_fd_sc_hd__nand2_1
XFILLER_136_421 VGND VGND VPWR VPWR sky130_fd_sc_hd__fill_2
XTAP_TAPCELL_ROW_98_1663 VGND VPWR sky130_fd_sc_hd__tapvpwrvgnd_1
X_10371_ net663 net639 net278 net276 VGND VGND VPWR VPWR _03188_ sky130_fd_sc_hd__and4_1
XFILLER_40_55 VGND VGND VPWR VPWR sky130_fd_sc_hd__decap_4
XFILLER_124_649 VPWR VGND VPWR VGND sky130_ef_sc_hd__decap_12
XFILLER_124_638 VGND VGND VPWR VPWR sky130_fd_sc_hd__decap_6
XFILLER_123_104 VGND VGND VPWR VPWR sky130_fd_sc_hd__fill_2
XFILLER_108_178 VGND VGND VPWR VPWR sky130_fd_sc_hd__fill_2
X_12110_ _05077_ _05081_ VGND VGND VPWR VPWR _05083_ sky130_fd_sc_hd__xnor2_1
XFILLER_2_401 VPWR VGND VPWR VGND sky130_ef_sc_hd__decap_12
X_13090_ _06138_ _06153_ VGND VGND VPWR VPWR _06154_ sky130_fd_sc_hd__xnor2_1
X_12041_ net618 net298 VGND VGND VPWR VPWR _05008_ sky130_fd_sc_hd__nand2_1
XFILLER_6_3 VPWR VGND VPWR VGND sky130_ef_sc_hd__decap_12
XFILLER_2_445 VPWR VGND VPWR VGND sky130_ef_sc_hd__decap_12
XFILLER_2_489 VPWR VGND VPWR VGND sky130_ef_sc_hd__decap_12
XFILLER_132_693 VGND VGND VPWR VPWR sky130_fd_sc_hd__decap_6
XFILLER_1_27 VPWR VGND VPWR VGND sky130_ef_sc_hd__decap_12
XTAP_TAPCELL_ROW_125_2048 VGND VPWR sky130_fd_sc_hd__tapvpwrvgnd_1
XFILLER_105_81 VGND VGND VPWR VPWR sky130_fd_sc_hd__decap_8
XFILLER_92_249 VGND VGND VPWR VPWR sky130_fd_sc_hd__decap_3
XFILLER_46_611 VPWR VGND VPWR VGND sky130_ef_sc_hd__decap_12
XFILLER_45_110 VGND VGND VPWR VPWR sky130_fd_sc_hd__fill_2
X_12943_ net412 net581 _05992_ VGND VGND VPWR VPWR _05993_ sky130_fd_sc_hd__a21oi_1
XFILLER_73_485 VPWR VGND VPWR VGND sky130_ef_sc_hd__decap_12
XFILLER_61_636 VGND VGND VPWR VPWR sky130_fd_sc_hd__fill_1
XFILLER_45_165 VGND VGND VPWR VPWR sky130_fd_sc_hd__decap_3
XTAP_TAPCELL_ROW_16_514 VGND VPWR sky130_fd_sc_hd__tapvpwrvgnd_1
X_12874_ net662 _05552_ VGND VGND VPWR VPWR _05918_ sky130_fd_sc_hd__nand2_1
XTAP_TAPCELL_ROW_107_1792 VGND VPWR sky130_fd_sc_hd__tapvpwrvgnd_1
XFILLER_61_658 VGND VGND VPWR VPWR sky130_fd_sc_hd__decap_3
X_11825_ net786 net371 net369 net789 VGND VGND VPWR VPWR _04772_ sky130_fd_sc_hd__a22oi_2
XTAP_TAPCELL_ROW_16_525 VGND VPWR sky130_fd_sc_hd__tapvpwrvgnd_1
XFILLER_33_349 VPWR VGND VPWR VGND sky130_ef_sc_hd__decap_12
X_11756_ _04693_ _04694_ VGND VGND VPWR VPWR _04696_ sky130_fd_sc_hd__xnor2_1
XTAP_TAPCELL_ROW_120_1981 VGND VPWR sky130_fd_sc_hd__tapvpwrvgnd_1
XTAP_TAPCELL_ROW_120_1970 VGND VPWR sky130_fd_sc_hd__tapvpwrvgnd_1
XFILLER_81_84 VGND VGND VPWR VPWR sky130_fd_sc_hd__decap_3
X_10707_ _03539_ _03552_ VGND VGND VPWR VPWR _03555_ sky130_fd_sc_hd__xnor2_1
XFILLER_41_382 VGND VGND VPWR VPWR sky130_fd_sc_hd__decap_8
X_11687_ _04585_ _04619_ VGND VGND VPWR VPWR _04622_ sky130_fd_sc_hd__xnor2_1
X_10638_ _03476_ _03477_ VGND VGND VPWR VPWR _03480_ sky130_fd_sc_hd__xnor2_1
XTAP_TAPCELL_ROW_136_2199 VGND VPWR sky130_fd_sc_hd__tapvpwrvgnd_1
X_13357_ clknet_3_3__leaf_clk _00038_ _00067_ VGND VGND VPWR VPWR net171 sky130_fd_sc_hd__dfrtp_1
XFILLER_60_6 VGND VGND VPWR VPWR sky130_fd_sc_hd__decap_8
XTAP_TAPCELL_ROW_58_1113 VGND VPWR sky130_fd_sc_hd__tapvpwrvgnd_1
XTAP_TAPCELL_ROW_58_1102 VGND VPWR sky130_fd_sc_hd__tapvpwrvgnd_1
X_10569_ net467 net560 _03258_ _03257_ VGND VGND VPWR VPWR _03404_ sky130_fd_sc_hd__a31o_1
XFILLER_114_126 VGND VGND VPWR VPWR sky130_fd_sc_hd__fill_1
X_12308_ _05299_ VGND VGND VPWR VPWR _05300_ sky130_fd_sc_hd__inv_2
XFILLER_5_261 VPWR VGND VPWR VGND sky130_ef_sc_hd__decap_12
X_13288_ _06320_ _06368_ VGND VGND VPWR VPWR _06369_ sky130_fd_sc_hd__xnor2_1
X_12239_ _05069_ _05071_ VGND VGND VPWR VPWR _05224_ sky130_fd_sc_hd__nand2_1
XFILLER_110_332 VGND VGND VPWR VPWR sky130_fd_sc_hd__decap_8
XFILLER_96_533 VGND VGND VPWR VPWR sky130_fd_sc_hd__fill_2
XFILLER_68_246 VGND VGND VPWR VPWR sky130_fd_sc_hd__decap_6
X_06800_ net687 net316 net306 net267 VGND VGND VPWR VPWR _03346_ sky130_fd_sc_hd__a22oi_1
XFILLER_110_365 VGND VGND VPWR VPWR sky130_fd_sc_hd__fill_1
X_07780_ _06588_ _00400_ _00399_ VGND VGND VPWR VPWR _00519_ sky130_fd_sc_hd__o21ba_1
X_06731_ _02522_ _02588_ VGND VGND VPWR VPWR _02599_ sky130_fd_sc_hd__nand2_1
XFILLER_83_238 VGND VGND VPWR VPWR sky130_fd_sc_hd__decap_8
XFILLER_77_780 VGND VGND VPWR VPWR sky130_fd_sc_hd__decap_4
Xinput4 in0[3] VGND VGND VPWR VPWR net4 sky130_fd_sc_hd__buf_12
X_09450_ _02187_ _02188_ VGND VGND VPWR VPWR _02190_ sky130_fd_sc_hd__xnor2_2
XTAP_TAPCELL_ROW_69_1264 VGND VPWR sky130_fd_sc_hd__tapvpwrvgnd_1
XFILLER_37_677 VGND VGND VPWR VPWR sky130_fd_sc_hd__fill_1
X_08401_ net455 net558 _01129_ VGND VGND VPWR VPWR _01131_ sky130_fd_sc_hd__and3_1
XFILLER_24_327 VPWR VGND VPWR VGND sky130_ef_sc_hd__decap_12
XFILLER_36_165 VPWR VGND VPWR VGND sky130_ef_sc_hd__decap_12
XFILLER_36_187 VGND VGND VPWR VPWR sky130_fd_sc_hd__decap_8
X_09381_ _02110_ _02113_ VGND VGND VPWR VPWR _02114_ sky130_fd_sc_hd__or2_1
XFILLER_51_113 VGND VGND VPWR VPWR sky130_fd_sc_hd__fill_1
XTAP_TAPCELL_ROW_82_1442 VGND VPWR sky130_fd_sc_hd__tapvpwrvgnd_1
X_08332_ _01061_ _01064_ VGND VGND VPWR VPWR _01066_ sky130_fd_sc_hd__xnor2_1
X_08263_ _00894_ _00996_ VGND VGND VPWR VPWR _00998_ sky130_fd_sc_hd__xor2_1
XFILLER_20_533 VGND VGND VPWR VPWR sky130_fd_sc_hd__decap_4
X_07214_ _06381_ _06398_ _06396_ VGND VGND VPWR VPWR _06505_ sky130_fd_sc_hd__o21bai_1
XFILLER_20_544 VGND VGND VPWR VPWR sky130_fd_sc_hd__fill_2
XFILLER_118_421 VGND VGND VPWR VPWR sky130_fd_sc_hd__decap_6
X_08194_ _00808_ _00810_ _00928_ VGND VGND VPWR VPWR _00930_ sky130_fd_sc_hd__or3b_1
XFILLER_20_599 VGND VGND VPWR VPWR sky130_fd_sc_hd__decap_4
X_07145_ _06433_ _06436_ VGND VGND VPWR VPWR _06437_ sky130_fd_sc_hd__xnor2_1
X_07076_ net667 net642 net317 net307 VGND VGND VPWR VPWR _06356_ sky130_fd_sc_hd__and4_1
XFILLER_114_671 VGND VGND VPWR VPWR sky130_fd_sc_hd__fill_1
XTAP_TAPCELL_ROW_93_1593 VGND VPWR sky130_fd_sc_hd__tapvpwrvgnd_1
XFILLER_86_29 VGND VGND VPWR VPWR sky130_fd_sc_hd__decap_8
XFILLER_113_181 VPWR VGND VPWR VGND sky130_ef_sc_hd__decap_12
XFILLER_101_332 VGND VGND VPWR VPWR sky130_fd_sc_hd__fill_1
XFILLER_101_365 VGND VGND VPWR VPWR sky130_fd_sc_hd__decap_3
X_07978_ _00713_ _00714_ VGND VGND VPWR VPWR _00715_ sky130_fd_sc_hd__and2_1
XFILLER_19_23 VPWR VGND VPWR VGND sky130_ef_sc_hd__decap_12
X_09717_ _02478_ _02450_ VGND VGND VPWR VPWR _02480_ sky130_fd_sc_hd__and2b_1
X_06929_ _02987_ _03325_ VGND VGND VPWR VPWR _04752_ sky130_fd_sc_hd__and2_1
XFILLER_68_780 VGND VGND VPWR VPWR sky130_fd_sc_hd__fill_1
XFILLER_19_89 VPWR VGND VPWR VGND sky130_ef_sc_hd__decap_12
XFILLER_74_249 VGND VGND VPWR VPWR sky130_fd_sc_hd__decap_3
X_09648_ net415 net537 _02403_ VGND VGND VPWR VPWR _02404_ sky130_fd_sc_hd__a21o_1
XFILLER_83_783 VGND VGND VPWR VPWR sky130_fd_sc_hd__fill_1
XFILLER_35_22 VGND VGND VPWR VPWR sky130_fd_sc_hd__fill_1
X_09579_ _02326_ _02328_ VGND VGND VPWR VPWR _02330_ sky130_fd_sc_hd__xnor2_1
XFILLER_82_282 VGND VGND VPWR VPWR sky130_fd_sc_hd__decap_4
XFILLER_70_477 VPWR VGND VPWR VGND sky130_ef_sc_hd__decap_12
X_11610_ _04529_ _04540_ VGND VGND VPWR VPWR _04541_ sky130_fd_sc_hd__xor2_1
X_12590_ _05435_ _05436_ _05434_ VGND VGND VPWR VPWR _05608_ sky130_fd_sc_hd__a21boi_1
XFILLER_35_99 VGND VGND VPWR VPWR sky130_fd_sc_hd__fill_1
XFILLER_70_499 VGND VGND VPWR VPWR sky130_fd_sc_hd__decap_3
XFILLER_11_522 VGND VGND VPWR VPWR sky130_fd_sc_hd__fill_2
XFILLER_11_511 VGND VGND VPWR VPWR sky130_fd_sc_hd__fill_1
X_11541_ _04442_ _04464_ VGND VGND VPWR VPWR _04466_ sky130_fd_sc_hd__xnor2_1
XFILLER_23_393 VPWR VGND VPWR VGND sky130_ef_sc_hd__decap_12
XFILLER_11_555 VGND VGND VPWR VPWR sky130_fd_sc_hd__decap_4
X_11472_ _04388_ _04389_ _04376_ VGND VGND VPWR VPWR _04391_ sky130_fd_sc_hd__o21ai_1
X_10423_ _03114_ _03241_ _03242_ VGND VGND VPWR VPWR _03244_ sky130_fd_sc_hd__and3_1
X_13211_ _06284_ _06285_ VGND VGND VPWR VPWR _06286_ sky130_fd_sc_hd__and2b_1
XTAP_TAPCELL_ROW_21_583 VGND VPWR sky130_fd_sc_hd__tapvpwrvgnd_1
XTAP_TAPCELL_ROW_21_594 VGND VPWR sky130_fd_sc_hd__tapvpwrvgnd_1
XFILLER_136_273 VGND VGND VPWR VPWR sky130_fd_sc_hd__decap_6
XFILLER_109_487 VPWR VGND VPWR VGND sky130_ef_sc_hd__decap_12
X_10354_ _03167_ _03168_ _03086_ VGND VGND VPWR VPWR _03170_ sky130_fd_sc_hd__o21a_1
XFILLER_3_721 VGND VGND VPWR VPWR sky130_fd_sc_hd__decap_6
X_13142_ _05963_ _06079_ _06078_ VGND VGND VPWR VPWR _06211_ sky130_fd_sc_hd__o21ba_1
XFILLER_124_457 VPWR VGND VPWR VGND sky130_ef_sc_hd__decap_12
XFILLER_105_671 VGND VGND VPWR VPWR sky130_fd_sc_hd__fill_1
X_10285_ _02922_ _02924_ _02923_ VGND VGND VPWR VPWR _03094_ sky130_fd_sc_hd__o21bai_1
XFILLER_3_765 VPWR VGND VPWR VGND sky130_ef_sc_hd__decap_12
XFILLER_2_253 VPWR VGND VPWR VGND sky130_ef_sc_hd__decap_12
X_13073_ net250 net657 _06134_ VGND VGND VPWR VPWR _06135_ sky130_fd_sc_hd__and3_1
XFILLER_120_641 VGND VGND VPWR VPWR sky130_fd_sc_hd__decap_3
XFILLER_78_533 VGND VGND VPWR VPWR sky130_fd_sc_hd__decap_8
XFILLER_78_522 VGND VGND VPWR VPWR sky130_fd_sc_hd__decap_8
XTAP_TAPCELL_ROW_53_1043 VGND VPWR sky130_fd_sc_hd__tapvpwrvgnd_1
XTAP_TAPCELL_ROW_53_1032 VGND VPWR sky130_fd_sc_hd__tapvpwrvgnd_1
X_12024_ _04987_ _04988_ VGND VGND VPWR VPWR _04989_ sky130_fd_sc_hd__nor2_1
XFILLER_38_419 VGND VGND VPWR VPWR sky130_fd_sc_hd__fill_1
XTAP_TAPCELL_ROW_109_1821 VGND VPWR sky130_fd_sc_hd__tapvpwrvgnd_1
XFILLER_93_536 VGND VGND VPWR VPWR sky130_fd_sc_hd__decap_8
XFILLER_78_599 VGND VGND VPWR VPWR sky130_fd_sc_hd__fill_2
XFILLER_19_633 VGND VGND VPWR VPWR sky130_fd_sc_hd__fill_1
Xfanout590 net593 VGND VGND VPWR VPWR net590 sky130_fd_sc_hd__buf_4
XFILLER_18_132 VGND VGND VPWR VPWR sky130_fd_sc_hd__decap_8
XFILLER_73_260 VGND VGND VPWR VPWR sky130_fd_sc_hd__fill_1
X_12926_ net334 net312 net361 net360 VGND VGND VPWR VPWR _05974_ sky130_fd_sc_hd__and4b_1
X_12857_ _05890_ _05898_ VGND VGND VPWR VPWR _05900_ sky130_fd_sc_hd__xor2_1
XTAP_TAPCELL_ROW_29_694 VGND VPWR sky130_fd_sc_hd__tapvpwrvgnd_1
XFILLER_34_669 VPWR VGND VPWR VGND sky130_ef_sc_hd__decap_12
X_11808_ _04746_ _04753_ VGND VGND VPWR VPWR _04754_ sky130_fd_sc_hd__nor2_1
XFILLER_33_157 VGND VGND VPWR VPWR sky130_fd_sc_hd__decap_8
XTAP_TAPCELL_ROW_64_1194 VGND VPWR sky130_fd_sc_hd__tapvpwrvgnd_1
XFILLER_61_499 VGND VGND VPWR VPWR sky130_fd_sc_hd__decap_4
X_12788_ net296 net294 net541 VGND VGND VPWR VPWR _05824_ sky130_fd_sc_hd__o21ai_1
X_11739_ net269 net295 VGND VGND VPWR VPWR _04678_ sky130_fd_sc_hd__nand2_1
X_13409_ clknet_3_7__leaf_clk _00061_ _00119_ VGND VGND VPWR VPWR net223 sky130_fd_sc_hd__dfrtp_1
XFILLER_6_581 VGND VGND VPWR VPWR sky130_fd_sc_hd__decap_6
X_08950_ net407 net557 VGND VGND VPWR VPWR _01676_ sky130_fd_sc_hd__and2_2
XPHY_EDGE_ROW_135_Right_135 VGND VGND VPWR VPWR sky130_fd_sc_hd__decap_3
X_08881_ net545 net264 _01606_ VGND VGND VPWR VPWR _01607_ sky130_fd_sc_hd__and3_1
X_07901_ _00636_ _00637_ VGND VGND VPWR VPWR _00639_ sky130_fd_sc_hd__nand2_1
X_07832_ _00568_ _00569_ VGND VGND VPWR VPWR _00571_ sky130_fd_sc_hd__nand2_1
XFILLER_96_363 VGND VGND VPWR VPWR sky130_fd_sc_hd__fill_1
XFILLER_84_503 VGND VGND VPWR VPWR sky130_fd_sc_hd__decap_8
XFILLER_84_547 VGND VGND VPWR VPWR sky130_fd_sc_hd__fill_1
XFILLER_69_599 VGND VGND VPWR VPWR sky130_fd_sc_hd__decap_6
XFILLER_56_238 VPWR VGND VPWR VGND sky130_ef_sc_hd__decap_12
X_09502_ _02089_ _02093_ _02091_ VGND VGND VPWR VPWR _02246_ sky130_fd_sc_hd__o21ba_1
X_07763_ _00500_ _00501_ VGND VGND VPWR VPWR _00502_ sky130_fd_sc_hd__or2_1
X_07694_ _06669_ _00284_ _00283_ VGND VGND VPWR VPWR _00433_ sky130_fd_sc_hd__a21o_1
XFILLER_112_27 VGND VGND VPWR VPWR sky130_fd_sc_hd__fill_1
X_06714_ net390 net516 net388 net695 VGND VGND VPWR VPWR _02413_ sky130_fd_sc_hd__a22o_1
XFILLER_65_772 VGND VGND VPWR VPWR sky130_fd_sc_hd__fill_1
XTAP_TAPCELL_ROW_48_970 VGND VPWR sky130_fd_sc_hd__tapvpwrvgnd_1
XFILLER_37_485 VGND VGND VPWR VPWR sky130_fd_sc_hd__fill_1
X_09433_ _02165_ _02170_ VGND VGND VPWR VPWR _02171_ sky130_fd_sc_hd__xor2_2
X_09364_ net621 net255 _01926_ _01925_ VGND VGND VPWR VPWR _02095_ sky130_fd_sc_hd__a31o_1
XFILLER_13_809 VGND VGND VPWR VPWR sky130_fd_sc_hd__fill_2
X_08315_ _01046_ _01048_ VGND VGND VPWR VPWR _01049_ sky130_fd_sc_hd__xnor2_1
XFILLER_52_499 VGND VGND VPWR VPWR sky130_fd_sc_hd__fill_2
XANTENNA_31 net62 VGND VGND VPWR VPWR sky130_fd_sc_hd__diode_2
X_09295_ net336 net313 net329 net327 VGND VGND VPWR VPWR _02020_ sky130_fd_sc_hd__and4_1
XANTENNA_20 net32 VGND VGND VPWR VPWR sky130_fd_sc_hd__diode_2
X_08246_ _00967_ _00980_ VGND VGND VPWR VPWR _00981_ sky130_fd_sc_hd__xor2_1
XFILLER_20_374 VGND VGND VPWR VPWR sky130_fd_sc_hd__decap_8
X_08177_ _00795_ _00798_ _00911_ VGND VGND VPWR VPWR _00913_ sky130_fd_sc_hd__and3_1
XTAP_TAPCELL_ROW_95_1622 VGND VPWR sky130_fd_sc_hd__tapvpwrvgnd_1
XFILLER_119_785 VPWR VGND VPWR VGND sky130_ef_sc_hd__decap_12
X_07128_ net252 net251 net491 net484 VGND VGND VPWR VPWR _06420_ sky130_fd_sc_hd__nand4_1
XFILLER_134_755 VGND VGND VPWR VPWR sky130_fd_sc_hd__fill_1
XFILLER_106_468 VGND VGND VPWR VPWR sky130_fd_sc_hd__decap_8
XFILLER_97_39 VGND VGND VPWR VPWR sky130_fd_sc_hd__decap_3
X_07059_ net936 _04686_ _06150_ _06161_ VGND VGND VPWR VPWR _06172_ sky130_fd_sc_hd__o211a_4
XFILLER_0_713 VPWR VGND VPWR VGND sky130_ef_sc_hd__decap_12
Xoutput171 net171 VGND VGND VPWR VPWR out0[3] sky130_fd_sc_hd__buf_2
XFILLER_102_630 VGND VGND VPWR VPWR sky130_fd_sc_hd__fill_1
XFILLER_99_190 VPWR VGND VPWR VGND sky130_ef_sc_hd__decap_12
X_10070_ _02814_ _02859_ VGND VGND VPWR VPWR _02860_ sky130_fd_sc_hd__and2_1
Xoutput193 net193 VGND VGND VPWR VPWR out1[9] sky130_fd_sc_hd__buf_2
Xoutput182 net182 VGND VGND VPWR VPWR out1[13] sky130_fd_sc_hd__buf_2
XPHY_EDGE_ROW_102_Right_102 VGND VGND VPWR VPWR sky130_fd_sc_hd__decap_3
XTAP_TAPCELL_ROW_7_389 VGND VPWR sky130_fd_sc_hd__tapvpwrvgnd_1
XFILLER_0_757 VPWR VGND VPWR VGND sky130_ef_sc_hd__decap_12
XFILLER_75_558 VGND VGND VPWR VPWR sky130_fd_sc_hd__fill_2
XFILLER_28_430 VPWR VGND VPWR VGND sky130_ef_sc_hd__decap_12
XTAP_TAPCELL_ROW_122_2007 VGND VPWR sky130_fd_sc_hd__tapvpwrvgnd_1
X_10972_ _03842_ _03843_ _03742_ VGND VGND VPWR VPWR _03845_ sky130_fd_sc_hd__a21o_1
XFILLER_28_485 VGND VGND VPWR VPWR sky130_fd_sc_hd__decap_4
XFILLER_55_293 VPWR VGND VPWR VGND sky130_ef_sc_hd__decap_12
XFILLER_15_102 VGND VGND VPWR VPWR sky130_fd_sc_hd__fill_1
XFILLER_15_113 VPWR VGND VPWR VGND sky130_ef_sc_hd__decap_12
XFILLER_28_496 VGND VGND VPWR VPWR sky130_fd_sc_hd__fill_2
X_12711_ _05709_ _05739_ VGND VGND VPWR VPWR _05740_ sky130_fd_sc_hd__and2b_1
XTAP_TAPCELL_ROW_104_1751 VGND VPWR sky130_fd_sc_hd__tapvpwrvgnd_1
XFILLER_70_263 VPWR VGND VPWR VGND sky130_ef_sc_hd__decap_12
XTAP_TAPCELL_ROW_26_653 VGND VPWR sky130_fd_sc_hd__tapvpwrvgnd_1
XTAP_TAPCELL_ROW_26_664 VGND VPWR sky130_fd_sc_hd__tapvpwrvgnd_1
XFILLER_31_617 VGND VGND VPWR VPWR sky130_fd_sc_hd__decap_8
X_12642_ _05539_ _05541_ _05662_ VGND VGND VPWR VPWR _05664_ sky130_fd_sc_hd__and3_1
XFILLER_24_691 VGND VGND VPWR VPWR sky130_fd_sc_hd__fill_2
XFILLER_129_505 VPWR VGND VPWR VGND sky130_ef_sc_hd__decap_12
X_12573_ net404 net599 net588 VGND VGND VPWR VPWR _05589_ sky130_fd_sc_hd__and3_1
XFILLER_7_15 VPWR VGND VPWR VGND sky130_ef_sc_hd__decap_12
X_11524_ _04340_ _04347_ _04346_ VGND VGND VPWR VPWR _04447_ sky130_fd_sc_hd__a21bo_1
X_11455_ _04370_ _04371_ VGND VGND VPWR VPWR _04372_ sky130_fd_sc_hd__and2b_1
XTAP_TAPCELL_ROW_133_2158 VGND VPWR sky130_fd_sc_hd__tapvpwrvgnd_1
X_10406_ _03099_ _03106_ _03105_ VGND VGND VPWR VPWR _03226_ sky130_fd_sc_hd__a21oi_1
X_11386_ _04295_ _04296_ VGND VGND VPWR VPWR _00015_ sky130_fd_sc_hd__nor2_1
XFILLER_125_777 VGND VGND VPWR VPWR sky130_fd_sc_hd__decap_6
XFILLER_124_276 VPWR VGND VPWR VGND sky130_ef_sc_hd__decap_12
XFILLER_97_116 VGND VGND VPWR VPWR sky130_fd_sc_hd__fill_2
X_10337_ net706 VGND VGND VPWR VPWR _03152_ sky130_fd_sc_hd__inv_2
XFILLER_3_573 VPWR VGND VPWR VGND sky130_ef_sc_hd__decap_12
X_13125_ _06177_ _06190_ _06191_ VGND VGND VPWR VPWR _06192_ sky130_fd_sc_hd__or3_1
XFILLER_112_438 VGND VGND VPWR VPWR sky130_fd_sc_hd__fill_1
XFILLER_97_138 VGND VGND VPWR VPWR sky130_fd_sc_hd__fill_1
X_10268_ _03072_ _03075_ VGND VGND VPWR VPWR _03076_ sky130_fd_sc_hd__nand2_1
X_13056_ _05994_ _06115_ VGND VGND VPWR VPWR _06116_ sky130_fd_sc_hd__nor2_1
XFILLER_78_341 VGND VGND VPWR VPWR sky130_fd_sc_hd__fill_1
X_12007_ _04826_ _04830_ net775 _04969_ VGND VGND VPWR VPWR _04972_ sky130_fd_sc_hd__a211oi_4
XFILLER_78_396 VPWR VGND VPWR VGND sky130_ef_sc_hd__decap_12
X_10199_ _02997_ _02991_ _02827_ VGND VGND VPWR VPWR _03001_ sky130_fd_sc_hd__a21o_1
XFILLER_54_709 VGND VGND VPWR VPWR sky130_fd_sc_hd__decap_6
XFILLER_47_750 VPWR VGND VPWR VGND sky130_ef_sc_hd__decap_12
XTAP_TAPCELL_ROW_66_1212 VGND VPWR sky130_fd_sc_hd__tapvpwrvgnd_1
XFILLER_53_219 VGND VGND VPWR VPWR sky130_fd_sc_hd__fill_1
XFILLER_46_260 VPWR VGND VPWR VGND sky130_ef_sc_hd__decap_12
XFILLER_19_452 VPWR VGND VPWR VGND sky130_ef_sc_hd__decap_12
XTAP_TAPCELL_ROW_66_1223 VGND VPWR sky130_fd_sc_hd__tapvpwrvgnd_1
X_12909_ _05955_ _05956_ VGND VGND VPWR VPWR _05957_ sky130_fd_sc_hd__or2_1
XFILLER_62_753 VGND VGND VPWR VPWR sky130_fd_sc_hd__decap_3
XFILLER_34_477 VGND VGND VPWR VPWR sky130_fd_sc_hd__decap_8
XFILLER_15_691 VGND VGND VPWR VPWR sky130_fd_sc_hd__fill_1
X_09080_ net523 net509 net627 net128 VGND VGND VPWR VPWR _01805_ sky130_fd_sc_hd__and4_1
X_08100_ _00834_ _00835_ VGND VGND VPWR VPWR _00836_ sky130_fd_sc_hd__nor2_1
X_08031_ _00765_ _00766_ VGND VGND VPWR VPWR _00768_ sky130_fd_sc_hd__xor2_1
Xinput40 w00[6] VGND VGND VPWR VPWR net40 sky130_fd_sc_hd__clkbuf_2
XFILLER_128_571 VPWR VGND VPWR VGND sky130_ef_sc_hd__decap_12
Xinput73 w10[7] VGND VGND VPWR VPWR net73 sky130_fd_sc_hd__clkbuf_4
Xinput62 w03[4] VGND VGND VPWR VPWR net62 sky130_fd_sc_hd__buf_1
Xinput51 w02[1] VGND VGND VPWR VPWR net51 sky130_fd_sc_hd__clkbuf_1
Xinput95 w13[5] VGND VGND VPWR VPWR net95 sky130_fd_sc_hd__buf_1
XFILLER_116_755 VGND VGND VPWR VPWR sky130_fd_sc_hd__fill_1
XTAP_TAPCELL_ROW_77_1374 VGND VPWR sky130_fd_sc_hd__tapvpwrvgnd_1
Xinput84 w12[2] VGND VGND VPWR VPWR net84 sky130_fd_sc_hd__buf_2
X_09982_ _02757_ _02766_ VGND VGND VPWR VPWR _02767_ sky130_fd_sc_hd__xnor2_1
XFILLER_107_27 VGND VGND VPWR VPWR sky130_fd_sc_hd__decap_4
XFILLER_103_405 VGND VGND VPWR VPWR sky130_fd_sc_hd__decap_3
XFILLER_103_449 VGND VGND VPWR VPWR sky130_fd_sc_hd__decap_6
XTAP_TAPCELL_ROW_90_1552 VGND VPWR sky130_fd_sc_hd__tapvpwrvgnd_1
X_08933_ net455 net549 _01657_ _01658_ VGND VGND VPWR VPWR _01659_ sky130_fd_sc_hd__a22o_1
XFILLER_130_268 VPWR VGND VPWR VGND sky130_ef_sc_hd__decap_12
XFILLER_97_650 VGND VGND VPWR VPWR sky130_fd_sc_hd__fill_2
XFILLER_57_503 VGND VGND VPWR VPWR sky130_fd_sc_hd__fill_1
XFILLER_123_15 VPWR VGND VPWR VGND sky130_ef_sc_hd__decap_12
X_08864_ _01453_ _01486_ _01488_ VGND VGND VPWR VPWR _01590_ sky130_fd_sc_hd__a21oi_1
XFILLER_97_694 VGND VGND VPWR VPWR sky130_fd_sc_hd__fill_1
XTAP_TAPCELL_ROW_4_348 VGND VPWR sky130_fd_sc_hd__tapvpwrvgnd_1
X_07815_ _00553_ _00552_ VGND VGND VPWR VPWR _00554_ sky130_fd_sc_hd__and2b_1
XFILLER_96_193 VGND VGND VPWR VPWR sky130_fd_sc_hd__decap_3
XFILLER_96_182 VGND VGND VPWR VPWR sky130_fd_sc_hd__decap_4
X_08795_ net455 net551 net549 net464 VGND VGND VPWR VPWR _01522_ sky130_fd_sc_hd__a22o_1
X_07746_ net681 net483 VGND VGND VPWR VPWR _00485_ sky130_fd_sc_hd__nand2_1
XFILLER_72_517 VPWR VGND VPWR VGND sky130_ef_sc_hd__decap_12
XFILLER_65_591 VGND VGND VPWR VPWR sky130_fd_sc_hd__decap_8
XFILLER_65_580 VGND VGND VPWR VPWR sky130_fd_sc_hd__fill_1
X_09416_ _02148_ _02151_ VGND VGND VPWR VPWR _02152_ sky130_fd_sc_hd__and2b_1
X_07677_ _00415_ _00414_ _00257_ _00259_ VGND VGND VPWR VPWR _00417_ sky130_fd_sc_hd__a211o_4
XFILLER_13_617 VGND VGND VPWR VPWR sky130_fd_sc_hd__decap_8
XFILLER_52_285 VGND VGND VPWR VPWR sky130_fd_sc_hd__fill_1
XFILLER_16_79 VGND VGND VPWR VPWR sky130_fd_sc_hd__decap_4
XTAP_TAPCELL_ROW_23_612 VGND VPWR sky130_fd_sc_hd__tapvpwrvgnd_1
XTAP_TAPCELL_ROW_23_623 VGND VPWR sky130_fd_sc_hd__tapvpwrvgnd_1
X_09347_ _02074_ _02076_ VGND VGND VPWR VPWR _02078_ sky130_fd_sc_hd__nor2_4
X_09278_ net438 net422 net550 net548 VGND VGND VPWR VPWR _02002_ sky130_fd_sc_hd__and4_1
X_08229_ _00868_ _00881_ _00879_ VGND VGND VPWR VPWR _00964_ sky130_fd_sc_hd__a21o_1
XFILLER_20_182 VGND VGND VPWR VPWR sky130_fd_sc_hd__fill_1
XFILLER_32_67 VGND VGND VPWR VPWR sky130_fd_sc_hd__fill_1
X_11240_ _04125_ _04137_ VGND VGND VPWR VPWR _04138_ sky130_fd_sc_hd__xnor2_1
X_11171_ _04026_ _04061_ VGND VGND VPWR VPWR _04062_ sky130_fd_sc_hd__xor2_1
X_10122_ _02914_ _02915_ VGND VGND VPWR VPWR _02916_ sky130_fd_sc_hd__nor2_1
XFILLER_0_510 VGND VGND VPWR VPWR sky130_fd_sc_hd__decap_4
XFILLER_122_769 VPWR VGND VPWR VGND sky130_ef_sc_hd__decap_12
XFILLER_57_31 VGND VGND VPWR VPWR sky130_fd_sc_hd__fill_1
X_10053_ net520 net656 net654 net526 VGND VGND VPWR VPWR _02841_ sky130_fd_sc_hd__a22o_1
XFILLER_0_587 VGND VGND VPWR VPWR sky130_fd_sc_hd__fill_1
XFILLER_48_558 VGND VGND VPWR VPWR sky130_fd_sc_hd__decap_4
XFILLER_57_97 VGND VGND VPWR VPWR sky130_fd_sc_hd__fill_1
XFILLER_16_400 VGND VGND VPWR VPWR sky130_fd_sc_hd__fill_2
XFILLER_29_783 VGND VGND VPWR VPWR sky130_fd_sc_hd__fill_1
XFILLER_113_70 VGND VGND VPWR VPWR sky130_fd_sc_hd__fill_1
XFILLER_73_30 VGND VGND VPWR VPWR sky130_fd_sc_hd__fill_2
XFILLER_16_433 VGND VGND VPWR VPWR sky130_fd_sc_hd__decap_8
XFILLER_28_271 VGND VGND VPWR VPWR sky130_fd_sc_hd__fill_1
XFILLER_90_369 VPWR VGND VPWR VGND sky130_ef_sc_hd__decap_12
XFILLER_71_561 VPWR VGND VPWR VGND sky130_ef_sc_hd__decap_12
XFILLER_44_764 VGND VGND VPWR VPWR sky130_fd_sc_hd__fill_2
XFILLER_43_252 VPWR VGND VPWR VGND sky130_ef_sc_hd__decap_12
X_10955_ _03426_ _03824_ VGND VGND VPWR VPWR _03826_ sky130_fd_sc_hd__xnor2_1
XFILLER_16_477 VPWR VGND VPWR VGND sky130_ef_sc_hd__decap_12
X_10886_ net475 net652 net650 net482 VGND VGND VPWR VPWR _03750_ sky130_fd_sc_hd__a22o_1
XTAP_TAPCELL_ROW_61_1142 VGND VPWR sky130_fd_sc_hd__tapvpwrvgnd_1
X_12625_ _05643_ _05644_ _05542_ VGND VGND VPWR VPWR _05646_ sky130_fd_sc_hd__a21o_1
XFILLER_129_324 VPWR VGND VPWR VGND sky130_ef_sc_hd__decap_12
XTAP_TAPCELL_ROW_61_1153 VGND VPWR sky130_fd_sc_hd__tapvpwrvgnd_1
X_12556_ _05563_ _05569_ VGND VGND VPWR VPWR _05570_ sky130_fd_sc_hd__xor2_1
XFILLER_8_632 VPWR VGND VPWR VGND sky130_ef_sc_hd__decap_12
X_11507_ _04300_ _04427_ VGND VGND VPWR VPWR _04429_ sky130_fd_sc_hd__xnor2_1
XTAP_TAPCELL_ROW_117_1931 VGND VPWR sky130_fd_sc_hd__tapvpwrvgnd_1
X_12487_ _05315_ _05493_ VGND VGND VPWR VPWR _05495_ sky130_fd_sc_hd__xor2_1
X_11438_ _04353_ _04333_ VGND VGND VPWR VPWR _04354_ sky130_fd_sc_hd__and2b_1
X_11369_ _04164_ _04278_ VGND VGND VPWR VPWR _04279_ sky130_fd_sc_hd__xnor2_1
XFILLER_125_585 VPWR VGND VPWR VGND sky130_ef_sc_hd__decap_12
XFILLER_112_213 VPWR VGND VPWR VGND sky130_ef_sc_hd__decap_12
X_13108_ _06171_ _06173_ VGND VGND VPWR VPWR _06174_ sky130_fd_sc_hd__and2b_1
XFILLER_112_257 VGND VGND VPWR VPWR sky130_fd_sc_hd__fill_1
XFILLER_85_119 VGND VGND VPWR VPWR sky130_fd_sc_hd__fill_1
X_13039_ _05225_ _05976_ _05974_ VGND VGND VPWR VPWR _06098_ sky130_fd_sc_hd__a21o_1
XFILLER_66_333 VPWR VGND VPWR VGND sky130_ef_sc_hd__decap_12
XTAP_TAPCELL_ROW_1_307 VGND VPWR sky130_fd_sc_hd__tapvpwrvgnd_1
XFILLER_39_558 VGND VGND VPWR VPWR sky130_fd_sc_hd__fill_2
X_07600_ _00337_ _00338_ _00339_ VGND VGND VPWR VPWR _00340_ sky130_fd_sc_hd__and3_1
XFILLER_93_163 VGND VGND VPWR VPWR sky130_fd_sc_hd__decap_4
XFILLER_93_152 VGND VGND VPWR VPWR sky130_fd_sc_hd__decap_6
X_08580_ _01175_ _01308_ VGND VGND VPWR VPWR _01309_ sky130_fd_sc_hd__or2_1
XFILLER_66_388 VPWR VGND VPWR VGND sky130_ef_sc_hd__decap_12
X_07531_ _06650_ _06652_ _00270_ _00271_ VGND VGND VPWR VPWR _00272_ sky130_fd_sc_hd__a211oi_4
XFILLER_81_325 VGND VGND VPWR VPWR sky130_fd_sc_hd__decap_6
XFILLER_81_358 VGND VGND VPWR VPWR sky130_fd_sc_hd__fill_1
X_07462_ _00201_ _00202_ VGND VGND VPWR VPWR _00203_ sky130_fd_sc_hd__and2b_1
XFILLER_34_274 VGND VGND VPWR VPWR sky130_fd_sc_hd__decap_6
X_09201_ net596 net572 net258 net256 VGND VGND VPWR VPWR _01925_ sky130_fd_sc_hd__and4_1
X_07393_ _06672_ _06673_ _00132_ VGND VGND VPWR VPWR _00134_ sky130_fd_sc_hd__o21ai_1
X_09132_ _01698_ _01701_ VGND VGND VPWR VPWR _01857_ sky130_fd_sc_hd__nand2_1
Xrebuffer217 net916 VGND VGND VPWR VPWR net917 sky130_fd_sc_hd__buf_6
XTAP_TAPCELL_ROW_79_1403 VGND VPWR sky130_fd_sc_hd__tapvpwrvgnd_1
XFILLER_135_305 VPWR VGND VPWR VGND sky130_ef_sc_hd__decap_12
XFILLER_118_15 VPWR VGND VPWR VGND sky130_ef_sc_hd__decap_12
X_09063_ _01780_ _01786_ VGND VGND VPWR VPWR _01788_ sky130_fd_sc_hd__nand2b_1
Xrebuffer239 _06074_ VGND VGND VPWR VPWR net939 sky130_fd_sc_hd__dlygate4sd1_1
XFILLER_8_91 VGND VGND VPWR VPWR sky130_fd_sc_hd__fill_1
XFILLER_135_349 VPWR VGND VPWR VGND sky130_ef_sc_hd__decap_12
X_08014_ net679 net483 net678 net476 VGND VGND VPWR VPWR _00751_ sky130_fd_sc_hd__and4_1
XTAP_TAPCELL_ROW_9_418 VGND VPWR sky130_fd_sc_hd__tapvpwrvgnd_1
XFILLER_116_585 VGND VGND VPWR VPWR sky130_fd_sc_hd__decap_3
XFILLER_104_747 VGND VGND VPWR VPWR sky130_fd_sc_hd__decap_6
XFILLER_103_213 VGND VGND VPWR VPWR sky130_fd_sc_hd__fill_1
XFILLER_1_329 VGND VGND VPWR VPWR sky130_fd_sc_hd__decap_6
X_09965_ _02652_ _02738_ VGND VGND VPWR VPWR _02748_ sky130_fd_sc_hd__xnor2_1
X_09896_ _02673_ _02672_ VGND VGND VPWR VPWR _02674_ sky130_fd_sc_hd__and2b_1
XFILLER_103_279 VGND VGND VPWR VPWR sky130_fd_sc_hd__fill_1
X_08916_ net487 net633 net631 net493 VGND VGND VPWR VPWR _01642_ sky130_fd_sc_hd__a22o_1
XFILLER_76_108 VGND VGND VPWR VPWR sky130_fd_sc_hd__fill_1
X_08847_ _01434_ _01436_ _01572_ _01573_ VGND VGND VPWR VPWR _01574_ sky130_fd_sc_hd__o211ai_2
XFILLER_69_182 VPWR VGND VPWR VGND sky130_ef_sc_hd__decap_12
XFILLER_84_141 VGND VGND VPWR VPWR sky130_fd_sc_hd__fill_1
XFILLER_57_377 VGND VGND VPWR VPWR sky130_fd_sc_hd__decap_4
XFILLER_27_12 VGND VGND VPWR VPWR sky130_fd_sc_hd__fill_1
XFILLER_27_23 VPWR VGND VPWR VGND sky130_ef_sc_hd__decap_12
X_08778_ _01494_ _01504_ VGND VGND VPWR VPWR _01505_ sky130_fd_sc_hd__xnor2_1
XFILLER_85_697 VGND VGND VPWR VPWR sky130_fd_sc_hd__fill_1
XFILLER_26_731 VPWR VGND VPWR VGND sky130_ef_sc_hd__decap_12
X_07729_ _00466_ _00467_ VGND VGND VPWR VPWR _00468_ sky130_fd_sc_hd__nand2_1
XFILLER_26_753 VGND VGND VPWR VPWR sky130_fd_sc_hd__decap_3
XFILLER_53_561 VGND VGND VPWR VPWR sky130_fd_sc_hd__fill_2
XFILLER_25_274 VGND VGND VPWR VPWR sky130_fd_sc_hd__decap_6
X_10740_ _03588_ _03590_ VGND VGND VPWR VPWR _03591_ sky130_fd_sc_hd__xnor2_1
XTAP_TAPCELL_ROW_101_1710 VGND VPWR sky130_fd_sc_hd__tapvpwrvgnd_1
X_10671_ _03339_ _03341_ _03338_ VGND VGND VPWR VPWR _03515_ sky130_fd_sc_hd__a21oi_1
XFILLER_13_447 VGND VGND VPWR VPWR sky130_fd_sc_hd__fill_1
XTAP_TAPCELL_ROW_36_792 VGND VPWR sky130_fd_sc_hd__tapvpwrvgnd_1
XFILLER_40_244 VGND VGND VPWR VPWR sky130_fd_sc_hd__decap_8
XFILLER_9_429 VGND VGND VPWR VPWR sky130_fd_sc_hd__fill_2
X_12410_ net405 net599 net588 net413 VGND VGND VPWR VPWR _05411_ sky130_fd_sc_hd__a22o_1
XFILLER_43_66 VPWR VGND VPWR VGND sky130_ef_sc_hd__decap_12
X_13390_ clknet_3_0__leaf_clk _00019_ _00100_ VGND VGND VPWR VPWR net204 sky130_fd_sc_hd__dfrtp_1
XFILLER_21_480 VGND VGND VPWR VPWR sky130_fd_sc_hd__decap_6
X_12341_ _05332_ _05333_ VGND VGND VPWR VPWR _05335_ sky130_fd_sc_hd__xor2_1
XTAP_TAPCELL_ROW_130_2117 VGND VPWR sky130_fd_sc_hd__tapvpwrvgnd_1
X_12272_ net312 net369 _05258_ _05259_ VGND VGND VPWR VPWR _05260_ sky130_fd_sc_hd__o2bb2a_1
X_11223_ net649 _03752_ VGND VGND VPWR VPWR _04119_ sky130_fd_sc_hd__and2_1
XFILLER_107_596 VPWR VGND VPWR VGND sky130_ef_sc_hd__decap_12
XFILLER_4_189 VGND VGND VPWR VPWR sky130_fd_sc_hd__decap_6
XFILLER_4_27 VGND VGND VPWR VPWR sky130_fd_sc_hd__fill_1
XTAP_TAPCELL_ROW_112_1861 VGND VPWR sky130_fd_sc_hd__tapvpwrvgnd_1
XFILLER_68_52 VPWR VGND VPWR VGND sky130_ef_sc_hd__decap_12
X_11154_ _04042_ _04041_ VGND VGND VPWR VPWR _04043_ sky130_fd_sc_hd__and2b_1
XFILLER_67_108 VGND VGND VPWR VPWR sky130_fd_sc_hd__decap_4
X_10105_ net615 net638 net283 net281 VGND VGND VPWR VPWR _02897_ sky130_fd_sc_hd__and4_1
X_11085_ _03966_ _03967_ VGND VGND VPWR VPWR _03968_ sky130_fd_sc_hd__and2b_1
X_10036_ net513 net944 net353 net350 VGND VGND VPWR VPWR _02822_ sky130_fd_sc_hd__and4_1
XFILLER_91_612 VGND VGND VPWR VPWR sky130_fd_sc_hd__decap_4
XFILLER_48_377 VGND VGND VPWR VPWR sky130_fd_sc_hd__decap_4
XFILLER_91_645 VPWR VGND VPWR VGND sky130_ef_sc_hd__decap_12
XFILLER_91_689 VGND VGND VPWR VPWR sky130_fd_sc_hd__fill_2
XFILLER_91_667 VGND VGND VPWR VPWR sky130_fd_sc_hd__decap_4
X_11987_ _04777_ _04764_ _04776_ VGND VGND VPWR VPWR _04950_ sky130_fd_sc_hd__a21bo_1
XFILLER_17_797 VPWR VGND VPWR VGND sky130_ef_sc_hd__decap_12
X_10938_ net289 net52 VGND VGND VPWR VPWR _03808_ sky130_fd_sc_hd__and2_1
XFILLER_32_701 VPWR VGND VPWR VGND sky130_ef_sc_hd__decap_12
XFILLER_71_391 VGND VGND VPWR VPWR sky130_fd_sc_hd__fill_1
XFILLER_31_222 VGND VGND VPWR VPWR sky130_fd_sc_hd__fill_2
X_10869_ _03719_ _03731_ VGND VGND VPWR VPWR _03732_ sky130_fd_sc_hd__xor2_1
XTAP_TAPCELL_ROW_14_486 VGND VPWR sky130_fd_sc_hd__tapvpwrvgnd_1
XTAP_TAPCELL_ROW_14_497 VGND VPWR sky130_fd_sc_hd__tapvpwrvgnd_1
X_12608_ _05226_ _05625_ VGND VGND VPWR VPWR _05628_ sky130_fd_sc_hd__xnor2_1
XFILLER_31_299 VGND VGND VPWR VPWR sky130_fd_sc_hd__fill_2
XFILLER_8_473 VGND VGND VPWR VPWR sky130_fd_sc_hd__decap_3
X_12539_ net478 net674 net672 VGND VGND VPWR VPWR _05552_ sky130_fd_sc_hd__and3_1
XFILLER_133_809 VGND VGND VPWR VPWR sky130_fd_sc_hd__fill_2
XFILLER_113_500 VGND VGND VPWR VPWR sky130_fd_sc_hd__decap_4
XTAP_TAPCELL_ROW_74_1333 VGND VPWR sky130_fd_sc_hd__tapvpwrvgnd_1
XFILLER_125_393 VGND VGND VPWR VPWR sky130_fd_sc_hd__decap_8
XFILLER_99_778 VGND VGND VPWR VPWR sky130_fd_sc_hd__fill_2
Xfanout419 net424 VGND VGND VPWR VPWR net419 sky130_fd_sc_hd__clkbuf_2
Xfanout408 net409 VGND VGND VPWR VPWR net408 sky130_fd_sc_hd__buf_2
X_06962_ _05090_ _05101_ VGND VGND VPWR VPWR _05112_ sky130_fd_sc_hd__nor2_1
XFILLER_100_216 VGND VGND VPWR VPWR sky130_fd_sc_hd__decap_4
XFILLER_98_299 VGND VGND VPWR VPWR sky130_fd_sc_hd__fill_2
XFILLER_98_277 VPWR VGND VPWR VGND sky130_ef_sc_hd__decap_12
XFILLER_86_417 VGND VGND VPWR VPWR sky130_fd_sc_hd__decap_3
X_09750_ _02109_ net291 net325 net324 VGND VGND VPWR VPWR _02515_ sky130_fd_sc_hd__and4_1
XFILLER_104_17 VGND VGND VPWR VPWR sky130_fd_sc_hd__fill_2
X_09681_ _02427_ _02438_ VGND VGND VPWR VPWR _02440_ sky130_fd_sc_hd__xnor2_1
X_08701_ _01424_ _01426_ _01407_ VGND VGND VPWR VPWR _01429_ sky130_fd_sc_hd__o21a_1
X_08632_ _01358_ _01359_ VGND VGND VPWR VPWR _01360_ sky130_fd_sc_hd__xnor2_1
X_06893_ _04254_ _04276_ _04265_ VGND VGND VPWR VPWR _04363_ sky130_fd_sc_hd__a21o_1
XFILLER_55_804 VGND VGND VPWR VPWR sky130_fd_sc_hd__decap_3
XFILLER_54_303 VGND VGND VPWR VPWR sky130_fd_sc_hd__decap_4
XFILLER_27_517 VGND VGND VPWR VPWR sky130_fd_sc_hd__decap_6
XFILLER_82_634 VGND VGND VPWR VPWR sky130_fd_sc_hd__decap_8
XFILLER_81_100 VGND VGND VPWR VPWR sky130_fd_sc_hd__decap_4
X_08563_ _01287_ _01289_ _01252_ VGND VGND VPWR VPWR _01292_ sky130_fd_sc_hd__o21a_1
XFILLER_81_155 VPWR VGND VPWR VGND sky130_ef_sc_hd__decap_12
XFILLER_35_550 VGND VGND VPWR VPWR sky130_fd_sc_hd__decap_8
XFILLER_120_27 VGND VGND VPWR VPWR sky130_fd_sc_hd__fill_1
X_08494_ _01169_ _01220_ _01219_ VGND VGND VPWR VPWR _01223_ sky130_fd_sc_hd__o21ai_2
XTAP_TAPCELL_ROW_85_1484 VGND VPWR sky130_fd_sc_hd__tapvpwrvgnd_1
X_07514_ _00218_ _00219_ _00251_ _00252_ VGND VGND VPWR VPWR _00255_ sky130_fd_sc_hd__a2bb2oi_1
X_07445_ net251 net476 VGND VGND VPWR VPWR _00186_ sky130_fd_sc_hd__and2_2
XTAP_TAPCELL_ROW_33_751 VGND VPWR sky130_fd_sc_hd__tapvpwrvgnd_1
XTAP_TAPCELL_ROW_33_762 VGND VPWR sky130_fd_sc_hd__tapvpwrvgnd_1
X_07376_ _06551_ _06584_ _06582_ VGND VGND VPWR VPWR _06666_ sky130_fd_sc_hd__o21ba_1
XFILLER_50_597 VGND VGND VPWR VPWR sky130_fd_sc_hd__decap_3
XFILLER_13_47 VGND VGND VPWR VPWR sky130_fd_sc_hd__decap_8
X_09115_ net439 net550 net548 net448 VGND VGND VPWR VPWR _01840_ sky130_fd_sc_hd__a22o_1
XFILLER_135_113 VPWR VGND VPWR VGND sky130_ef_sc_hd__decap_12
XFILLER_129_69 VPWR VGND VPWR VGND sky130_ef_sc_hd__decap_12
X_09046_ _01761_ _01762_ _01770_ VGND VGND VPWR VPWR _01771_ sky130_fd_sc_hd__or3_1
XFILLER_1_137 VPWR VGND VPWR VGND sky130_ef_sc_hd__decap_12
XFILLER_131_352 VGND VGND VPWR VPWR sky130_fd_sc_hd__decap_8
X_09948_ _02728_ _02726_ _02725_ VGND VGND VPWR VPWR _02730_ sky130_fd_sc_hd__a21oi_2
XFILLER_77_417 VPWR VGND VPWR VGND sky130_ef_sc_hd__decap_12
X_09879_ net407 _01822_ _02655_ VGND VGND VPWR VPWR _02656_ sky130_fd_sc_hd__o21ba_1
XFILLER_85_461 VPWR VGND VPWR VGND sky130_ef_sc_hd__decap_12
XFILLER_38_88 VGND VGND VPWR VPWR sky130_fd_sc_hd__fill_2
XFILLER_85_494 VGND VGND VPWR VPWR sky130_fd_sc_hd__decap_8
X_11910_ _04863_ _04864_ VGND VGND VPWR VPWR _04865_ sky130_fd_sc_hd__nand2_1
XFILLER_18_539 VPWR VGND VPWR VGND sky130_ef_sc_hd__decap_12
X_12890_ _05907_ _05935_ VGND VGND VPWR VPWR _05936_ sky130_fd_sc_hd__nor2_1
X_11841_ net438 net600 _04787_ _04788_ VGND VGND VPWR VPWR _04790_ sky130_fd_sc_hd__a22o_1
XFILLER_45_347 VPWR VGND VPWR VGND sky130_ef_sc_hd__decap_12
X_11772_ net534 net662 VGND VGND VPWR VPWR _04714_ sky130_fd_sc_hd__nand2_1
XFILLER_26_583 VGND VGND VPWR VPWR sky130_fd_sc_hd__decap_4
XFILLER_60_339 VGND VGND VPWR VPWR sky130_fd_sc_hd__fill_2
XFILLER_14_734 VPWR VGND VPWR VGND sky130_ef_sc_hd__decap_12
X_10723_ _03570_ _03571_ VGND VGND VPWR VPWR _03572_ sky130_fd_sc_hd__xnor2_1
X_10654_ _03496_ _03334_ VGND VGND VPWR VPWR _03497_ sky130_fd_sc_hd__nand2_2
X_13373_ clknet_3_4__leaf_clk _00025_ _00083_ VGND VGND VPWR VPWR net187 sky130_fd_sc_hd__dfrtp_1
XFILLER_70_75 VGND VGND VPWR VPWR sky130_fd_sc_hd__fill_2
X_10585_ _03418_ _03419_ _03386_ VGND VGND VPWR VPWR _03421_ sky130_fd_sc_hd__a21o_1
XTAP_TAPCELL_ROW_11_445 VGND VPWR sky130_fd_sc_hd__tapvpwrvgnd_1
XFILLER_70_97 VPWR VGND VPWR VGND sky130_ef_sc_hd__decap_12
X_12324_ _05313_ _05314_ VGND VGND VPWR VPWR _05316_ sky130_fd_sc_hd__and2_1
XFILLER_115_809 VGND VGND VPWR VPWR sky130_fd_sc_hd__fill_2
X_12255_ _05230_ _05239_ _05240_ VGND VGND VPWR VPWR _05241_ sky130_fd_sc_hd__nand3_1
XFILLER_79_73 VGND VGND VPWR VPWR sky130_fd_sc_hd__decap_4
XTAP_TAPCELL_ROW_56_1074 VGND VPWR sky130_fd_sc_hd__tapvpwrvgnd_1
X_12186_ net524 net507 net110 net661 VGND VGND VPWR VPWR _05165_ sky130_fd_sc_hd__and4_1
X_11206_ _04094_ _04099_ VGND VGND VPWR VPWR _04100_ sky130_fd_sc_hd__xnor2_1
XFILLER_96_737 VGND VGND VPWR VPWR sky130_fd_sc_hd__fill_1
XTAP_TAPCELL_ROW_56_1085 VGND VPWR sky130_fd_sc_hd__tapvpwrvgnd_1
XFILLER_1_671 VGND VGND VPWR VPWR sky130_fd_sc_hd__fill_1
X_11137_ _03886_ _03901_ _03900_ VGND VGND VPWR VPWR _04025_ sky130_fd_sc_hd__o21a_1
XFILLER_96_748 VGND VGND VPWR VPWR sky130_fd_sc_hd__decap_8
XFILLER_0_181 VPWR VGND VPWR VGND sky130_ef_sc_hd__decap_12
XFILLER_110_569 VPWR VGND VPWR VGND sky130_ef_sc_hd__decap_12
XFILLER_48_141 VGND VGND VPWR VPWR sky130_fd_sc_hd__decap_8
X_11068_ _03947_ _03949_ VGND VGND VPWR VPWR _03950_ sky130_fd_sc_hd__xnor2_2
XFILLER_63_111 VGND VGND VPWR VPWR sky130_fd_sc_hd__fill_1
X_10019_ _02804_ VGND VGND VPWR VPWR _02805_ sky130_fd_sc_hd__inv_2
XFILLER_63_133 VPWR VGND VPWR VGND sky130_ef_sc_hd__decap_12
XTAP_TAPCELL_ROW_19_556 VGND VPWR sky130_fd_sc_hd__tapvpwrvgnd_1
XFILLER_63_166 VGND VGND VPWR VPWR sky130_fd_sc_hd__fill_2
XFILLER_17_561 VGND VGND VPWR VPWR sky130_fd_sc_hd__decap_3
XTAP_TAPCELL_ROW_19_567 VGND VPWR sky130_fd_sc_hd__tapvpwrvgnd_1
XFILLER_63_199 VGND VGND VPWR VPWR sky130_fd_sc_hd__decap_6
XFILLER_17_594 VGND VGND VPWR VPWR sky130_fd_sc_hd__decap_4
XFILLER_32_575 VPWR VGND VPWR VGND sky130_ef_sc_hd__decap_12
X_07230_ _06383_ _06520_ VGND VGND VPWR VPWR _06521_ sky130_fd_sc_hd__xnor2_1
XPHY_EDGE_ROW_4_Left_141 VGND VGND VPWR VPWR sky130_fd_sc_hd__decap_3
XTAP_TAPCELL_ROW_30_710 VGND VPWR sky130_fd_sc_hd__tapvpwrvgnd_1
XTAP_TAPCELL_ROW_30_721 VGND VPWR sky130_fd_sc_hd__tapvpwrvgnd_1
X_07161_ _05833_ _05855_ _05844_ VGND VGND VPWR VPWR _06453_ sky130_fd_sc_hd__o21ba_1
XFILLER_118_658 VGND VGND VPWR VPWR sky130_fd_sc_hd__fill_1
XFILLER_8_281 VPWR VGND VPWR VGND sky130_ef_sc_hd__decap_12
XFILLER_133_617 VPWR VGND VPWR VGND sky130_ef_sc_hd__decap_12
X_07092_ net322 net320 net595 net571 VGND VGND VPWR VPWR _06384_ sky130_fd_sc_hd__and4_1
XFILLER_113_330 VGND VGND VPWR VPWR sky130_fd_sc_hd__decap_6
XFILLER_5_81 VPWR VGND VPWR VGND sky130_ef_sc_hd__decap_12
XFILLER_115_27 VPWR VGND VPWR VGND sky130_ef_sc_hd__decap_12
XFILLER_99_597 VPWR VGND VPWR VGND sky130_ef_sc_hd__decap_12
X_09802_ _02416_ _02443_ _02415_ VGND VGND VPWR VPWR _02572_ sky130_fd_sc_hd__a21oi_1
XFILLER_87_726 VGND VGND VPWR VPWR sky130_fd_sc_hd__fill_2
Xfanout249 _00310_ VGND VGND VPWR VPWR net249 sky130_fd_sc_hd__clkbuf_4
X_07994_ _00643_ _00649_ _00545_ VGND VGND VPWR VPWR _00731_ sky130_fd_sc_hd__a21o_1
X_09733_ _02083_ _02367_ _02366_ VGND VGND VPWR VPWR _02497_ sky130_fd_sc_hd__a21o_1
X_06945_ _04872_ _04916_ _04829_ _04840_ VGND VGND VPWR VPWR _04927_ sky130_fd_sc_hd__o211ai_2
XFILLER_74_409 VGND VGND VPWR VPWR sky130_fd_sc_hd__fill_1
XFILLER_28_804 VGND VGND VPWR VPWR sky130_fd_sc_hd__decap_6
XFILLER_39_152 VGND VGND VPWR VPWR sky130_fd_sc_hd__fill_2
XFILLER_131_15 VPWR VGND VPWR VGND sky130_ef_sc_hd__decap_12
X_09664_ net479 net626 net625 VGND VGND VPWR VPWR _02421_ sky130_fd_sc_hd__and3_2
XTAP_TAPCELL_ROW_87_1513 VGND VPWR sky130_fd_sc_hd__tapvpwrvgnd_1
X_06876_ net514 net386 net383 net695 VGND VGND VPWR VPWR _04177_ sky130_fd_sc_hd__a22oi_1
XFILLER_67_483 VPWR VGND VPWR VGND sky130_ef_sc_hd__decap_12
XFILLER_54_100 VPWR VGND VPWR VGND sky130_ef_sc_hd__decap_12
XTAP_TAPCELL_ROW_38_821 VGND VPWR sky130_fd_sc_hd__tapvpwrvgnd_1
XFILLER_39_163 VGND VGND VPWR VPWR sky130_fd_sc_hd__decap_4
X_08615_ _01341_ _01342_ VGND VGND VPWR VPWR _01343_ sky130_fd_sc_hd__nor2_1
X_09595_ _02345_ _02346_ VGND VGND VPWR VPWR _02347_ sky130_fd_sc_hd__or2_1
XFILLER_82_442 VGND VGND VPWR VPWR sky130_fd_sc_hd__decap_3
XFILLER_55_667 VGND VGND VPWR VPWR sky130_fd_sc_hd__fill_2
XTAP_TAPCELL_ROW_38_832 VGND VPWR sky130_fd_sc_hd__tapvpwrvgnd_1
XFILLER_91_19 VGND VGND VPWR VPWR sky130_fd_sc_hd__fill_2
XFILLER_82_475 VGND VGND VPWR VPWR sky130_fd_sc_hd__fill_1
XFILLER_54_177 VGND VGND VPWR VPWR sky130_fd_sc_hd__decap_8
X_08546_ _01253_ _01273_ _01274_ VGND VGND VPWR VPWR _01275_ sky130_fd_sc_hd__or3_4
XFILLER_23_542 VPWR VGND VPWR VGND sky130_ef_sc_hd__decap_12
X_08477_ _01175_ _01204_ VGND VGND VPWR VPWR _01206_ sky130_fd_sc_hd__xnor2_1
XPHY_EDGE_ROW_59_Left_196 VGND VGND VPWR VPWR sky130_fd_sc_hd__decap_3
XFILLER_50_361 VGND VGND VPWR VPWR sky130_fd_sc_hd__decap_3
XFILLER_23_575 VPWR VGND VPWR VGND sky130_ef_sc_hd__decap_12
X_07428_ _00167_ _00168_ VGND VGND VPWR VPWR _00169_ sky130_fd_sc_hd__nand2b_1
XFILLER_11_726 VGND VGND VPWR VPWR sky130_fd_sc_hd__fill_2
XFILLER_10_225 VPWR VGND VPWR VGND sky130_ef_sc_hd__decap_12
X_07359_ _06648_ _06649_ VGND VGND VPWR VPWR _06650_ sky130_fd_sc_hd__or2_1
XTAP_TAPCELL_ROW_98_1664 VGND VPWR sky130_fd_sc_hd__tapvpwrvgnd_1
XFILLER_40_12 VGND VGND VPWR VPWR sky130_fd_sc_hd__fill_2
XFILLER_40_34 VPWR VGND VPWR VGND sky130_ef_sc_hd__decap_12
XFILLER_136_477 VPWR VGND VPWR VGND sky130_ef_sc_hd__decap_12
XFILLER_108_146 VPWR VGND VPWR VGND sky130_ef_sc_hd__decap_12
X_10370_ net639 net276 VGND VGND VPWR VPWR _03187_ sky130_fd_sc_hd__nand2_1
X_09029_ _01617_ _01632_ _01631_ VGND VGND VPWR VPWR _01754_ sky130_fd_sc_hd__o21ai_1
XFILLER_2_413 VGND VGND VPWR VPWR sky130_fd_sc_hd__decap_6
XFILLER_104_330 VGND VGND VPWR VPWR sky130_fd_sc_hd__decap_6
X_12040_ _05005_ _05006_ VGND VGND VPWR VPWR _05007_ sky130_fd_sc_hd__and2b_1
XFILLER_2_457 VPWR VGND VPWR VGND sky130_ef_sc_hd__decap_12
XFILLER_78_737 VGND VGND VPWR VPWR sky130_fd_sc_hd__decap_6
XFILLER_77_225 VPWR VGND VPWR VGND sky130_ef_sc_hd__decap_12
XFILLER_49_76 VGND VGND VPWR VPWR sky130_fd_sc_hd__fill_1
XFILLER_93_729 VGND VGND VPWR VPWR sky130_fd_sc_hd__decap_3
XTAP_TAPCELL_ROW_125_2049 VGND VPWR sky130_fd_sc_hd__tapvpwrvgnd_1
XTAP_TAPCELL_ROW_125_2038 VGND VPWR sky130_fd_sc_hd__tapvpwrvgnd_1
XFILLER_65_31 VGND VGND VPWR VPWR sky130_fd_sc_hd__decap_8
XFILLER_58_472 VGND VGND VPWR VPWR sky130_fd_sc_hd__decap_4
XFILLER_46_623 VPWR VGND VPWR VGND sky130_ef_sc_hd__decap_12
X_12942_ _05894_ _05991_ VGND VGND VPWR VPWR _05992_ sky130_fd_sc_hd__nor2_1
XFILLER_1_39 VPWR VGND VPWR VGND sky130_ef_sc_hd__decap_12
XFILLER_46_645 VPWR VGND VPWR VGND sky130_ef_sc_hd__decap_12
XFILLER_18_336 VPWR VGND VPWR VGND sky130_ef_sc_hd__decap_12
XFILLER_61_615 VGND VGND VPWR VPWR sky130_fd_sc_hd__fill_1
XTAP_TAPCELL_ROW_16_515 VGND VPWR sky130_fd_sc_hd__tapvpwrvgnd_1
X_12873_ _05717_ _05916_ VGND VGND VPWR VPWR _05917_ sky130_fd_sc_hd__xnor2_1
XTAP_TAPCELL_ROW_107_1793 VGND VPWR sky130_fd_sc_hd__tapvpwrvgnd_1
XFILLER_73_497 VGND VGND VPWR VPWR sky130_fd_sc_hd__decap_6
X_11824_ net519 net44 VGND VGND VPWR VPWR _04771_ sky130_fd_sc_hd__nand2_1
XFILLER_121_81 VGND VGND VPWR VPWR sky130_fd_sc_hd__decap_6
X_11755_ _04694_ _04693_ VGND VGND VPWR VPWR _04695_ sky130_fd_sc_hd__and2b_1
XTAP_TAPCELL_ROW_120_1971 VGND VPWR sky130_fd_sc_hd__tapvpwrvgnd_1
X_10706_ _03539_ _03552_ VGND VGND VPWR VPWR _03553_ sky130_fd_sc_hd__nand2_1
X_11686_ _04584_ _04619_ VGND VGND VPWR VPWR _04620_ sky130_fd_sc_hd__and2_1
XFILLER_10_781 VPWR VGND VPWR VGND sky130_ef_sc_hd__decap_12
X_10637_ _03477_ _03476_ VGND VGND VPWR VPWR _03479_ sky130_fd_sc_hd__nand2b_1
X_13356_ clknet_3_3__leaf_clk _00008_ _00066_ VGND VGND VPWR VPWR net170 sky130_fd_sc_hd__dfrtp_1
XPHY_EDGE_ROW_116_Right_116 VGND VGND VPWR VPWR sky130_fd_sc_hd__decap_3
XTAP_TAPCELL_ROW_58_1103 VGND VPWR sky130_fd_sc_hd__tapvpwrvgnd_1
X_10568_ _03391_ _03402_ VGND VGND VPWR VPWR _03403_ sky130_fd_sc_hd__xnor2_1
X_10499_ _03044_ _03177_ _03324_ _03326_ VGND VGND VPWR VPWR _03328_ sky130_fd_sc_hd__a22o_1
X_12307_ _05119_ _05121_ _05297_ VGND VGND VPWR VPWR _05299_ sky130_fd_sc_hd__a21oi_1
XFILLER_5_273 VGND VGND VPWR VPWR sky130_fd_sc_hd__decap_6
X_13287_ _06321_ _06366_ VGND VGND VPWR VPWR _06368_ sky130_fd_sc_hd__xnor2_1
X_12238_ _05184_ _05222_ VGND VGND VPWR VPWR _05223_ sky130_fd_sc_hd__xnor2_1
X_12169_ _04986_ _05146_ VGND VGND VPWR VPWR _05147_ sky130_fd_sc_hd__xnor2_1
XFILLER_96_589 VGND VGND VPWR VPWR sky130_fd_sc_hd__decap_4
XFILLER_56_409 VGND VGND VPWR VPWR sky130_fd_sc_hd__decap_8
XFILLER_37_601 VGND VGND VPWR VPWR sky130_fd_sc_hd__decap_4
X_06730_ _02577_ VGND VGND VPWR VPWR _02588_ sky130_fd_sc_hd__inv_2
Xinput5 in0[4] VGND VGND VPWR VPWR net5 sky130_fd_sc_hd__buf_12
XFILLER_37_612 VGND VGND VPWR VPWR sky130_fd_sc_hd__decap_4
XFILLER_37_634 VPWR VGND VPWR VGND sky130_ef_sc_hd__decap_12
XFILLER_92_751 VGND VGND VPWR VPWR sky130_fd_sc_hd__decap_4
XTAP_TAPCELL_ROW_69_1254 VGND VPWR sky130_fd_sc_hd__tapvpwrvgnd_1
X_08400_ net455 net558 VGND VGND VPWR VPWR _01130_ sky130_fd_sc_hd__nand2_1
XTAP_TAPCELL_ROW_69_1265 VGND VPWR sky130_fd_sc_hd__tapvpwrvgnd_1
XFILLER_24_306 VGND VGND VPWR VPWR sky130_fd_sc_hd__fill_2
XFILLER_24_317 VGND VGND VPWR VPWR sky130_fd_sc_hd__decap_3
XFILLER_36_177 VGND VGND VPWR VPWR sky130_fd_sc_hd__decap_3
X_09380_ _01950_ _02112_ VGND VGND VPWR VPWR _02113_ sky130_fd_sc_hd__xnor2_1
XFILLER_101_18 VPWR VGND VPWR VGND sky130_ef_sc_hd__decap_12
XFILLER_17_391 VGND VGND VPWR VPWR sky130_fd_sc_hd__fill_1
XFILLER_24_339 VPWR VGND VPWR VGND sky130_ef_sc_hd__decap_12
X_08331_ _00974_ _00976_ _00973_ VGND VGND VPWR VPWR _01065_ sky130_fd_sc_hd__a21oi_1
XTAP_TAPCELL_ROW_82_1443 VGND VPWR sky130_fd_sc_hd__tapvpwrvgnd_1
XFILLER_51_169 VPWR VGND VPWR VGND sky130_ef_sc_hd__decap_12
XFILLER_32_350 VGND VGND VPWR VPWR sky130_fd_sc_hd__decap_3
X_08262_ _00996_ VGND VGND VPWR VPWR _00997_ sky130_fd_sc_hd__inv_2
XFILLER_32_361 VGND VGND VPWR VPWR sky130_fd_sc_hd__decap_3
X_07213_ _06379_ _06502_ VGND VGND VPWR VPWR _06504_ sky130_fd_sc_hd__xnor2_1
XTAP_TAPCELL_ROW_43_890 VGND VPWR sky130_fd_sc_hd__tapvpwrvgnd_1
X_08193_ _00808_ _00810_ _00928_ VGND VGND VPWR VPWR _00929_ sky130_fd_sc_hd__o21ba_1
X_07144_ _06434_ _06435_ VGND VGND VPWR VPWR _06436_ sky130_fd_sc_hd__and2b_1
X_07075_ net642 net307 VGND VGND VPWR VPWR _06345_ sky130_fd_sc_hd__nand2_1
XFILLER_118_477 VGND VGND VPWR VPWR sky130_fd_sc_hd__decap_4
XFILLER_10_15 VPWR VGND VPWR VGND sky130_ef_sc_hd__decap_12
XFILLER_126_15 VPWR VGND VPWR VGND sky130_ef_sc_hd__decap_12
XFILLER_120_108 VPWR VGND VPWR VGND sky130_ef_sc_hd__decap_12
XTAP_TAPCELL_ROW_93_1594 VGND VPWR sky130_fd_sc_hd__tapvpwrvgnd_1
XFILLER_86_19 VGND VGND VPWR VPWR sky130_fd_sc_hd__decap_8
XFILLER_59_225 VGND VGND VPWR VPWR sky130_fd_sc_hd__fill_1
XFILLER_59_214 VGND VGND VPWR VPWR sky130_fd_sc_hd__decap_8
XFILLER_19_13 VGND VGND VPWR VPWR sky130_fd_sc_hd__fill_1
XFILLER_113_193 VPWR VGND VPWR VGND sky130_ef_sc_hd__decap_12
XFILLER_75_718 VGND VGND VPWR VPWR sky130_fd_sc_hd__decap_8
X_07977_ _00508_ _00620_ _00388_ VGND VGND VPWR VPWR _00714_ sky130_fd_sc_hd__o21ai_1
X_09716_ _02464_ _02477_ VGND VGND VPWR VPWR _02478_ sky130_fd_sc_hd__xnor2_1
X_06928_ _04654_ _04719_ _04730_ VGND VGND VPWR VPWR _04741_ sky130_fd_sc_hd__and3_4
XFILLER_19_57 VGND VGND VPWR VPWR sky130_fd_sc_hd__decap_3
XFILLER_27_111 VGND VGND VPWR VPWR sky130_fd_sc_hd__fill_1
X_09647_ _02310_ _02402_ VGND VGND VPWR VPWR _02403_ sky130_fd_sc_hd__nor2_1
X_06859_ net460 net611 net452 net610 VGND VGND VPWR VPWR _03992_ sky130_fd_sc_hd__and4_1
XFILLER_70_412 VGND VGND VPWR VPWR sky130_fd_sc_hd__decap_8
XFILLER_70_401 VGND VGND VPWR VPWR sky130_fd_sc_hd__decap_6
XFILLER_42_103 VGND VGND VPWR VPWR sky130_fd_sc_hd__fill_1
X_09578_ _02326_ _02328_ VGND VGND VPWR VPWR _02329_ sky130_fd_sc_hd__and2b_1
XPHY_EDGE_ROW_67_Left_204 VGND VGND VPWR VPWR sky130_fd_sc_hd__decap_3
XFILLER_43_648 VGND VGND VPWR VPWR sky130_fd_sc_hd__fill_1
XFILLER_35_67 VGND VGND VPWR VPWR sky130_fd_sc_hd__fill_1
X_08529_ net358 net735 net340 net339 VGND VGND VPWR VPWR _01258_ sky130_fd_sc_hd__and4_1
XFILLER_30_309 VGND VGND VPWR VPWR sky130_fd_sc_hd__fill_1
XFILLER_42_169 VPWR VGND VPWR VGND sky130_ef_sc_hd__decap_12
XFILLER_129_709 VPWR VGND VPWR VGND sky130_ef_sc_hd__decap_12
XFILLER_70_489 VGND VGND VPWR VPWR sky130_fd_sc_hd__decap_4
XFILLER_11_501 VGND VGND VPWR VPWR sky130_fd_sc_hd__decap_3
X_11540_ _04442_ _04464_ VGND VGND VPWR VPWR _04465_ sky130_fd_sc_hd__nand2b_1
XFILLER_136_3 VPWR VGND VPWR VGND sky130_ef_sc_hd__decap_12
XFILLER_7_505 VPWR VGND VPWR VGND sky130_ef_sc_hd__decap_12
XFILLER_51_88 VGND VGND VPWR VPWR sky130_fd_sc_hd__fill_2
X_11471_ _04376_ _04388_ _04389_ VGND VGND VPWR VPWR _04390_ sky130_fd_sc_hd__or3_1
X_10422_ _03241_ _03242_ _03114_ VGND VGND VPWR VPWR _03243_ sky130_fd_sc_hd__a21oi_1
X_13210_ _05524_ _06011_ _06135_ VGND VGND VPWR VPWR _06285_ sky130_fd_sc_hd__or3_1
XTAP_TAPCELL_ROW_21_584 VGND VPWR sky130_fd_sc_hd__tapvpwrvgnd_1
XTAP_TAPCELL_ROW_21_595 VGND VPWR sky130_fd_sc_hd__tapvpwrvgnd_1
XFILLER_109_499 VGND VGND VPWR VPWR sky130_fd_sc_hd__decap_4
XPHY_EDGE_ROW_76_Left_213 VGND VGND VPWR VPWR sky130_fd_sc_hd__decap_3
X_10353_ _03086_ _03167_ _03168_ VGND VGND VPWR VPWR _03169_ sky130_fd_sc_hd__nor3_4
X_13141_ _06204_ _06209_ VGND VGND VPWR VPWR _06210_ sky130_fd_sc_hd__xnor2_1
XFILLER_2_221 VPWR VGND VPWR VGND sky130_ef_sc_hd__decap_12
X_13072_ _06011_ _06133_ VGND VGND VPWR VPWR _06134_ sky130_fd_sc_hd__nor2_1
XFILLER_124_469 VGND VGND VPWR VPWR sky130_fd_sc_hd__decap_6
X_10284_ _03090_ _03091_ _03089_ VGND VGND VPWR VPWR _03093_ sky130_fd_sc_hd__a21bo_1
XFILLER_3_777 VGND VGND VPWR VPWR sky130_fd_sc_hd__decap_6
XFILLER_2_265 VPWR VGND VPWR VGND sky130_ef_sc_hd__decap_12
X_12023_ net640 net296 net294 net665 VGND VGND VPWR VPWR _04988_ sky130_fd_sc_hd__a22oi_1
XFILLER_104_171 VPWR VGND VPWR VGND sky130_ef_sc_hd__decap_12
XTAP_TAPCELL_ROW_53_1033 VGND VPWR sky130_fd_sc_hd__tapvpwrvgnd_1
XFILLER_76_41 VGND VGND VPWR VPWR sky130_fd_sc_hd__decap_8
XFILLER_120_697 VGND VGND VPWR VPWR sky130_fd_sc_hd__decap_3
XFILLER_120_686 VGND VGND VPWR VPWR sky130_fd_sc_hd__fill_1
XTAP_TAPCELL_ROW_109_1822 VGND VPWR sky130_fd_sc_hd__tapvpwrvgnd_1
XFILLER_76_63 VPWR VGND VPWR VGND sky130_ef_sc_hd__decap_12
Xfanout591 net593 VGND VGND VPWR VPWR net591 sky130_fd_sc_hd__dlymetal6s2s_1
Xfanout580 net146 VGND VGND VPWR VPWR net580 sky130_fd_sc_hd__buf_2
XFILLER_93_559 VGND VGND VPWR VPWR sky130_fd_sc_hd__fill_1
XPHY_EDGE_ROW_85_Left_222 VGND VGND VPWR VPWR sky130_fd_sc_hd__decap_3
XFILLER_80_209 VGND VGND VPWR VPWR sky130_fd_sc_hd__decap_4
XFILLER_46_475 VGND VGND VPWR VPWR sky130_fd_sc_hd__fill_1
X_12925_ net312 net361 _02284_ net334 VGND VGND VPWR VPWR _05973_ sky130_fd_sc_hd__o2bb2a_1
XFILLER_18_177 VPWR VGND VPWR VGND sky130_ef_sc_hd__decap_12
X_12856_ _05892_ _05897_ VGND VGND VPWR VPWR _05898_ sky130_fd_sc_hd__xnor2_1
XTAP_TAPCELL_ROW_29_695 VGND VPWR sky130_fd_sc_hd__tapvpwrvgnd_1
X_11807_ net472 net587 _04744_ _04745_ VGND VGND VPWR VPWR _04753_ sky130_fd_sc_hd__o2bb2a_1
XTAP_TAPCELL_ROW_64_1184 VGND VPWR sky130_fd_sc_hd__tapvpwrvgnd_1
XFILLER_14_383 VPWR VGND VPWR VGND sky130_ef_sc_hd__decap_12
X_12787_ _05708_ _05741_ _05740_ VGND VGND VPWR VPWR _05823_ sky130_fd_sc_hd__a21o_1
XFILLER_42_681 VGND VGND VPWR VPWR sky130_fd_sc_hd__fill_2
XTAP_TAPCELL_ROW_64_1195 VGND VPWR sky130_fd_sc_hd__tapvpwrvgnd_1
X_11738_ net690 net297 VGND VGND VPWR VPWR _04677_ sky130_fd_sc_hd__nand2_1
X_11669_ _04574_ _04575_ _04576_ _04602_ VGND VGND VPWR VPWR _04603_ sky130_fd_sc_hd__or4_2
XTAP_TAPCELL_ROW_40_860 VGND VPWR sky130_fd_sc_hd__tapvpwrvgnd_1
X_13408_ clknet_3_7__leaf_clk _00060_ _00118_ VGND VGND VPWR VPWR net222 sky130_fd_sc_hd__dfrtp_1
XPHY_EDGE_ROW_94_Left_231 VGND VGND VPWR VPWR sky130_fd_sc_hd__decap_3
X_13339_ net398 VGND VGND VPWR VPWR _00113_ sky130_fd_sc_hd__inv_2
XFILLER_115_447 VGND VGND VPWR VPWR sky130_fd_sc_hd__fill_1
XFILLER_102_108 VGND VGND VPWR VPWR sky130_fd_sc_hd__decap_4
XFILLER_88_309 VGND VGND VPWR VPWR sky130_fd_sc_hd__decap_8
X_08880_ net535 net624 VGND VGND VPWR VPWR _01606_ sky130_fd_sc_hd__and2b_1
X_07900_ _00636_ _00637_ VGND VGND VPWR VPWR _00638_ sky130_fd_sc_hd__nor2_1
X_07831_ _00568_ _00569_ VGND VGND VPWR VPWR _00570_ sky130_fd_sc_hd__nor2_1
XFILLER_111_653 VGND VGND VPWR VPWR sky130_fd_sc_hd__fill_1
XFILLER_110_141 VGND VGND VPWR VPWR sky130_fd_sc_hd__decap_4
XFILLER_69_567 VGND VGND VPWR VPWR sky130_fd_sc_hd__decap_3
XFILLER_57_729 VGND VGND VPWR VPWR sky130_fd_sc_hd__decap_8
XFILLER_56_206 VGND VGND VPWR VPWR sky130_fd_sc_hd__fill_2
X_09501_ net572 net255 _02243_ VGND VGND VPWR VPWR _02245_ sky130_fd_sc_hd__and3_1
X_07762_ _00344_ _00350_ _00349_ VGND VGND VPWR VPWR _00501_ sky130_fd_sc_hd__a21oi_1
X_06713_ _02381_ _02392_ VGND VGND VPWR VPWR _00006_ sky130_fd_sc_hd__and2_1
X_07693_ _00431_ _00432_ VGND VGND VPWR VPWR _00050_ sky130_fd_sc_hd__xor2_1
XFILLER_92_570 VGND VGND VPWR VPWR sky130_fd_sc_hd__decap_4
XFILLER_80_710 VGND VGND VPWR VPWR sky130_fd_sc_hd__fill_1
XTAP_TAPCELL_ROW_48_971 VGND VPWR sky130_fd_sc_hd__tapvpwrvgnd_1
XTAP_TAPCELL_ROW_48_960 VGND VPWR sky130_fd_sc_hd__tapvpwrvgnd_1
XFILLER_37_464 VPWR VGND VPWR VGND sky130_ef_sc_hd__decap_12
X_09432_ _02168_ _02169_ VGND VGND VPWR VPWR _02170_ sky130_fd_sc_hd__xnor2_2
X_09363_ _02092_ _02093_ VGND VGND VPWR VPWR _02094_ sky130_fd_sc_hd__xor2_1
XFILLER_12_309 VGND VGND VPWR VPWR sky130_fd_sc_hd__decap_4
X_08314_ _01044_ _01047_ VGND VGND VPWR VPWR _01048_ sky130_fd_sc_hd__xnor2_1
X_09294_ _02000_ _02018_ VGND VGND VPWR VPWR _02019_ sky130_fd_sc_hd__xor2_1
XANTENNA_32 net311 VGND VGND VPWR VPWR sky130_fd_sc_hd__diode_2
XANTENNA_10 _02109_ VGND VGND VPWR VPWR sky130_fd_sc_hd__diode_2
XANTENNA_21 net89 VGND VGND VPWR VPWR sky130_fd_sc_hd__diode_2
X_08245_ _00978_ _00979_ VGND VGND VPWR VPWR _00980_ sky130_fd_sc_hd__nand2_1
X_08176_ _00795_ _00798_ _00911_ VGND VGND VPWR VPWR _00912_ sky130_fd_sc_hd__a21oi_1
XFILLER_134_701 VPWR VGND VPWR VGND sky130_ef_sc_hd__decap_12
XFILLER_119_797 VGND VGND VPWR VPWR sky130_fd_sc_hd__decap_6
XTAP_TAPCELL_ROW_95_1623 VGND VPWR sky130_fd_sc_hd__tapvpwrvgnd_1
X_07127_ net99 net491 net484 net252 VGND VGND VPWR VPWR _06419_ sky130_fd_sc_hd__a22o_1
XFILLER_133_222 VGND VGND VPWR VPWR sky130_fd_sc_hd__fill_2
XFILLER_106_447 VPWR VGND VPWR VGND sky130_ef_sc_hd__decap_12
XFILLER_106_425 VGND VGND VPWR VPWR sky130_fd_sc_hd__decap_6
X_07058_ _06117_ net937 _05626_ VGND VGND VPWR VPWR _06161_ sky130_fd_sc_hd__o21ai_4
Xoutput172 net172 VGND VGND VPWR VPWR out0[4] sky130_fd_sc_hd__buf_2
Xoutput194 net194 VGND VGND VPWR VPWR out2[0] sky130_fd_sc_hd__buf_2
XFILLER_0_725 VGND VGND VPWR VPWR sky130_fd_sc_hd__decap_3
Xoutput183 net183 VGND VGND VPWR VPWR out1[14] sky130_fd_sc_hd__buf_2
XFILLER_87_364 VGND VGND VPWR VPWR sky130_fd_sc_hd__decap_6
XFILLER_0_769 VPWR VGND VPWR VGND sky130_ef_sc_hd__decap_12
XFILLER_75_537 VGND VGND VPWR VPWR sky130_fd_sc_hd__decap_4
XFILLER_47_217 VGND VGND VPWR VPWR sky130_fd_sc_hd__decap_6
XFILLER_101_185 VPWR VGND VPWR VGND sky130_ef_sc_hd__decap_12
XFILLER_28_442 VGND VGND VPWR VPWR sky130_fd_sc_hd__decap_8
XTAP_TAPCELL_ROW_122_2008 VGND VPWR sky130_fd_sc_hd__tapvpwrvgnd_1
X_10971_ _03742_ _03842_ _03843_ VGND VGND VPWR VPWR _03844_ sky130_fd_sc_hd__nand3_1
XFILLER_15_125 VGND VGND VPWR VPWR sky130_fd_sc_hd__decap_8
XFILLER_16_626 VGND VGND VPWR VPWR sky130_fd_sc_hd__decap_3
X_12710_ _05726_ _05738_ VGND VGND VPWR VPWR _05739_ sky130_fd_sc_hd__xor2_1
XTAP_TAPCELL_ROW_104_1752 VGND VPWR sky130_fd_sc_hd__tapvpwrvgnd_1
XFILLER_102_50 VGND VGND VPWR VPWR sky130_fd_sc_hd__decap_8
XFILLER_15_136 VGND VGND VPWR VPWR sky130_fd_sc_hd__fill_2
XTAP_TAPCELL_ROW_26_654 VGND VPWR sky130_fd_sc_hd__tapvpwrvgnd_1
XTAP_TAPCELL_ROW_26_665 VGND VPWR sky130_fd_sc_hd__tapvpwrvgnd_1
X_12641_ _05539_ _05541_ _05662_ VGND VGND VPWR VPWR _05663_ sky130_fd_sc_hd__a21oi_1
XFILLER_129_517 VGND VGND VPWR VPWR sky130_fd_sc_hd__decap_6
XFILLER_62_98 VPWR VGND VPWR VGND sky130_ef_sc_hd__decap_12
X_12572_ _05586_ _05587_ VGND VGND VPWR VPWR _05588_ sky130_fd_sc_hd__or2_1
XFILLER_11_375 VPWR VGND VPWR VGND sky130_ef_sc_hd__decap_12
XFILLER_7_27 VPWR VGND VPWR VGND sky130_ef_sc_hd__decap_12
X_11523_ _04208_ _04445_ VGND VGND VPWR VPWR _04446_ sky130_fd_sc_hd__xnor2_2
XFILLER_7_335 VGND VGND VPWR VPWR sky130_fd_sc_hd__fill_1
X_11454_ _04242_ _04248_ _04246_ VGND VGND VPWR VPWR _04371_ sky130_fd_sc_hd__o21a_1
XTAP_TAPCELL_ROW_133_2159 VGND VPWR sky130_fd_sc_hd__tapvpwrvgnd_1
XFILLER_109_252 VPWR VGND VPWR VGND sky130_ef_sc_hd__decap_12
X_10405_ _03185_ _03223_ VGND VGND VPWR VPWR _03225_ sky130_fd_sc_hd__xnor2_2
X_11385_ _04289_ _04294_ VGND VGND VPWR VPWR _04296_ sky130_fd_sc_hd__and2_1
XFILLER_124_266 VGND VGND VPWR VPWR sky130_fd_sc_hd__decap_4
X_10336_ _03147_ _03149_ _03148_ VGND VGND VPWR VPWR _03150_ sky130_fd_sc_hd__and3_1
XFILLER_3_541 VPWR VGND VPWR VGND sky130_ef_sc_hd__decap_12
X_13124_ _06062_ _06065_ _06189_ VGND VGND VPWR VPWR _06191_ sky130_fd_sc_hd__and3_1
XFILLER_124_288 VGND VGND VPWR VPWR sky130_fd_sc_hd__decap_6
X_10267_ _02897_ _02900_ VGND VGND VPWR VPWR _03075_ sky130_fd_sc_hd__or2_1
X_13055_ net404 net581 _05992_ VGND VGND VPWR VPWR _06115_ sky130_fd_sc_hd__a21oi_1
XFILLER_3_585 VPWR VGND VPWR VGND sky130_ef_sc_hd__decap_12
XFILLER_94_802 VGND VGND VPWR VPWR sky130_fd_sc_hd__fill_2
X_12006_ _04968_ _04967_ _04886_ VGND VGND VPWR VPWR _04970_ sky130_fd_sc_hd__o21a_1
XFILLER_120_461 VGND VGND VPWR VPWR sky130_fd_sc_hd__decap_8
XFILLER_66_515 VGND VGND VPWR VPWR sky130_fd_sc_hd__decap_6
X_10198_ net443 net580 VGND VGND VPWR VPWR _03000_ sky130_fd_sc_hd__and2_1
XFILLER_38_217 VGND VGND VPWR VPWR sky130_fd_sc_hd__decap_6
XFILLER_39_729 VGND VGND VPWR VPWR sky130_fd_sc_hd__decap_3
XFILLER_120_494 VGND VGND VPWR VPWR sky130_fd_sc_hd__fill_2
XFILLER_93_323 VGND VGND VPWR VPWR sky130_fd_sc_hd__fill_1
XFILLER_38_239 VPWR VGND VPWR VGND sky130_ef_sc_hd__decap_12
XFILLER_93_389 VGND VGND VPWR VPWR sky130_fd_sc_hd__decap_3
XFILLER_47_762 VGND VGND VPWR VPWR sky130_fd_sc_hd__fill_2
XFILLER_19_464 VPWR VGND VPWR VGND sky130_ef_sc_hd__decap_12
XTAP_TAPCELL_ROW_66_1224 VGND VPWR sky130_fd_sc_hd__tapvpwrvgnd_1
XTAP_TAPCELL_ROW_66_1213 VGND VPWR sky130_fd_sc_hd__tapvpwrvgnd_1
X_12908_ _05661_ _05809_ _05808_ VGND VGND VPWR VPWR _05956_ sky130_fd_sc_hd__a21oi_1
XFILLER_46_272 VGND VGND VPWR VPWR sky130_fd_sc_hd__decap_6
XTAP_TAPCELL_ROW_45_930 VGND VPWR sky130_fd_sc_hd__tapvpwrvgnd_1
XFILLER_61_231 VGND VGND VPWR VPWR sky130_fd_sc_hd__decap_6
X_12839_ _05226_ _05878_ VGND VGND VPWR VPWR _05880_ sky130_fd_sc_hd__xnor2_1
X_08030_ _00765_ _00766_ VGND VGND VPWR VPWR _00767_ sky130_fd_sc_hd__nor2_1
Xinput30 in3[5] VGND VGND VPWR VPWR net30 sky130_fd_sc_hd__clkbuf_1
XFILLER_128_583 VGND VGND VPWR VPWR sky130_fd_sc_hd__decap_4
XFILLER_128_561 VGND VGND VPWR VPWR sky130_fd_sc_hd__decap_6
XFILLER_116_701 VPWR VGND VPWR VGND sky130_ef_sc_hd__decap_12
Xinput41 w00[7] VGND VGND VPWR VPWR net41 sky130_fd_sc_hd__dlymetal6s2s_1
Xinput63 w03[5] VGND VGND VPWR VPWR net63 sky130_fd_sc_hd__clkbuf_2
Xinput52 w02[2] VGND VGND VPWR VPWR net52 sky130_fd_sc_hd__buf_2
Xinput96 w13[6] VGND VGND VPWR VPWR net96 sky130_fd_sc_hd__buf_1
Xinput85 w12[3] VGND VGND VPWR VPWR net85 sky130_fd_sc_hd__dlymetal6s2s_1
Xinput74 w11[0] VGND VGND VPWR VPWR net74 sky130_fd_sc_hd__buf_1
X_09981_ _02762_ _02765_ VGND VGND VPWR VPWR _02766_ sky130_fd_sc_hd__xnor2_1
XTAP_TAPCELL_ROW_77_1375 VGND VPWR sky130_fd_sc_hd__tapvpwrvgnd_1
X_08932_ net439 net552 net551 net448 VGND VGND VPWR VPWR _01658_ sky130_fd_sc_hd__a22o_1
XTAP_TAPCELL_ROW_90_1553 VGND VPWR sky130_fd_sc_hd__tapvpwrvgnd_1
XFILLER_97_673 VGND VGND VPWR VPWR sky130_fd_sc_hd__decap_3
X_08863_ _01589_ _01587_ VGND VGND VPWR VPWR _00060_ sky130_fd_sc_hd__xor2_1
XTAP_TAPCELL_ROW_4_349 VGND VPWR sky130_fd_sc_hd__tapvpwrvgnd_1
XFILLER_123_27 VPWR VGND VPWR VGND sky130_ef_sc_hd__decap_12
X_08794_ net464 net455 net551 net549 VGND VGND VPWR VPWR _01521_ sky130_fd_sc_hd__and4_1
X_07814_ _00377_ _00409_ _00407_ VGND VGND VPWR VPWR _00553_ sky130_fd_sc_hd__a21oi_1
XFILLER_69_397 VGND VGND VPWR VPWR sky130_fd_sc_hd__fill_1
X_07745_ _00333_ _00483_ VGND VGND VPWR VPWR _00484_ sky130_fd_sc_hd__or2_1
XFILLER_84_378 VGND VGND VPWR VPWR sky130_fd_sc_hd__fill_1
XFILLER_84_356 VGND VGND VPWR VPWR sky130_fd_sc_hd__fill_2
XFILLER_72_529 VGND VGND VPWR VPWR sky130_fd_sc_hd__decap_3
XFILLER_16_14 VGND VGND VPWR VPWR sky130_fd_sc_hd__fill_2
X_09415_ _01825_ _02150_ VGND VGND VPWR VPWR _02151_ sky130_fd_sc_hd__xnor2_1
X_07676_ _00257_ _00259_ _00414_ _00415_ VGND VGND VPWR VPWR _00416_ sky130_fd_sc_hd__o211ai_2
XFILLER_52_253 VPWR VGND VPWR VGND sky130_ef_sc_hd__decap_12
XTAP_TAPCELL_ROW_23_613 VGND VPWR sky130_fd_sc_hd__tapvpwrvgnd_1
X_09346_ _01908_ _01910_ _02072_ _02073_ VGND VGND VPWR VPWR _02076_ sky130_fd_sc_hd__o211a_4
XFILLER_12_139 VGND VGND VPWR VPWR sky130_fd_sc_hd__fill_1
X_09277_ _01857_ _01864_ _01863_ VGND VGND VPWR VPWR _02001_ sky130_fd_sc_hd__a21o_1
XFILLER_21_673 VGND VGND VPWR VPWR sky130_fd_sc_hd__decap_4
X_08228_ _00961_ _00962_ VGND VGND VPWR VPWR _00963_ sky130_fd_sc_hd__nor2_1
XFILLER_119_561 VPWR VGND VPWR VGND sky130_ef_sc_hd__decap_12
XFILLER_107_701 VGND VGND VPWR VPWR sky130_fd_sc_hd__decap_8
XFILLER_20_194 VGND VGND VPWR VPWR sky130_fd_sc_hd__fill_2
XFILLER_134_531 VGND VGND VPWR VPWR sky130_fd_sc_hd__fill_1
X_08159_ net303 net546 _02131_ net571 VGND VGND VPWR VPWR _00895_ sky130_fd_sc_hd__o2bb2a_1
XFILLER_107_734 VPWR VGND VPWR VGND sky130_ef_sc_hd__decap_12
XFILLER_79_106 VGND VGND VPWR VPWR sky130_fd_sc_hd__decap_6
X_11170_ _04045_ _04060_ VGND VGND VPWR VPWR _04061_ sky130_fd_sc_hd__xnor2_1
XFILLER_121_225 VPWR VGND VPWR VGND sky130_ef_sc_hd__decap_12
X_10121_ _02882_ _02913_ VGND VGND VPWR VPWR _02915_ sky130_fd_sc_hd__and2_1
XFILLER_121_247 VPWR VGND VPWR VGND sky130_ef_sc_hd__decap_12
X_10052_ _02837_ _02838_ VGND VGND VPWR VPWR _02840_ sky130_fd_sc_hd__xor2_1
XFILLER_0_533 VGND VGND VPWR VPWR sky130_fd_sc_hd__fill_2
XFILLER_130_781 VPWR VGND VPWR VGND sky130_ef_sc_hd__decap_12
XFILLER_75_345 VGND VGND VPWR VPWR sky130_fd_sc_hd__fill_2
XFILLER_28_250 VGND VGND VPWR VPWR sky130_fd_sc_hd__fill_2
XFILLER_35_209 VPWR VGND VPWR VGND sky130_ef_sc_hd__decap_12
XFILLER_44_721 VPWR VGND VPWR VGND sky130_ef_sc_hd__decap_12
XFILLER_16_412 VGND VGND VPWR VPWR sky130_fd_sc_hd__decap_8
XFILLER_44_743 VGND VGND VPWR VPWR sky130_fd_sc_hd__decap_6
X_10954_ _03427_ _03824_ VGND VGND VPWR VPWR _03825_ sky130_fd_sc_hd__nor2_1
XFILLER_71_573 VPWR VGND VPWR VGND sky130_ef_sc_hd__decap_12
XFILLER_43_264 VPWR VGND VPWR VGND sky130_ef_sc_hd__decap_12
XFILLER_16_489 VGND VGND VPWR VPWR sky130_fd_sc_hd__decap_4
X_10885_ _03747_ _03748_ VGND VGND VPWR VPWR _03749_ sky130_fd_sc_hd__xnor2_1
X_12624_ _05542_ _05643_ _05644_ VGND VGND VPWR VPWR _05645_ sky130_fd_sc_hd__nand3_1
XTAP_TAPCELL_ROW_61_1154 VGND VPWR sky130_fd_sc_hd__tapvpwrvgnd_1
XTAP_TAPCELL_ROW_61_1143 VGND VPWR sky130_fd_sc_hd__tapvpwrvgnd_1
XFILLER_11_150 VPWR VGND VPWR VGND sky130_ef_sc_hd__decap_12
X_12555_ _05564_ _05567_ VGND VGND VPWR VPWR _05569_ sky130_fd_sc_hd__xor2_1
X_11506_ _04419_ _04425_ VGND VGND VPWR VPWR _04427_ sky130_fd_sc_hd__xnor2_1
XTAP_TAPCELL_ROW_117_1932 VGND VPWR sky130_fd_sc_hd__tapvpwrvgnd_1
X_12486_ _05490_ _05491_ VGND VGND VPWR VPWR _05493_ sky130_fd_sc_hd__xor2_1
X_11437_ _04339_ _04351_ VGND VGND VPWR VPWR _04353_ sky130_fd_sc_hd__xnor2_1
X_11368_ _04274_ _04275_ VGND VGND VPWR VPWR _04278_ sky130_fd_sc_hd__xor2_1
XFILLER_125_597 VGND VGND VPWR VPWR sky130_fd_sc_hd__decap_3
XFILLER_112_225 VGND VGND VPWR VPWR sky130_fd_sc_hd__decap_6
XFILLER_98_437 VGND VGND VPWR VPWR sky130_fd_sc_hd__fill_1
X_10319_ _03130_ _03131_ VGND VGND VPWR VPWR _03132_ sky130_fd_sc_hd__or2_1
X_13107_ _06044_ _06049_ _06047_ VGND VGND VPWR VPWR _06173_ sky130_fd_sc_hd__o21a_1
XFILLER_3_393 VPWR VGND VPWR VGND sky130_ef_sc_hd__decap_12
X_11299_ _04187_ _04201_ VGND VGND VPWR VPWR _04202_ sky130_fd_sc_hd__xnor2_1
XFILLER_79_673 VGND VGND VPWR VPWR sky130_fd_sc_hd__decap_8
X_13038_ _06094_ _06096_ VGND VGND VPWR VPWR _06097_ sky130_fd_sc_hd__nand2_2
XFILLER_120_291 VPWR VGND VPWR VGND sky130_ef_sc_hd__decap_12
XFILLER_66_345 VPWR VGND VPWR VGND sky130_ef_sc_hd__decap_12
XFILLER_14_3 VPWR VGND VPWR VGND sky130_ef_sc_hd__decap_12
XTAP_TAPCELL_ROW_1_308 VGND VPWR sky130_fd_sc_hd__tapvpwrvgnd_1
X_07530_ _00267_ _00269_ _06664_ VGND VGND VPWR VPWR _00271_ sky130_fd_sc_hd__a21oi_1
XFILLER_19_272 VGND VGND VPWR VPWR sky130_fd_sc_hd__fill_1
X_07461_ net435 net605 net604 net444 VGND VGND VPWR VPWR _00202_ sky130_fd_sc_hd__a22o_1
XFILLER_34_253 VGND VGND VPWR VPWR sky130_fd_sc_hd__decap_4
X_07392_ _06672_ _06673_ _00132_ VGND VGND VPWR VPWR _00133_ sky130_fd_sc_hd__or3_1
X_09200_ _01803_ _01836_ _01835_ VGND VGND VPWR VPWR _01924_ sky130_fd_sc_hd__a21o_1
XPHY_EDGE_ROW_22_Left_159 VGND VGND VPWR VPWR sky130_fd_sc_hd__decap_3
XFILLER_34_297 VGND VGND VPWR VPWR sky130_fd_sc_hd__decap_8
X_09131_ _01853_ _01854_ _01689_ _01691_ VGND VGND VPWR VPWR _01856_ sky130_fd_sc_hd__o211a_1
X_09062_ _01786_ _01780_ VGND VGND VPWR VPWR _01787_ sky130_fd_sc_hd__and2b_1
Xrebuffer218 _04589_ VGND VGND VPWR VPWR net918 sky130_fd_sc_hd__dlygate4sd1_1
XTAP_TAPCELL_ROW_79_1404 VGND VPWR sky130_fd_sc_hd__tapvpwrvgnd_1
Xrebuffer229 net430 VGND VGND VPWR VPWR net929 sky130_fd_sc_hd__dlygate4sd1_1
XFILLER_135_317 VPWR VGND VPWR VGND sky130_ef_sc_hd__decap_12
XFILLER_118_27 VGND VGND VPWR VPWR sky130_fd_sc_hd__fill_1
X_08013_ _00483_ _00666_ _00668_ VGND VGND VPWR VPWR _00750_ sky130_fd_sc_hd__a21o_2
XFILLER_104_715 VPWR VGND VPWR VGND sky130_ef_sc_hd__decap_12
XTAP_TAPCELL_ROW_9_419 VGND VPWR sky130_fd_sc_hd__tapvpwrvgnd_1
XFILLER_103_225 VPWR VGND VPWR VGND sky130_ef_sc_hd__decap_12
XFILLER_134_15 VPWR VGND VPWR VGND sky130_ef_sc_hd__decap_12
X_09964_ _02638_ _02641_ _02640_ VGND VGND VPWR VPWR _02747_ sky130_fd_sc_hd__a21oi_1
XPHY_EDGE_ROW_31_Left_168 VGND VGND VPWR VPWR sky130_fd_sc_hd__decap_3
XFILLER_112_781 VPWR VGND VPWR VGND sky130_ef_sc_hd__decap_12
X_09895_ _02541_ _02570_ _02540_ VGND VGND VPWR VPWR _02673_ sky130_fd_sc_hd__o21ba_1
X_08915_ net487 net631 _01379_ VGND VGND VPWR VPWR _01641_ sky130_fd_sc_hd__and3_1
XFILLER_69_150 VPWR VGND VPWR VGND sky130_ef_sc_hd__decap_12
XFILLER_97_481 VPWR VGND VPWR VGND sky130_ef_sc_hd__decap_12
X_08846_ _01570_ _01571_ _01518_ VGND VGND VPWR VPWR _01573_ sky130_fd_sc_hd__a21o_1
XFILLER_69_194 VPWR VGND VPWR VGND sky130_ef_sc_hd__decap_12
XFILLER_84_131 VGND VGND VPWR VPWR sky130_fd_sc_hd__fill_1
XFILLER_73_805 VGND VGND VPWR VPWR sky130_fd_sc_hd__decap_6
XFILLER_45_518 VGND VGND VPWR VPWR sky130_fd_sc_hd__decap_8
XFILLER_27_35 VPWR VGND VPWR VGND sky130_ef_sc_hd__decap_12
X_08777_ _01502_ _01503_ VGND VGND VPWR VPWR _01504_ sky130_fd_sc_hd__nand2b_1
XFILLER_84_197 VPWR VGND VPWR VGND sky130_ef_sc_hd__decap_12
XFILLER_84_175 VPWR VGND VPWR VGND sky130_ef_sc_hd__decap_12
X_07728_ _00305_ _00315_ _00314_ VGND VGND VPWR VPWR _00467_ sky130_fd_sc_hd__a21o_1
XFILLER_53_551 VGND VGND VPWR VPWR sky130_fd_sc_hd__decap_8
XFILLER_26_743 VGND VGND VPWR VPWR sky130_fd_sc_hd__fill_1
XFILLER_80_370 VPWR VGND VPWR VGND sky130_ef_sc_hd__decap_12
X_07659_ _00397_ _00398_ VGND VGND VPWR VPWR _00399_ sky130_fd_sc_hd__nor2_1
XPHY_EDGE_ROW_40_Left_177 VGND VGND VPWR VPWR sky130_fd_sc_hd__decap_3
XTAP_TAPCELL_ROW_101_1711 VGND VPWR sky130_fd_sc_hd__tapvpwrvgnd_1
X_10670_ net639 net276 _03345_ _03344_ VGND VGND VPWR VPWR _03514_ sky130_fd_sc_hd__a31oi_1
XTAP_TAPCELL_ROW_36_793 VGND VPWR sky130_fd_sc_hd__tapvpwrvgnd_1
X_09329_ _02054_ _02056_ _01888_ net240 VGND VGND VPWR VPWR _02058_ sky130_fd_sc_hd__a211o_1
XFILLER_43_78 VGND VGND VPWR VPWR sky130_fd_sc_hd__decap_4
X_12340_ _05332_ _05333_ VGND VGND VPWR VPWR _05334_ sky130_fd_sc_hd__nand2b_1
X_12271_ net292 net42 net145 VGND VGND VPWR VPWR _05259_ sky130_fd_sc_hd__and3_1
XTAP_TAPCELL_ROW_130_2118 VGND VPWR sky130_fd_sc_hd__tapvpwrvgnd_1
XFILLER_107_553 VGND VGND VPWR VPWR sky130_fd_sc_hd__fill_1
X_11222_ _03917_ _04117_ VGND VGND VPWR VPWR _04118_ sky130_fd_sc_hd__xnor2_1
XFILLER_122_523 VGND VGND VPWR VPWR sky130_fd_sc_hd__decap_8
XTAP_TAPCELL_ROW_112_1862 VGND VPWR sky130_fd_sc_hd__tapvpwrvgnd_1
X_11153_ _03877_ _03880_ _03876_ VGND VGND VPWR VPWR _04042_ sky130_fd_sc_hd__a21oi_1
XFILLER_122_589 VPWR VGND VPWR VGND sky130_ef_sc_hd__decap_12
XFILLER_110_718 VGND VGND VPWR VPWR sky130_fd_sc_hd__decap_3
XFILLER_95_429 VPWR VGND VPWR VGND sky130_ef_sc_hd__decap_12
XFILLER_95_418 VGND VGND VPWR VPWR sky130_fd_sc_hd__decap_4
XFILLER_68_64 VPWR VGND VPWR VGND sky130_ef_sc_hd__decap_12
X_10104_ _02890_ _02895_ VGND VGND VPWR VPWR _02896_ sky130_fd_sc_hd__and2b_1
X_11084_ _03819_ _03830_ _03818_ VGND VGND VPWR VPWR _03967_ sky130_fd_sc_hd__a21bo_1
XFILLER_88_481 VPWR VGND VPWR VGND sky130_ef_sc_hd__decap_12
X_10035_ net697 net52 VGND VGND VPWR VPWR _02821_ sky130_fd_sc_hd__nand2_1
XFILLER_0_385 VGND VGND VPWR VPWR sky130_fd_sc_hd__decap_3
XFILLER_75_186 VGND VGND VPWR VPWR sky130_fd_sc_hd__decap_6
XFILLER_17_710 VGND VGND VPWR VPWR sky130_fd_sc_hd__fill_1
XFILLER_91_657 VGND VGND VPWR VPWR sky130_fd_sc_hd__decap_6
X_11986_ _04945_ _04946_ _04937_ VGND VGND VPWR VPWR _04948_ sky130_fd_sc_hd__a21o_1
XFILLER_16_242 VGND VGND VPWR VPWR sky130_fd_sc_hd__fill_1
X_10937_ _03636_ _03637_ _03635_ VGND VGND VPWR VPWR _03807_ sky130_fd_sc_hd__a21boi_1
XFILLER_32_713 VPWR VGND VPWR VGND sky130_ef_sc_hd__decap_12
XFILLER_90_7 VGND VGND VPWR VPWR sky130_fd_sc_hd__decap_4
XFILLER_16_286 VPWR VGND VPWR VGND sky130_ef_sc_hd__decap_12
X_12607_ _05225_ _05625_ VGND VGND VPWR VPWR _05627_ sky130_fd_sc_hd__nand2_1
X_10868_ _03720_ _03728_ VGND VGND VPWR VPWR _03731_ sky130_fd_sc_hd__xor2_1
XFILLER_129_111 VGND VGND VPWR VPWR sky130_fd_sc_hd__fill_1
XTAP_TAPCELL_ROW_14_487 VGND VPWR sky130_fd_sc_hd__tapvpwrvgnd_1
X_10799_ _03634_ _03652_ _03655_ VGND VGND VPWR VPWR _03656_ sky130_fd_sc_hd__and3_1
X_12538_ net478 net674 net672 net486 VGND VGND VPWR VPWR _05551_ sky130_fd_sc_hd__a22o_1
X_12469_ _05475_ VGND VGND VPWR VPWR _05476_ sky130_fd_sc_hd__inv_2
XFILLER_132_309 VPWR VGND VPWR VGND sky130_ef_sc_hd__decap_12
XFILLER_99_702 VGND VGND VPWR VPWR sky130_fd_sc_hd__decap_3
XTAP_TAPCELL_ROW_74_1334 VGND VPWR sky130_fd_sc_hd__tapvpwrvgnd_1
Xfanout409 net31 VGND VGND VPWR VPWR net409 sky130_fd_sc_hd__buf_2
X_06961_ net667 net317 net307 net688 VGND VGND VPWR VPWR _05101_ sky130_fd_sc_hd__a22oi_1
XFILLER_101_729 VPWR VGND VPWR VGND sky130_ef_sc_hd__decap_12
XFILLER_98_289 VGND VGND VPWR VPWR sky130_fd_sc_hd__decap_4
XFILLER_86_407 VGND VGND VPWR VPWR sky130_fd_sc_hd__fill_1
XFILLER_100_228 VGND VGND VPWR VPWR sky130_fd_sc_hd__decap_6
X_09680_ _02427_ _02438_ VGND VGND VPWR VPWR _02439_ sky130_fd_sc_hd__or2_1
X_08700_ _01407_ _01424_ _01426_ VGND VGND VPWR VPWR _01428_ sky130_fd_sc_hd__or3_4
XFILLER_39_334 VGND VGND VPWR VPWR sky130_fd_sc_hd__fill_2
X_08631_ _01190_ _01195_ VGND VGND VPWR VPWR _01359_ sky130_fd_sc_hd__nor2_1
X_06892_ _02750_ net36 net696 _02739_ VGND VGND VPWR VPWR _04352_ sky130_fd_sc_hd__a31o_1
X_08562_ _01287_ _01252_ _01289_ VGND VGND VPWR VPWR _01291_ sky130_fd_sc_hd__or3_4
X_08493_ _01169_ _01220_ VGND VGND VPWR VPWR _01222_ sky130_fd_sc_hd__nor2_1
XTAP_TAPCELL_ROW_85_1485 VGND VPWR sky130_fd_sc_hd__tapvpwrvgnd_1
X_07513_ _00218_ _00219_ _00251_ net801 VGND VGND VPWR VPWR _00254_ sky130_fd_sc_hd__or4bb_4
XFILLER_81_167 VGND VGND VPWR VPWR sky130_fd_sc_hd__fill_1
XFILLER_35_584 VPWR VGND VPWR VGND sky130_ef_sc_hd__decap_12
X_07444_ _06561_ _00183_ VGND VGND VPWR VPWR _00185_ sky130_fd_sc_hd__xnor2_1
XFILLER_50_543 VGND VGND VPWR VPWR sky130_fd_sc_hd__decap_3
XFILLER_13_15 VPWR VGND VPWR VGND sky130_ef_sc_hd__decap_12
XTAP_TAPCELL_ROW_33_752 VGND VPWR sky130_fd_sc_hd__tapvpwrvgnd_1
XTAP_TAPCELL_ROW_33_763 VGND VPWR sky130_fd_sc_hd__tapvpwrvgnd_1
XFILLER_129_15 VPWR VGND VPWR VGND sky130_ef_sc_hd__decap_12
X_07375_ _06529_ _06544_ _06543_ VGND VGND VPWR VPWR _06665_ sky130_fd_sc_hd__o21ai_1
XFILLER_136_615 VGND VGND VPWR VPWR sky130_fd_sc_hd__fill_1
X_09114_ net438 net448 net550 net548 VGND VGND VPWR VPWR _01839_ sky130_fd_sc_hd__and4_1
XFILLER_135_125 VPWR VGND VPWR VGND sky130_ef_sc_hd__decap_12
X_09045_ _01767_ _01768_ VGND VGND VPWR VPWR _01770_ sky130_fd_sc_hd__xnor2_1
XFILLER_135_169 VPWR VGND VPWR VGND sky130_ef_sc_hd__decap_12
XFILLER_1_105 VGND VGND VPWR VPWR sky130_fd_sc_hd__decap_6
XFILLER_1_149 VPWR VGND VPWR VGND sky130_ef_sc_hd__decap_12
X_09947_ _02728_ _02727_ VGND VGND VPWR VPWR _00056_ sky130_fd_sc_hd__xnor2_1
XFILLER_77_429 VGND VGND VPWR VPWR sky130_fd_sc_hd__decap_3
XFILLER_58_610 VGND VGND VPWR VPWR sky130_fd_sc_hd__fill_1
XFILLER_58_643 VGND VGND VPWR VPWR sky130_fd_sc_hd__fill_1
X_09878_ net407 _02219_ _01649_ VGND VGND VPWR VPWR _02655_ sky130_fd_sc_hd__o21a_1
XFILLER_73_602 VGND VGND VPWR VPWR sky130_fd_sc_hd__decap_8
XFILLER_85_473 VGND VGND VPWR VPWR sky130_fd_sc_hd__decap_8
X_08829_ _01413_ _01415_ _01414_ VGND VGND VPWR VPWR _01556_ sky130_fd_sc_hd__o21bai_1
XFILLER_45_326 VGND VGND VPWR VPWR sky130_fd_sc_hd__decap_3
X_11840_ net438 net600 _04787_ _04788_ VGND VGND VPWR VPWR _04789_ sky130_fd_sc_hd__nand4_2
XFILLER_45_359 VGND VGND VPWR VPWR sky130_fd_sc_hd__decap_4
X_11771_ _04709_ _04712_ VGND VGND VPWR VPWR _04713_ sky130_fd_sc_hd__xor2_1
XFILLER_54_88 VPWR VGND VPWR VGND sky130_ef_sc_hd__decap_12
XFILLER_14_746 VGND VGND VPWR VPWR sky130_fd_sc_hd__decap_8
XFILLER_14_757 VGND VGND VPWR VPWR sky130_fd_sc_hd__decap_8
X_10722_ _02022_ net635 VGND VGND VPWR VPWR _03571_ sky130_fd_sc_hd__and2_1
XFILLER_41_521 VGND VGND VPWR VPWR sky130_fd_sc_hd__fill_2
XFILLER_13_267 VGND VGND VPWR VPWR sky130_fd_sc_hd__fill_1
XFILLER_70_21 VGND VGND VPWR VPWR sky130_fd_sc_hd__decap_6
X_10653_ _03493_ _03494_ VGND VGND VPWR VPWR _03496_ sky130_fd_sc_hd__xor2_1
X_13372_ clknet_3_4__leaf_clk _00005_ _00082_ VGND VGND VPWR VPWR net186 sky130_fd_sc_hd__dfrtp_1
XFILLER_70_54 VGND VGND VPWR VPWR sky130_fd_sc_hd__decap_3
X_10584_ _03386_ _03418_ _03419_ VGND VGND VPWR VPWR _03420_ sky130_fd_sc_hd__and3_1
XTAP_TAPCELL_ROW_11_446 VGND VPWR sky130_fd_sc_hd__tapvpwrvgnd_1
X_12323_ _05313_ _05314_ VGND VGND VPWR VPWR _05315_ sky130_fd_sc_hd__nor2_1
XFILLER_119_81 VPWR VGND VPWR VGND sky130_ef_sc_hd__decap_12
XFILLER_114_309 VGND VGND VPWR VPWR sky130_fd_sc_hd__decap_4
X_12254_ _05236_ _05237_ _05238_ VGND VGND VPWR VPWR _05240_ sky130_fd_sc_hd__a21o_1
X_12185_ net529 net659 _04888_ VGND VGND VPWR VPWR _05164_ sky130_fd_sc_hd__and3_1
X_11205_ _04097_ _04098_ VGND VGND VPWR VPWR _04099_ sky130_fd_sc_hd__xnor2_1
XTAP_TAPCELL_ROW_56_1075 VGND VPWR sky130_fd_sc_hd__tapvpwrvgnd_1
X_11136_ _04021_ _04022_ VGND VGND VPWR VPWR _04023_ sky130_fd_sc_hd__nor2_1
XFILLER_95_62 VGND VGND VPWR VPWR sky130_fd_sc_hd__decap_6
XFILLER_95_51 VGND VGND VPWR VPWR sky130_fd_sc_hd__fill_1
XFILLER_48_131 VGND VGND VPWR VPWR sky130_fd_sc_hd__fill_1
XFILLER_0_193 VGND VGND VPWR VPWR sky130_fd_sc_hd__decap_3
X_11067_ net331 net344 VGND VGND VPWR VPWR _03949_ sky130_fd_sc_hd__nand2_1
XFILLER_37_805 VGND VGND VPWR VPWR sky130_fd_sc_hd__decap_3
XFILLER_91_421 VGND VGND VPWR VPWR sky130_fd_sc_hd__decap_4
X_10018_ _02800_ _02801_ _02803_ VGND VGND VPWR VPWR _02804_ sky130_fd_sc_hd__a21o_1
XFILLER_48_175 VPWR VGND VPWR VGND sky130_ef_sc_hd__decap_12
XFILLER_36_326 VPWR VGND VPWR VGND sky130_ef_sc_hd__decap_12
XFILLER_63_145 VGND VGND VPWR VPWR sky130_fd_sc_hd__decap_8
XTAP_TAPCELL_ROW_19_557 VGND VPWR sky130_fd_sc_hd__tapvpwrvgnd_1
XFILLER_91_465 VGND VGND VPWR VPWR sky130_fd_sc_hd__fill_2
X_11969_ net424 net600 _04761_ VGND VGND VPWR VPWR _04930_ sky130_fd_sc_hd__and3_1
XFILLER_81_3 VGND VGND VPWR VPWR sky130_fd_sc_hd__fill_2
XTAP_TAPCELL_ROW_30_711 VGND VPWR sky130_fd_sc_hd__tapvpwrvgnd_1
XFILLER_32_587 VGND VGND VPWR VPWR sky130_fd_sc_hd__fill_1
X_07160_ _06432_ _06451_ VGND VGND VPWR VPWR _06452_ sky130_fd_sc_hd__xnor2_1
X_07091_ net320 net571 VGND VGND VPWR VPWR _06383_ sky130_fd_sc_hd__nand2_1
XFILLER_9_783 VGND VGND VPWR VPWR sky130_fd_sc_hd__fill_1
XFILLER_8_293 VPWR VGND VPWR VGND sky130_ef_sc_hd__decap_12
XFILLER_133_629 VPWR VGND VPWR VGND sky130_ef_sc_hd__decap_12
XFILLER_126_681 VPWR VGND VPWR VGND sky130_ef_sc_hd__decap_12
XFILLER_117_169 VGND VGND VPWR VPWR sky130_fd_sc_hd__decap_8
XFILLER_132_139 VGND VGND VPWR VPWR sky130_fd_sc_hd__fill_1
XFILLER_99_543 VGND VGND VPWR VPWR sky130_fd_sc_hd__decap_3
XFILLER_101_515 VGND VGND VPWR VPWR sky130_fd_sc_hd__decap_4
X_09801_ _02541_ _02570_ VGND VGND VPWR VPWR _02571_ sky130_fd_sc_hd__xor2_1
XFILLER_86_204 VGND VGND VPWR VPWR sky130_fd_sc_hd__fill_1
XFILLER_5_93 VPWR VGND VPWR VGND sky130_ef_sc_hd__decap_12
X_09732_ _02494_ _02495_ VGND VGND VPWR VPWR _02496_ sky130_fd_sc_hd__nand2_1
XFILLER_115_39 VGND VGND VPWR VPWR sky130_fd_sc_hd__decap_8
XPHY_EDGE_ROW_105_Left_242 VGND VGND VPWR VPWR sky130_fd_sc_hd__decap_3
X_07993_ _00727_ _00728_ VGND VGND VPWR VPWR _00730_ sky130_fd_sc_hd__xor2_1
X_06944_ _04905_ _04872_ _04894_ VGND VGND VPWR VPWR _04916_ sky130_fd_sc_hd__nor3b_4
X_09663_ net479 net626 net625 net487 VGND VGND VPWR VPWR _02420_ sky130_fd_sc_hd__a22oi_1
XTAP_TAPCELL_ROW_87_1514 VGND VPWR sky130_fd_sc_hd__tapvpwrvgnd_1
X_06875_ net695 net514 net385 net383 VGND VGND VPWR VPWR _04166_ sky130_fd_sc_hd__and4_1
XFILLER_67_495 VGND VGND VPWR VPWR sky130_fd_sc_hd__decap_8
XFILLER_55_635 VPWR VGND VPWR VGND sky130_ef_sc_hd__decap_12
XFILLER_27_326 VGND VGND VPWR VPWR sky130_fd_sc_hd__decap_8
XTAP_TAPCELL_ROW_38_822 VGND VPWR sky130_fd_sc_hd__tapvpwrvgnd_1
XFILLER_39_186 VGND VGND VPWR VPWR sky130_fd_sc_hd__fill_1
XFILLER_131_27 VPWR VGND VPWR VGND sky130_ef_sc_hd__decap_12
X_08614_ net669 net259 net257 net692 VGND VGND VPWR VPWR _01342_ sky130_fd_sc_hd__a22oi_1
X_09594_ _02147_ _02154_ _02152_ VGND VGND VPWR VPWR _02346_ sky130_fd_sc_hd__a21oi_1
XFILLER_82_421 VGND VGND VPWR VPWR sky130_fd_sc_hd__decap_4
XFILLER_54_112 VGND VGND VPWR VPWR sky130_fd_sc_hd__decap_3
XFILLER_27_337 VGND VGND VPWR VPWR sky130_fd_sc_hd__fill_2
XTAP_TAPCELL_ROW_38_833 VGND VPWR sky130_fd_sc_hd__tapvpwrvgnd_1
X_08545_ net823 _01272_ _01271_ VGND VGND VPWR VPWR _01274_ sky130_fd_sc_hd__a21oi_1
XFILLER_42_307 VGND VGND VPWR VPWR sky130_fd_sc_hd__fill_1
XFILLER_54_189 VGND VGND VPWR VPWR sky130_fd_sc_hd__decap_6
X_08476_ _01175_ _01204_ VGND VGND VPWR VPWR _01205_ sky130_fd_sc_hd__nand2_1
XFILLER_50_340 VGND VGND VPWR VPWR sky130_fd_sc_hd__decap_8
XFILLER_23_554 VGND VGND VPWR VPWR sky130_fd_sc_hd__decap_6
XPHY_EDGE_ROW_114_Left_251 VGND VGND VPWR VPWR sky130_fd_sc_hd__decap_3
X_07427_ net505 net680 net104 net521 VGND VGND VPWR VPWR _00168_ sky130_fd_sc_hd__a22o_1
XFILLER_23_587 VPWR VGND VPWR VGND sky130_ef_sc_hd__decap_12
XFILLER_109_615 VGND VGND VPWR VPWR sky130_fd_sc_hd__fill_1
X_07358_ _06402_ _06488_ _06487_ VGND VGND VPWR VPWR _06649_ sky130_fd_sc_hd__a21boi_2
XFILLER_10_237 VGND VGND VPWR VPWR sky130_fd_sc_hd__decap_4
XFILLER_7_709 VPWR VGND VPWR VGND sky130_ef_sc_hd__decap_12
XFILLER_136_434 VGND VGND VPWR VPWR sky130_fd_sc_hd__decap_3
XTAP_TAPCELL_ROW_98_1665 VGND VPWR sky130_fd_sc_hd__tapvpwrvgnd_1
XFILLER_108_158 VGND VGND VPWR VPWR sky130_fd_sc_hd__decap_8
X_07289_ _06566_ _06578_ _06579_ VGND VGND VPWR VPWR _06580_ sky130_fd_sc_hd__nand3_1
XFILLER_40_46 VGND VGND VPWR VPWR sky130_fd_sc_hd__fill_2
XFILLER_136_489 VPWR VGND VPWR VGND sky130_ef_sc_hd__decap_12
X_09028_ _01751_ _01752_ VGND VGND VPWR VPWR _01753_ sky130_fd_sc_hd__nor2_1
XPHY_EDGE_ROW_123_Left_260 VGND VGND VPWR VPWR sky130_fd_sc_hd__decap_3
XFILLER_78_705 VGND VGND VPWR VPWR sky130_fd_sc_hd__fill_1
XFILLER_77_204 VGND VGND VPWR VPWR sky130_fd_sc_hd__decap_4
XFILLER_2_469 VGND VGND VPWR VPWR sky130_fd_sc_hd__decap_6
XFILLER_131_161 VGND VGND VPWR VPWR sky130_fd_sc_hd__decap_6
XFILLER_77_237 VGND VGND VPWR VPWR sky130_fd_sc_hd__decap_8
XFILLER_77_215 VGND VGND VPWR VPWR sky130_fd_sc_hd__decap_8
XFILLER_19_805 VGND VGND VPWR VPWR sky130_fd_sc_hd__fill_2
XTAP_TAPCELL_ROW_125_2039 VGND VPWR sky130_fd_sc_hd__tapvpwrvgnd_1
XFILLER_86_771 VGND VGND VPWR VPWR sky130_fd_sc_hd__fill_1
XFILLER_58_484 VGND VGND VPWR VPWR sky130_fd_sc_hd__decap_8
XFILLER_46_635 VGND VGND VPWR VPWR sky130_fd_sc_hd__decap_4
X_12941_ net585 net583 net404 VGND VGND VPWR VPWR _05991_ sky130_fd_sc_hd__o21ai_1
XFILLER_85_281 VPWR VGND VPWR VGND sky130_ef_sc_hd__decap_12
XFILLER_46_657 VPWR VGND VPWR VGND sky130_ef_sc_hd__decap_12
XFILLER_18_348 VGND VGND VPWR VPWR sky130_fd_sc_hd__decap_4
X_12872_ net478 net662 VGND VGND VPWR VPWR _05916_ sky130_fd_sc_hd__nand2_1
XFILLER_60_104 VGND VGND VPWR VPWR sky130_fd_sc_hd__fill_1
X_11823_ net378 net429 net371 net369 VGND VGND VPWR VPWR _04770_ sky130_fd_sc_hd__and4_1
XTAP_TAPCELL_ROW_107_1794 VGND VPWR sky130_fd_sc_hd__tapvpwrvgnd_1
XFILLER_14_521 VGND VGND VPWR VPWR sky130_fd_sc_hd__decap_8
XTAP_TAPCELL_ROW_16_516 VGND VPWR sky130_fd_sc_hd__tapvpwrvgnd_1
X_11754_ _04682_ _04684_ _04683_ VGND VGND VPWR VPWR _04694_ sky130_fd_sc_hd__o21ba_1
XFILLER_41_351 VPWR VGND VPWR VGND sky130_ef_sc_hd__decap_12
XTAP_TAPCELL_ROW_120_1972 VGND VPWR sky130_fd_sc_hd__tapvpwrvgnd_1
X_11685_ _04615_ _04618_ VGND VGND VPWR VPWR _04619_ sky130_fd_sc_hd__xnor2_1
X_10705_ _03550_ _03551_ VGND VGND VPWR VPWR _03552_ sky130_fd_sc_hd__xnor2_1
X_10636_ _03284_ _03304_ _03302_ VGND VGND VPWR VPWR _03477_ sky130_fd_sc_hd__a21boi_1
X_13355_ clknet_3_3__leaf_clk _00007_ _00065_ VGND VGND VPWR VPWR net169 sky130_fd_sc_hd__dfrtp_1
XTAP_TAPCELL_ROW_58_1104 VGND VPWR sky130_fd_sc_hd__tapvpwrvgnd_1
X_10567_ _03397_ _03398_ VGND VGND VPWR VPWR _03402_ sky130_fd_sc_hd__xnor2_1
XFILLER_10_793 VPWR VGND VPWR VGND sky130_ef_sc_hd__decap_12
X_10498_ _03326_ _03177_ _03324_ _03044_ VGND VGND VPWR VPWR _03327_ sky130_fd_sc_hd__and4_1
X_12306_ _05134_ net704 VGND VGND VPWR VPWR _05297_ sky130_fd_sc_hd__xnor2_1
X_13286_ _06362_ _06365_ VGND VGND VPWR VPWR _06366_ sky130_fd_sc_hd__xnor2_1
X_12237_ _05219_ _05220_ VGND VGND VPWR VPWR _05222_ sky130_fd_sc_hd__nand2b_1
XFILLER_69_727 VGND VGND VPWR VPWR sky130_fd_sc_hd__fill_1
X_12168_ _05143_ _05145_ VGND VGND VPWR VPWR _05146_ sky130_fd_sc_hd__and2b_1
XFILLER_110_356 VGND VGND VPWR VPWR sky130_fd_sc_hd__fill_1
X_12099_ _05061_ _05069_ _05070_ VGND VGND VPWR VPWR _05071_ sky130_fd_sc_hd__nand3_1
X_11119_ _04002_ _04004_ VGND VGND VPWR VPWR _04006_ sky130_fd_sc_hd__xnor2_2
XFILLER_49_473 VGND VGND VPWR VPWR sky130_fd_sc_hd__decap_3
Xinput6 in0[5] VGND VGND VPWR VPWR net6 sky130_fd_sc_hd__clkbuf_1
XTAP_TAPCELL_ROW_69_1255 VGND VPWR sky130_fd_sc_hd__tapvpwrvgnd_1
XFILLER_64_421 VGND VGND VPWR VPWR sky130_fd_sc_hd__decap_4
XTAP_TAPCELL_ROW_69_1266 VGND VPWR sky130_fd_sc_hd__tapvpwrvgnd_1
XFILLER_91_295 VPWR VGND VPWR VGND sky130_ef_sc_hd__decap_12
XFILLER_52_649 VGND VGND VPWR VPWR sky130_fd_sc_hd__fill_1
XTAP_TAPCELL_ROW_82_1444 VGND VPWR sky130_fd_sc_hd__tapvpwrvgnd_1
X_08330_ _00945_ _00948_ VGND VGND VPWR VPWR _01064_ sky130_fd_sc_hd__nand2_1
X_08261_ _00994_ _00995_ VGND VGND VPWR VPWR _00996_ sky130_fd_sc_hd__or2_1
XFILLER_32_384 VGND VGND VPWR VPWR sky130_fd_sc_hd__fill_1
X_07212_ _05144_ _06378_ _06502_ VGND VGND VPWR VPWR _06503_ sky130_fd_sc_hd__or3_1
XTAP_TAPCELL_ROW_43_891 VGND VPWR sky130_fd_sc_hd__tapvpwrvgnd_1
X_08192_ _00589_ _00791_ _00789_ VGND VGND VPWR VPWR _00928_ sky130_fd_sc_hd__o21a_1
XFILLER_118_467 VGND VGND VPWR VPWR sky130_fd_sc_hd__fill_1
X_07143_ net452 net606 net604 net461 VGND VGND VPWR VPWR _06435_ sky130_fd_sc_hd__a22o_1
XFILLER_118_489 VPWR VGND VPWR VGND sky130_ef_sc_hd__decap_12
X_07074_ _04123_ _05582_ _05604_ VGND VGND VPWR VPWR _06334_ sky130_fd_sc_hd__o21bai_1
XFILLER_10_27 VGND VGND VPWR VPWR sky130_fd_sc_hd__fill_1
XFILLER_126_27 VGND VGND VPWR VPWR sky130_fd_sc_hd__fill_1
XFILLER_114_651 VGND VGND VPWR VPWR sky130_fd_sc_hd__decap_8
XTAP_TAPCELL_ROW_93_1595 VGND VPWR sky130_fd_sc_hd__tapvpwrvgnd_1
XFILLER_87_557 VGND VGND VPWR VPWR sky130_fd_sc_hd__decap_3
X_07976_ _00508_ _00712_ VGND VGND VPWR VPWR _00713_ sky130_fd_sc_hd__xnor2_1
X_09715_ _02474_ _02475_ VGND VGND VPWR VPWR _02477_ sky130_fd_sc_hd__xor2_1
X_06927_ _04600_ _04643_ _04632_ VGND VGND VPWR VPWR _04730_ sky130_fd_sc_hd__o21ai_1
XFILLER_74_207 VPWR VGND VPWR VGND sky130_ef_sc_hd__decap_12
X_09646_ net550 net548 net406 VGND VGND VPWR VPWR _02402_ sky130_fd_sc_hd__o21ai_1
XFILLER_67_281 VGND VGND VPWR VPWR sky130_fd_sc_hd__decap_4
X_06858_ _03937_ _03970_ VGND VGND VPWR VPWR _03981_ sky130_fd_sc_hd__xnor2_1
XFILLER_83_785 VGND VGND VPWR VPWR sky130_fd_sc_hd__decap_3
XFILLER_28_679 VGND VGND VPWR VPWR sky130_fd_sc_hd__fill_2
X_06789_ _02697_ _03205_ VGND VGND VPWR VPWR _00008_ sky130_fd_sc_hd__xnor2_1
X_09577_ net502 net624 VGND VGND VPWR VPWR _02328_ sky130_fd_sc_hd__and2b_1
X_08528_ net430 net60 VGND VGND VPWR VPWR _01257_ sky130_fd_sc_hd__nand2_1
X_08459_ net692 net261 _01186_ _01187_ VGND VGND VPWR VPWR _01188_ sky130_fd_sc_hd__and4_1
Xclkbuf_3_3__f_clk clknet_0_clk VGND VGND VPWR VPWR clknet_3_3__leaf_clk sky130_fd_sc_hd__clkbuf_16
XFILLER_11_546 VGND VGND VPWR VPWR sky130_fd_sc_hd__fill_1
XPHY_EDGE_ROW_14_Right_14 VGND VGND VPWR VPWR sky130_fd_sc_hd__decap_3
XFILLER_129_3 VPWR VGND VPWR VGND sky130_ef_sc_hd__decap_12
XFILLER_7_539 VGND VGND VPWR VPWR sky130_fd_sc_hd__decap_3
XFILLER_7_517 VGND VGND VPWR VPWR sky130_fd_sc_hd__fill_2
X_11470_ _04260_ _04263_ _04387_ VGND VGND VPWR VPWR _04389_ sky130_fd_sc_hd__and3_1
X_10421_ net482 net655 _03101_ VGND VGND VPWR VPWR _03242_ sky130_fd_sc_hd__nand3_1
XTAP_TAPCELL_ROW_21_585 VGND VPWR sky130_fd_sc_hd__tapvpwrvgnd_1
XFILLER_136_253 VPWR VGND VPWR VGND sky130_ef_sc_hd__decap_12
XTAP_TAPCELL_ROW_135_2190 VGND VPWR sky130_fd_sc_hd__tapvpwrvgnd_1
XFILLER_124_404 VGND VGND VPWR VPWR sky130_fd_sc_hd__fill_2
X_10352_ _03165_ _03166_ net865 _03021_ VGND VGND VPWR VPWR _03168_ sky130_fd_sc_hd__a211oi_4
X_13140_ _06207_ _06208_ VGND VGND VPWR VPWR _06209_ sky130_fd_sc_hd__and2b_1
XFILLER_136_286 VGND VGND VPWR VPWR sky130_fd_sc_hd__decap_4
X_13071_ net660 net658 net478 VGND VGND VPWR VPWR _06133_ sky130_fd_sc_hd__o21ai_1
XFILLER_105_673 VPWR VGND VPWR VGND sky130_ef_sc_hd__decap_12
X_10283_ _03089_ _03090_ _03091_ VGND VGND VPWR VPWR _03092_ sky130_fd_sc_hd__nand3b_1
XFILLER_2_233 VPWR VGND VPWR VGND sky130_ef_sc_hd__decap_12
X_12022_ net665 net640 net296 net294 VGND VGND VPWR VPWR _04987_ sky130_fd_sc_hd__and4_1
XFILLER_104_183 VPWR VGND VPWR VGND sky130_ef_sc_hd__decap_12
XTAP_TAPCELL_ROW_53_1034 VGND VPWR sky130_fd_sc_hd__tapvpwrvgnd_1
XFILLER_2_277 VPWR VGND VPWR VGND sky130_ef_sc_hd__decap_12
XPHY_EDGE_ROW_23_Right_23 VGND VGND VPWR VPWR sky130_fd_sc_hd__decap_3
Xfanout570 net571 VGND VGND VPWR VPWR net570 sky130_fd_sc_hd__clkbuf_2
XFILLER_76_75 VGND VGND VPWR VPWR sky130_fd_sc_hd__fill_2
Xfanout592 net593 VGND VGND VPWR VPWR net592 sky130_fd_sc_hd__clkbuf_2
Xfanout581 net144 VGND VGND VPWR VPWR net581 sky130_fd_sc_hd__buf_2
XTAP_TAPCELL_ROW_109_1823 VGND VPWR sky130_fd_sc_hd__tapvpwrvgnd_1
XFILLER_58_292 VGND VGND VPWR VPWR sky130_fd_sc_hd__fill_1
XFILLER_46_421 VGND VGND VPWR VPWR sky130_fd_sc_hd__decap_8
X_12924_ net315 _05867_ _05748_ VGND VGND VPWR VPWR _05972_ sky130_fd_sc_hd__a21oi_1
XFILLER_18_112 VPWR VGND VPWR VGND sky130_ef_sc_hd__decap_12
X_12855_ _05895_ _05896_ VGND VGND VPWR VPWR _05897_ sky130_fd_sc_hd__xnor2_1
XFILLER_18_189 VGND VGND VPWR VPWR sky130_fd_sc_hd__decap_6
XTAP_TAPCELL_ROW_29_696 VGND VPWR sky130_fd_sc_hd__tapvpwrvgnd_1
X_11806_ _04737_ _04749_ VGND VGND VPWR VPWR _04751_ sky130_fd_sc_hd__xnor2_1
XPHY_EDGE_ROW_32_Right_32 VGND VGND VPWR VPWR sky130_fd_sc_hd__decap_3
X_12786_ _05685_ _05700_ _05699_ VGND VGND VPWR VPWR _05821_ sky130_fd_sc_hd__o21a_1
X_11737_ _04642_ _04674_ VGND VGND VPWR VPWR _04676_ sky130_fd_sc_hd__nor2_1
XTAP_TAPCELL_ROW_64_1185 VGND VPWR sky130_fd_sc_hd__tapvpwrvgnd_1
XFILLER_14_362 VGND VGND VPWR VPWR sky130_fd_sc_hd__fill_2
XTAP_TAPCELL_ROW_64_1196 VGND VPWR sky130_fd_sc_hd__tapvpwrvgnd_1
XFILLER_14_395 VGND VGND VPWR VPWR sky130_fd_sc_hd__decap_3
X_11668_ _04599_ _04601_ VGND VGND VPWR VPWR _04602_ sky130_fd_sc_hd__nand2_1
XTAP_TAPCELL_ROW_40_850 VGND VPWR sky130_fd_sc_hd__tapvpwrvgnd_1
XTAP_TAPCELL_ROW_40_861 VGND VPWR sky130_fd_sc_hd__tapvpwrvgnd_1
X_13407_ clknet_3_7__leaf_clk _00059_ _00117_ VGND VGND VPWR VPWR net221 sky130_fd_sc_hd__dfrtp_1
X_11599_ _04443_ _04463_ _04462_ VGND VGND VPWR VPWR _04529_ sky130_fd_sc_hd__a21oi_1
X_10619_ net286 net352 net153 VGND VGND VPWR VPWR _03459_ sky130_fd_sc_hd__a21oi_1
XFILLER_115_415 VGND VGND VPWR VPWR sky130_fd_sc_hd__decap_8
X_13338_ net398 VGND VGND VPWR VPWR _00112_ sky130_fd_sc_hd__inv_2
XFILLER_115_459 VPWR VGND VPWR VGND sky130_ef_sc_hd__decap_12
XFILLER_130_418 VGND VGND VPWR VPWR sky130_fd_sc_hd__fill_2
XFILLER_44_3 VGND VGND VPWR VPWR sky130_fd_sc_hd__fill_2
X_13269_ _06009_ _06247_ _05918_ VGND VGND VPWR VPWR _06348_ sky130_fd_sc_hd__o21a_1
XPHY_EDGE_ROW_41_Right_41 VGND VGND VPWR VPWR sky130_fd_sc_hd__decap_3
XFILLER_69_524 VPWR VGND VPWR VGND sky130_ef_sc_hd__decap_12
X_07830_ _06662_ _00425_ _00424_ VGND VGND VPWR VPWR _00569_ sky130_fd_sc_hd__a21boi_2
XFILLER_96_343 VPWR VGND VPWR VGND sky130_ef_sc_hd__decap_12
XFILLER_69_546 VGND VGND VPWR VPWR sky130_fd_sc_hd__fill_2
XFILLER_57_708 VPWR VGND VPWR VGND sky130_ef_sc_hd__decap_12
XFILLER_96_365 VGND VGND VPWR VPWR sky130_fd_sc_hd__decap_6
X_07761_ _00493_ _00499_ VGND VGND VPWR VPWR _00500_ sky130_fd_sc_hd__xnor2_1
X_06712_ _02349_ _02360_ _02371_ VGND VGND VPWR VPWR _02392_ sky130_fd_sc_hd__o21ai_1
X_09500_ net572 net255 _02243_ VGND VGND VPWR VPWR _02244_ sky130_fd_sc_hd__a21oi_1
XFILLER_110_197 VGND VGND VPWR VPWR sky130_fd_sc_hd__decap_8
XFILLER_49_281 VPWR VGND VPWR VGND sky130_ef_sc_hd__decap_12
XFILLER_2_83 VGND VGND VPWR VPWR sky130_fd_sc_hd__fill_1
X_07692_ _00279_ _00280_ _00277_ VGND VGND VPWR VPWR _00432_ sky130_fd_sc_hd__o21ba_1
XFILLER_112_29 VPWR VGND VPWR VGND sky130_ef_sc_hd__decap_12
XTAP_TAPCELL_ROW_48_972 VGND VPWR sky130_fd_sc_hd__tapvpwrvgnd_1
XTAP_TAPCELL_ROW_48_961 VGND VPWR sky130_fd_sc_hd__tapvpwrvgnd_1
XFILLER_37_476 VGND VGND VPWR VPWR sky130_fd_sc_hd__fill_1
X_09431_ net336 net326 VGND VGND VPWR VPWR _02169_ sky130_fd_sc_hd__nand2_1
XFILLER_64_284 VGND VGND VPWR VPWR sky130_fd_sc_hd__fill_2
XFILLER_64_273 VGND VGND VPWR VPWR sky130_fd_sc_hd__decap_3
XFILLER_52_424 VPWR VGND VPWR VGND sky130_ef_sc_hd__decap_12
XPHY_EDGE_ROW_50_Right_50 VGND VGND VPWR VPWR sky130_fd_sc_hd__decap_3
X_09362_ net596 net255 VGND VGND VPWR VPWR _02093_ sky130_fd_sc_hd__nand2_1
XFILLER_80_755 VGND VGND VPWR VPWR sky130_fd_sc_hd__fill_1
X_08313_ net249 _00863_ VGND VGND VPWR VPWR _01047_ sky130_fd_sc_hd__xor2_1
X_09293_ _02001_ _02016_ VGND VGND VPWR VPWR _02018_ sky130_fd_sc_hd__xnor2_1
XANTENNA_11 _02109_ VGND VGND VPWR VPWR sky130_fd_sc_hd__diode_2
XANTENNA_22 net89 VGND VGND VPWR VPWR sky130_fd_sc_hd__diode_2
X_08244_ _00874_ _00876_ _00977_ VGND VGND VPWR VPWR _00979_ sky130_fd_sc_hd__nand3_1
XANTENNA_33 net525 VGND VGND VPWR VPWR sky130_fd_sc_hd__diode_2
X_08175_ _00904_ _00909_ VGND VGND VPWR VPWR _00911_ sky130_fd_sc_hd__xor2_1
XFILLER_134_713 VPWR VGND VPWR VGND sky130_ef_sc_hd__decap_12
X_07126_ _06407_ _06417_ VGND VGND VPWR VPWR _06418_ sky130_fd_sc_hd__xnor2_1
XTAP_TAPCELL_ROW_95_1624 VGND VPWR sky130_fd_sc_hd__tapvpwrvgnd_1
XFILLER_134_757 VPWR VGND VPWR VGND sky130_ef_sc_hd__decap_12
XFILLER_97_19 VPWR VGND VPWR VGND sky130_ef_sc_hd__decap_12
XFILLER_133_267 VGND VGND VPWR VPWR sky130_fd_sc_hd__decap_4
XFILLER_121_407 VGND VGND VPWR VPWR sky130_fd_sc_hd__fill_1
XFILLER_106_459 VGND VGND VPWR VPWR sky130_fd_sc_hd__fill_2
X_07057_ _05626_ _06128_ _06117_ VGND VGND VPWR VPWR _06150_ sky130_fd_sc_hd__or3_4
XFILLER_88_800 VGND VGND VPWR VPWR sky130_fd_sc_hd__decap_4
Xoutput173 net173 VGND VGND VPWR VPWR out0[5] sky130_fd_sc_hd__buf_2
Xoutput162 net162 VGND VGND VPWR VPWR out0[0] sky130_fd_sc_hd__buf_2
XFILLER_133_278 VGND VGND VPWR VPWR sky130_fd_sc_hd__fill_2
XFILLER_99_181 VGND VGND VPWR VPWR sky130_fd_sc_hd__decap_3
Xoutput195 net195 VGND VGND VPWR VPWR out2[10] sky130_fd_sc_hd__buf_2
Xoutput184 net184 VGND VGND VPWR VPWR out1[15] sky130_fd_sc_hd__buf_2
XFILLER_48_719 VGND VGND VPWR VPWR sky130_fd_sc_hd__fill_2
X_07959_ _00578_ _00696_ VGND VGND VPWR VPWR _00697_ sky130_fd_sc_hd__xnor2_2
XFILLER_101_197 VPWR VGND VPWR VGND sky130_ef_sc_hd__decap_12
XFILLER_87_398 VGND VGND VPWR VPWR sky130_fd_sc_hd__decap_6
XFILLER_28_421 VGND VGND VPWR VPWR sky130_fd_sc_hd__fill_2
XTAP_TAPCELL_ROW_122_2009 VGND VPWR sky130_fd_sc_hd__tapvpwrvgnd_1
XFILLER_46_67 VPWR VGND VPWR VGND sky130_ef_sc_hd__decap_12
XFILLER_46_56 VGND VGND VPWR VPWR sky130_fd_sc_hd__decap_4
XFILLER_46_45 VGND VGND VPWR VPWR sky130_fd_sc_hd__fill_1
X_10970_ _03840_ _03841_ _03665_ _03667_ VGND VGND VPWR VPWR _03843_ sky130_fd_sc_hd__a211o_1
XFILLER_83_571 VGND VGND VPWR VPWR sky130_fd_sc_hd__fill_1
X_09629_ net358 _02208_ _02292_ _02296_ VGND VGND VPWR VPWR _02384_ sky130_fd_sc_hd__o31ai_1
XFILLER_70_221 VGND VGND VPWR VPWR sky130_fd_sc_hd__decap_3
XTAP_TAPCELL_ROW_26_655 VGND VPWR sky130_fd_sc_hd__tapvpwrvgnd_1
X_12640_ _05318_ _05515_ _05512_ VGND VGND VPWR VPWR _05662_ sky130_fd_sc_hd__a21oi_1
XTAP_TAPCELL_ROW_104_1753 VGND VPWR sky130_fd_sc_hd__tapvpwrvgnd_1
XFILLER_62_22 VGND VGND VPWR VPWR sky130_fd_sc_hd__decap_6
XFILLER_23_192 VPWR VGND VPWR VGND sky130_ef_sc_hd__decap_12
X_12571_ _05584_ _05585_ net449 net582 VGND VGND VPWR VPWR _05587_ sky130_fd_sc_hd__and4bb_1
X_11522_ _02175_ net635 _04335_ VGND VGND VPWR VPWR _04445_ sky130_fd_sc_hd__a21oi_2
XFILLER_11_387 VGND VGND VPWR VPWR sky130_fd_sc_hd__decap_4
XFILLER_7_39 VPWR VGND VPWR VGND sky130_ef_sc_hd__decap_12
X_11453_ _04365_ _04368_ VGND VGND VPWR VPWR _04370_ sky130_fd_sc_hd__xor2_1
XFILLER_109_264 VGND VGND VPWR VPWR sky130_fd_sc_hd__decap_6
X_10404_ _03223_ _03185_ VGND VGND VPWR VPWR _03224_ sky130_fd_sc_hd__and2b_1
X_13123_ _06062_ _06065_ _06189_ VGND VGND VPWR VPWR _06190_ sky130_fd_sc_hd__a21oi_1
X_11384_ _04294_ _04289_ VGND VGND VPWR VPWR _04295_ sky130_fd_sc_hd__nor2_8
X_10335_ _02970_ _02983_ _02982_ VGND VGND VPWR VPWR _03149_ sky130_fd_sc_hd__a21bo_1
XFILLER_3_553 VGND VGND VPWR VPWR sky130_fd_sc_hd__decap_6
XFILLER_127_81 VPWR VGND VPWR VGND sky130_ef_sc_hd__decap_12
XFILLER_87_52 VGND VGND VPWR VPWR sky130_fd_sc_hd__decap_4
X_10266_ _02897_ _02900_ VGND VGND VPWR VPWR _03073_ sky130_fd_sc_hd__nor2_1
X_13054_ _05892_ _05995_ _05785_ VGND VGND VPWR VPWR _06114_ sky130_fd_sc_hd__o21ba_1
XFILLER_3_597 VPWR VGND VPWR VGND sky130_ef_sc_hd__decap_12
XFILLER_78_321 VPWR VGND VPWR VGND sky130_ef_sc_hd__decap_12
X_12005_ _04886_ _04968_ _04967_ VGND VGND VPWR VPWR _04969_ sky130_fd_sc_hd__nor3_4
XFILLER_39_708 VGND VGND VPWR VPWR sky130_fd_sc_hd__decap_8
XFILLER_87_96 VPWR VGND VPWR VGND sky130_ef_sc_hd__decap_12
X_10197_ _02827_ _02991_ net931 VGND VGND VPWR VPWR _02999_ sky130_fd_sc_hd__nand3_2
XTAP_TAPCELL_ROW_6_380 VGND VPWR sky130_fd_sc_hd__tapvpwrvgnd_1
XFILLER_23_8 VGND VGND VPWR VPWR sky130_fd_sc_hd__fill_1
XFILLER_93_357 VGND VGND VPWR VPWR sky130_fd_sc_hd__fill_2
XFILLER_74_571 VPWR VGND VPWR VGND sky130_ef_sc_hd__decap_12
XTAP_TAPCELL_ROW_66_1225 VGND VPWR sky130_fd_sc_hd__tapvpwrvgnd_1
XTAP_TAPCELL_ROW_66_1214 VGND VPWR sky130_fd_sc_hd__tapvpwrvgnd_1
XFILLER_47_785 VGND VGND VPWR VPWR sky130_fd_sc_hd__decap_8
XTAP_TAPCELL_ROW_45_931 VGND VPWR sky130_fd_sc_hd__tapvpwrvgnd_1
XTAP_TAPCELL_ROW_45_920 VGND VPWR sky130_fd_sc_hd__tapvpwrvgnd_1
XFILLER_19_476 VGND VGND VPWR VPWR sky130_fd_sc_hd__decap_8
XFILLER_34_402 VPWR VGND VPWR VGND sky130_ef_sc_hd__decap_12
X_12907_ _05663_ _05953_ VGND VGND VPWR VPWR _05955_ sky130_fd_sc_hd__xnor2_1
XFILLER_61_221 VGND VGND VPWR VPWR sky130_fd_sc_hd__decap_3
X_12838_ _05225_ _05878_ VGND VGND VPWR VPWR _05879_ sky130_fd_sc_hd__nand2_1
XFILLER_61_276 VGND VGND VPWR VPWR sky130_fd_sc_hd__decap_4
X_12769_ _05802_ _05803_ VGND VGND VPWR VPWR _05804_ sky130_fd_sc_hd__and2b_1
Xinput20 in2[3] VGND VGND VPWR VPWR net20 sky130_fd_sc_hd__buf_1
Xinput31 in3[6] VGND VGND VPWR VPWR net31 sky130_fd_sc_hd__clkbuf_4
XFILLER_116_713 VPWR VGND VPWR VGND sky130_ef_sc_hd__decap_12
Xinput64 w03[6] VGND VGND VPWR VPWR net64 sky130_fd_sc_hd__clkbuf_2
Xinput42 w01[0] VGND VGND VPWR VPWR net42 sky130_fd_sc_hd__clkbuf_2
Xinput53 w02[3] VGND VGND VPWR VPWR net53 sky130_fd_sc_hd__buf_1
Xinput97 w13[7] VGND VGND VPWR VPWR net97 sky130_fd_sc_hd__clkbuf_4
Xinput75 w11[1] VGND VGND VPWR VPWR net75 sky130_fd_sc_hd__buf_1
Xinput86 w12[4] VGND VGND VPWR VPWR net86 sky130_fd_sc_hd__dlymetal6s2s_1
XFILLER_116_779 VPWR VGND VPWR VGND sky130_ef_sc_hd__decap_12
X_09980_ _02763_ _02764_ VGND VGND VPWR VPWR _02765_ sky130_fd_sc_hd__xnor2_1
XTAP_TAPCELL_ROW_77_1376 VGND VPWR sky130_fd_sc_hd__tapvpwrvgnd_1
XFILLER_131_727 VGND VGND VPWR VPWR sky130_fd_sc_hd__fill_1
X_08931_ net439 net448 net552 net551 VGND VGND VPWR VPWR _01657_ sky130_fd_sc_hd__nand4_1
XFILLER_130_237 VGND VGND VPWR VPWR sky130_fd_sc_hd__fill_1
X_08862_ _01331_ _01337_ _01449_ _01450_ _01588_ VGND VGND VPWR VPWR _01589_ sky130_fd_sc_hd__a41o_1
XTAP_TAPCELL_ROW_90_1554 VGND VPWR sky130_fd_sc_hd__tapvpwrvgnd_1
XFILLER_96_162 VGND VGND VPWR VPWR sky130_fd_sc_hd__decap_6
X_07813_ _00533_ _00551_ VGND VGND VPWR VPWR _00552_ sky130_fd_sc_hd__xor2_1
XFILLER_123_39 VPWR VGND VPWR VGND sky130_ef_sc_hd__decap_12
X_08793_ net473 net538 VGND VGND VPWR VPWR _01520_ sky130_fd_sc_hd__nand2_1
X_07744_ net684 net682 net477 VGND VGND VPWR VPWR _00483_ sky130_fd_sc_hd__o21ai_1
X_07675_ _00413_ _00412_ _00359_ VGND VGND VPWR VPWR _00415_ sky130_fd_sc_hd__a21o_1
XFILLER_53_711 VGND VGND VPWR VPWR sky130_fd_sc_hd__fill_1
XFILLER_52_210 VGND VGND VPWR VPWR sky130_fd_sc_hd__decap_6
X_09414_ _01649_ _02149_ VGND VGND VPWR VPWR _02150_ sky130_fd_sc_hd__xnor2_1
XFILLER_80_552 VPWR VGND VPWR VGND sky130_ef_sc_hd__decap_12
XFILLER_53_744 VGND VGND VPWR VPWR sky130_fd_sc_hd__fill_1
XFILLER_13_608 VGND VGND VPWR VPWR sky130_fd_sc_hd__decap_8
XFILLER_25_435 VPWR VGND VPWR VGND sky130_ef_sc_hd__decap_12
XFILLER_80_574 VPWR VGND VPWR VGND sky130_ef_sc_hd__decap_12
XFILLER_52_265 VPWR VGND VPWR VGND sky130_ef_sc_hd__decap_12
XTAP_TAPCELL_ROW_23_614 VGND VPWR sky130_fd_sc_hd__tapvpwrvgnd_1
X_09345_ _02072_ _02073_ net886 _01910_ VGND VGND VPWR VPWR _02075_ sky130_fd_sc_hd__a211o_1
X_09276_ _01849_ _01851_ VGND VGND VPWR VPWR _02000_ sky130_fd_sc_hd__nand2_1
X_08227_ _00959_ _00960_ VGND VGND VPWR VPWR _00962_ sky130_fd_sc_hd__and2b_1
XFILLER_119_573 VGND VGND VPWR VPWR sky130_fd_sc_hd__decap_4
X_08158_ net570 net303 net73 net546 VGND VGND VPWR VPWR _00894_ sky130_fd_sc_hd__and4b_1
XFILLER_107_757 VGND VGND VPWR VPWR sky130_fd_sc_hd__fill_1
X_08089_ _00824_ _00825_ VGND VGND VPWR VPWR _00826_ sky130_fd_sc_hd__or2_1
XFILLER_107_779 VGND VGND VPWR VPWR sky130_fd_sc_hd__decap_4
X_07109_ _06400_ _06323_ VGND VGND VPWR VPWR _06401_ sky130_fd_sc_hd__and2b_1
XFILLER_134_587 VGND VGND VPWR VPWR sky130_fd_sc_hd__fill_1
X_10120_ _02882_ _02913_ VGND VGND VPWR VPWR _02914_ sky130_fd_sc_hd__nor2_1
XFILLER_121_259 VPWR VGND VPWR VGND sky130_ef_sc_hd__decap_12
XFILLER_121_237 VGND VGND VPWR VPWR sky130_fd_sc_hd__decap_6
X_10051_ _02837_ _02838_ VGND VGND VPWR VPWR _02839_ sky130_fd_sc_hd__nor2_1
XFILLER_0_545 VGND VGND VPWR VPWR sky130_fd_sc_hd__decap_4
XFILLER_0_567 VPWR VGND VPWR VGND sky130_ef_sc_hd__decap_12
XFILLER_0_589 VPWR VGND VPWR VGND sky130_ef_sc_hd__decap_12
XFILLER_130_793 VPWR VGND VPWR VGND sky130_ef_sc_hd__decap_12
XFILLER_75_335 VGND VGND VPWR VPWR sky130_fd_sc_hd__fill_1
XFILLER_63_508 VGND VGND VPWR VPWR sky130_fd_sc_hd__fill_2
XFILLER_56_593 VGND VGND VPWR VPWR sky130_fd_sc_hd__decap_4
XFILLER_44_733 VGND VGND VPWR VPWR sky130_fd_sc_hd__decap_6
X_10953_ _03822_ _03823_ VGND VGND VPWR VPWR _03824_ sky130_fd_sc_hd__xnor2_1
XFILLER_29_785 VPWR VGND VPWR VGND sky130_ef_sc_hd__decap_12
XFILLER_113_94 VGND VGND VPWR VPWR sky130_fd_sc_hd__decap_6
XFILLER_73_43 VPWR VGND VPWR VGND sky130_ef_sc_hd__decap_12
XFILLER_71_585 VGND VGND VPWR VPWR sky130_fd_sc_hd__decap_4
XFILLER_43_276 VGND VGND VPWR VPWR sky130_fd_sc_hd__fill_1
X_10884_ _02044_ net635 VGND VGND VPWR VPWR _03748_ sky130_fd_sc_hd__and2_1
XFILLER_71_596 VGND VGND VPWR VPWR sky130_fd_sc_hd__fill_2
XFILLER_12_630 VGND VGND VPWR VPWR sky130_fd_sc_hd__fill_2
XFILLER_31_449 VPWR VGND VPWR VGND sky130_ef_sc_hd__decap_12
X_12623_ _05641_ _05642_ _05464_ _05466_ VGND VGND VPWR VPWR _05644_ sky130_fd_sc_hd__a211o_1
XTAP_TAPCELL_ROW_61_1155 VGND VPWR sky130_fd_sc_hd__tapvpwrvgnd_1
XTAP_TAPCELL_ROW_61_1144 VGND VPWR sky130_fd_sc_hd__tapvpwrvgnd_1
X_12554_ _05564_ _05567_ VGND VGND VPWR VPWR _05568_ sky130_fd_sc_hd__and2_1
XFILLER_129_337 VGND VGND VPWR VPWR sky130_fd_sc_hd__fill_2
XFILLER_11_162 VGND VGND VPWR VPWR sky130_fd_sc_hd__fill_1
X_11505_ _04419_ _04425_ VGND VGND VPWR VPWR _04426_ sky130_fd_sc_hd__nand2b_1
XFILLER_8_645 VGND VGND VPWR VPWR sky130_fd_sc_hd__decap_8
XTAP_TAPCELL_ROW_117_1933 VGND VPWR sky130_fd_sc_hd__tapvpwrvgnd_1
X_12485_ _05490_ _05491_ VGND VGND VPWR VPWR _05492_ sky130_fd_sc_hd__nor2_1
XFILLER_125_510 VGND VGND VPWR VPWR sky130_fd_sc_hd__decap_3
X_11436_ _04348_ _04349_ VGND VGND VPWR VPWR _04351_ sky130_fd_sc_hd__xor2_1
X_11367_ _04274_ _04275_ VGND VGND VPWR VPWR _04277_ sky130_fd_sc_hd__and2b_1
X_10318_ net417 net579 _02968_ VGND VGND VPWR VPWR _03131_ sky130_fd_sc_hd__a21oi_1
XFILLER_3_361 VPWR VGND VPWR VGND sky130_ef_sc_hd__decap_12
X_13106_ _06166_ _06169_ VGND VGND VPWR VPWR _06171_ sky130_fd_sc_hd__xor2_1
X_13037_ net244 _05745_ _05966_ VGND VGND VPWR VPWR _06096_ sky130_fd_sc_hd__or3_1
X_11298_ _04189_ _04198_ VGND VGND VPWR VPWR _04201_ sky130_fd_sc_hd__xnor2_1
X_10249_ _02869_ _03054_ _03052_ VGND VGND VPWR VPWR _03056_ sky130_fd_sc_hd__o21bai_4
XFILLER_39_505 VGND VGND VPWR VPWR sky130_fd_sc_hd__decap_4
XFILLER_94_622 VGND VGND VPWR VPWR sky130_fd_sc_hd__decap_8
XFILLER_78_173 VGND VGND VPWR VPWR sky130_fd_sc_hd__fill_2
XFILLER_66_357 VGND VGND VPWR VPWR sky130_fd_sc_hd__decap_6
XTAP_TAPCELL_ROW_1_309 VGND VPWR sky130_fd_sc_hd__tapvpwrvgnd_1
XFILLER_94_699 VGND VGND VPWR VPWR sky130_fd_sc_hd__fill_1
XFILLER_93_176 VGND VGND VPWR VPWR sky130_fd_sc_hd__decap_8
XFILLER_47_593 VGND VGND VPWR VPWR sky130_fd_sc_hd__decap_8
X_07460_ net435 net444 net605 net604 VGND VGND VPWR VPWR _00201_ sky130_fd_sc_hd__and4_1
XFILLER_62_574 VGND VGND VPWR VPWR sky130_fd_sc_hd__decap_4
X_07391_ _00129_ _00130_ VGND VGND VPWR VPWR _00132_ sky130_fd_sc_hd__xnor2_1
X_09130_ _01689_ _01691_ _01853_ _01854_ VGND VGND VPWR VPWR _01855_ sky130_fd_sc_hd__a211oi_2
X_09061_ net572 _01785_ _01784_ VGND VGND VPWR VPWR _01786_ sky130_fd_sc_hd__a21bo_1
XTAP_TAPCELL_ROW_79_1405 VGND VPWR sky130_fd_sc_hd__tapvpwrvgnd_1
Xrebuffer219 _04374_ VGND VGND VPWR VPWR net919 sky130_fd_sc_hd__buf_2
X_08012_ _00641_ _00652_ _00651_ VGND VGND VPWR VPWR _00749_ sky130_fd_sc_hd__a21bo_1
XFILLER_135_329 VGND VGND VPWR VPWR sky130_fd_sc_hd__decap_6
XFILLER_116_565 VPWR VGND VPWR VGND sky130_ef_sc_hd__decap_12
XFILLER_104_727 VGND VGND VPWR VPWR sky130_fd_sc_hd__decap_4
X_09963_ _02741_ _02745_ VGND VGND VPWR VPWR _02746_ sky130_fd_sc_hd__xnor2_1
XPHY_EDGE_ROW_4_Right_4 VGND VGND VPWR VPWR sky130_fd_sc_hd__decap_3
XFILLER_89_449 VPWR VGND VPWR VGND sky130_ef_sc_hd__decap_12
X_08914_ _01519_ _01537_ _01536_ VGND VGND VPWR VPWR _01640_ sky130_fd_sc_hd__o21bai_1
XFILLER_134_27 VGND VGND VPWR VPWR sky130_fd_sc_hd__fill_1
X_09894_ _02649_ _02671_ VGND VGND VPWR VPWR _02672_ sky130_fd_sc_hd__xor2_2
XFILLER_69_162 VGND VGND VPWR VPWR sky130_fd_sc_hd__decap_6
XFILLER_69_140 VGND VGND VPWR VPWR sky130_fd_sc_hd__decap_4
XFILLER_112_793 VPWR VGND VPWR VGND sky130_ef_sc_hd__decap_12
XFILLER_111_281 VPWR VGND VPWR VGND sky130_ef_sc_hd__decap_12
XFILLER_97_493 VGND VGND VPWR VPWR sky130_fd_sc_hd__decap_8
X_08845_ _01518_ _01570_ _01571_ VGND VGND VPWR VPWR _01572_ sky130_fd_sc_hd__nand3_1
XFILLER_57_335 VGND VGND VPWR VPWR sky130_fd_sc_hd__fill_1
X_08776_ _01499_ _01500_ _01501_ VGND VGND VPWR VPWR _01503_ sky130_fd_sc_hd__a21o_1
X_07727_ _00456_ _00465_ VGND VGND VPWR VPWR _00466_ sky130_fd_sc_hd__xor2_1
XFILLER_84_187 VGND VGND VPWR VPWR sky130_fd_sc_hd__decap_8
XFILLER_27_47 VGND VGND VPWR VPWR sky130_fd_sc_hd__decap_4
XFILLER_25_232 VGND VGND VPWR VPWR sky130_fd_sc_hd__fill_1
X_07658_ net425 net41 VGND VGND VPWR VPWR _00398_ sky130_fd_sc_hd__nand2b_1
XFILLER_41_703 VGND VGND VPWR VPWR sky130_fd_sc_hd__decap_4
X_07589_ net497 net679 net104 net505 VGND VGND VPWR VPWR _00329_ sky130_fd_sc_hd__a22o_1
XTAP_TAPCELL_ROW_101_1712 VGND VPWR sky130_fd_sc_hd__tapvpwrvgnd_1
XFILLER_80_382 VGND VGND VPWR VPWR sky130_fd_sc_hd__fill_2
XFILLER_13_449 VGND VGND VPWR VPWR sky130_fd_sc_hd__decap_8
XTAP_TAPCELL_ROW_36_794 VGND VPWR sky130_fd_sc_hd__tapvpwrvgnd_1
XFILLER_40_213 VGND VGND VPWR VPWR sky130_fd_sc_hd__fill_1
XFILLER_41_736 VPWR VGND VPWR VGND sky130_ef_sc_hd__decap_12
X_09328_ _01888_ net240 _02054_ _02056_ VGND VGND VPWR VPWR _02057_ sky130_fd_sc_hd__o211ai_2
XFILLER_43_57 VGND VGND VPWR VPWR sky130_fd_sc_hd__fill_1
X_09259_ _01972_ _01982_ VGND VGND VPWR VPWR _01983_ sky130_fd_sc_hd__xnor2_1
XTAP_TAPCELL_ROW_130_2108 VGND VPWR sky130_fd_sc_hd__tapvpwrvgnd_1
XFILLER_111_3 VPWR VGND VPWR VGND sky130_ef_sc_hd__decap_12
Xclone89 net431 VGND VGND VPWR VPWR net789 sky130_fd_sc_hd__clkbuf_1
XFILLER_5_615 VGND VGND VPWR VPWR sky130_fd_sc_hd__fill_1
X_12270_ net292 net42 net145 VGND VGND VPWR VPWR _05258_ sky130_fd_sc_hd__a21oi_1
XTAP_TAPCELL_ROW_130_2119 VGND VPWR sky130_fd_sc_hd__tapvpwrvgnd_1
X_11221_ net475 net649 VGND VGND VPWR VPWR _04117_ sky130_fd_sc_hd__nand2_1
XFILLER_4_29 VPWR VGND VPWR VGND sky130_ef_sc_hd__decap_12
X_11152_ _04034_ _04039_ VGND VGND VPWR VPWR _04041_ sky130_fd_sc_hd__xnor2_1
XTAP_TAPCELL_ROW_112_1863 VGND VPWR sky130_fd_sc_hd__tapvpwrvgnd_1
XFILLER_108_83 VGND VGND VPWR VPWR sky130_fd_sc_hd__fill_1
X_10103_ _02891_ _02894_ VGND VGND VPWR VPWR _02895_ sky130_fd_sc_hd__xnor2_1
XFILLER_122_579 VGND VGND VPWR VPWR sky130_fd_sc_hd__decap_8
X_11083_ _03954_ _03965_ VGND VGND VPWR VPWR _03966_ sky130_fd_sc_hd__xnor2_2
XFILLER_88_493 VGND VGND VPWR VPWR sky130_fd_sc_hd__decap_4
X_10034_ _02819_ _02820_ VGND VGND VPWR VPWR _00001_ sky130_fd_sc_hd__nor2_1
XFILLER_84_42 VGND VGND VPWR VPWR sky130_fd_sc_hd__decap_8
XFILLER_76_699 VGND VGND VPWR VPWR sky130_fd_sc_hd__fill_1
X_11985_ _04937_ _04945_ _04946_ VGND VGND VPWR VPWR _04947_ sky130_fd_sc_hd__nand3_1
X_10936_ _03803_ _03804_ VGND VGND VPWR VPWR _03805_ sky130_fd_sc_hd__xnor2_1
XFILLER_32_725 VGND VGND VPWR VPWR sky130_fd_sc_hd__fill_1
XFILLER_16_276 VGND VGND VPWR VPWR sky130_fd_sc_hd__fill_1
XFILLER_16_298 VGND VGND VPWR VPWR sky130_fd_sc_hd__decap_8
X_10867_ _03720_ _03728_ VGND VGND VPWR VPWR _03730_ sky130_fd_sc_hd__nor2_1
X_12606_ _05623_ _05624_ VGND VGND VPWR VPWR _05625_ sky130_fd_sc_hd__xnor2_1
XFILLER_31_268 VGND VGND VPWR VPWR sky130_fd_sc_hd__decap_3
XTAP_TAPCELL_ROW_14_488 VGND VPWR sky130_fd_sc_hd__tapvpwrvgnd_1
X_10798_ _03649_ _03650_ _03651_ VGND VGND VPWR VPWR _03655_ sky130_fd_sc_hd__a21o_1
XFILLER_129_167 VGND VGND VPWR VPWR sky130_fd_sc_hd__fill_1
X_12537_ _05547_ _05548_ VGND VGND VPWR VPWR _05550_ sky130_fd_sc_hd__xnor2_1
XFILLER_117_329 VGND VGND VPWR VPWR sky130_fd_sc_hd__fill_1
X_12468_ _05289_ _05291_ _05472_ _05474_ VGND VGND VPWR VPWR _05475_ sky130_fd_sc_hd__o211ai_2
X_11419_ _04197_ _04200_ VGND VGND VPWR VPWR _04333_ sky130_fd_sc_hd__nand2_1
XFILLER_99_725 VGND VGND VPWR VPWR sky130_fd_sc_hd__decap_3
XTAP_TAPCELL_ROW_74_1335 VGND VPWR sky130_fd_sc_hd__tapvpwrvgnd_1
XTAP_TAPCELL_ROW_74_1324 VGND VPWR sky130_fd_sc_hd__tapvpwrvgnd_1
X_12399_ _05381_ _05398_ VGND VGND VPWR VPWR _05399_ sky130_fd_sc_hd__xnor2_1
XFILLER_4_681 VPWR VGND VPWR VGND sky130_ef_sc_hd__decap_12
X_06960_ net688 net667 net317 net307 VGND VGND VPWR VPWR _05090_ sky130_fd_sc_hd__and4_1
X_06891_ _04308_ _04319_ _04188_ VGND VGND VPWR VPWR _04341_ sky130_fd_sc_hd__a21o_1
XFILLER_39_324 VGND VGND VPWR VPWR sky130_fd_sc_hd__decap_3
X_08630_ _01216_ _01357_ VGND VGND VPWR VPWR _01358_ sky130_fd_sc_hd__xor2_1
XFILLER_94_452 VPWR VGND VPWR VGND sky130_ef_sc_hd__decap_12
XFILLER_81_113 VGND VGND VPWR VPWR sky130_fd_sc_hd__decap_8
X_08561_ _01252_ _01287_ _01289_ VGND VGND VPWR VPWR _01290_ sky130_fd_sc_hd__nor3_2
XFILLER_81_135 VPWR VGND VPWR VGND sky130_ef_sc_hd__decap_12
XFILLER_35_541 VGND VGND VPWR VPWR sky130_fd_sc_hd__fill_2
XFILLER_120_29 VPWR VGND VPWR VGND sky130_ef_sc_hd__decap_12
X_08492_ _01220_ VGND VGND VPWR VPWR _01221_ sky130_fd_sc_hd__inv_2
X_07512_ _00218_ _00219_ _00251_ _00252_ VGND VGND VPWR VPWR _00253_ sky130_fd_sc_hd__and4bb_1
XFILLER_23_714 VPWR VGND VPWR VGND sky130_ef_sc_hd__decap_12
X_07443_ _02164_ _06561_ VGND VGND VPWR VPWR _00184_ sky130_fd_sc_hd__or2_2
XTAP_TAPCELL_ROW_85_1486 VGND VPWR sky130_fd_sc_hd__tapvpwrvgnd_1
XFILLER_35_596 VGND VGND VPWR VPWR sky130_fd_sc_hd__decap_4
XFILLER_22_268 VPWR VGND VPWR VGND sky130_ef_sc_hd__decap_12
XTAP_TAPCELL_ROW_33_753 VGND VPWR sky130_fd_sc_hd__tapvpwrvgnd_1
X_07374_ _06662_ _06663_ VGND VGND VPWR VPWR _06664_ sky130_fd_sc_hd__nor2_1
X_09113_ _01542_ _01703_ _01702_ VGND VGND VPWR VPWR _01838_ sky130_fd_sc_hd__a21o_1
XFILLER_13_27 VGND VGND VPWR VPWR sky130_fd_sc_hd__decap_4
XFILLER_129_27 VPWR VGND VPWR VGND sky130_ef_sc_hd__decap_12
XFILLER_108_307 VGND VGND VPWR VPWR sky130_fd_sc_hd__fill_1
X_09044_ _01767_ _01768_ VGND VGND VPWR VPWR _01769_ sky130_fd_sc_hd__nand2_1
XFILLER_135_137 VPWR VGND VPWR VGND sky130_ef_sc_hd__decap_12
XFILLER_89_213 VGND VGND VPWR VPWR sky130_fd_sc_hd__decap_8
X_09946_ _02498_ _02625_ _02506_ _02626_ VGND VGND VPWR VPWR _02728_ sky130_fd_sc_hd__o31a_1
XFILLER_104_579 VGND VGND VPWR VPWR sky130_fd_sc_hd__fill_1
X_09877_ _02310_ _02405_ VGND VGND VPWR VPWR _02654_ sky130_fd_sc_hd__or2_1
XFILLER_57_143 VGND VGND VPWR VPWR sky130_fd_sc_hd__fill_2
XFILLER_38_46 VPWR VGND VPWR VGND sky130_ef_sc_hd__decap_12
XTAP_TAPCELL_ROW_127_2070 VGND VPWR sky130_fd_sc_hd__tapvpwrvgnd_1
XPHY_EDGE_ROW_79_Right_79 VGND VGND VPWR VPWR sky130_fd_sc_hd__decap_3
XFILLER_73_625 VPWR VGND VPWR VGND sky130_ef_sc_hd__decap_12
X_08828_ _01552_ _01553_ _01551_ VGND VGND VPWR VPWR _01555_ sky130_fd_sc_hd__o21ai_1
XFILLER_72_113 VGND VGND VPWR VPWR sky130_fd_sc_hd__decap_4
XFILLER_58_699 VGND VGND VPWR VPWR sky130_fd_sc_hd__fill_1
X_08759_ _01468_ _01485_ VGND VGND VPWR VPWR _01486_ sky130_fd_sc_hd__xor2_1
XFILLER_26_530 VGND VGND VPWR VPWR sky130_fd_sc_hd__fill_2
X_11770_ net271 net297 _04711_ VGND VGND VPWR VPWR _04712_ sky130_fd_sc_hd__nand3_1
XFILLER_41_500 VGND VGND VPWR VPWR sky130_fd_sc_hd__decap_4
XFILLER_53_393 VGND VGND VPWR VPWR sky130_fd_sc_hd__decap_8
XFILLER_13_202 VGND VGND VPWR VPWR sky130_fd_sc_hd__fill_1
X_10721_ _03568_ _03569_ VGND VGND VPWR VPWR _03570_ sky130_fd_sc_hd__nand2b_1
X_10652_ _03493_ _03494_ VGND VGND VPWR VPWR _03495_ sky130_fd_sc_hd__or2_1
XFILLER_41_599 VPWR VGND VPWR VGND sky130_ef_sc_hd__decap_12
X_13371_ clknet_3_4__leaf_clk _00004_ _00081_ VGND VGND VPWR VPWR net185 sky130_fd_sc_hd__dfrtp_1
X_10583_ _03416_ _03417_ _03403_ VGND VGND VPWR VPWR _03419_ sky130_fd_sc_hd__a21o_1
XTAP_TAPCELL_ROW_11_447 VGND VPWR sky130_fd_sc_hd__tapvpwrvgnd_1
XFILLER_21_290 VPWR VGND VPWR VGND sky130_ef_sc_hd__decap_12
XPHY_EDGE_ROW_88_Right_88 VGND VGND VPWR VPWR sky130_fd_sc_hd__decap_3
X_12322_ _05138_ _05140_ _05137_ VGND VGND VPWR VPWR _05314_ sky130_fd_sc_hd__a21oi_1
XFILLER_126_148 VGND VGND VPWR VPWR sky130_fd_sc_hd__fill_2
X_12253_ _05236_ _05237_ _05238_ VGND VGND VPWR VPWR _05239_ sky130_fd_sc_hd__nand3_2
XFILLER_135_671 VGND VGND VPWR VPWR sky130_fd_sc_hd__fill_1
XFILLER_119_93 VPWR VGND VPWR VGND sky130_ef_sc_hd__decap_12
XFILLER_107_373 VGND VGND VPWR VPWR sky130_fd_sc_hd__fill_1
X_11204_ net416 net559 VGND VGND VPWR VPWR _04098_ sky130_fd_sc_hd__nand2_1
X_12184_ net618 net298 _05006_ _05005_ VGND VGND VPWR VPWR _05163_ sky130_fd_sc_hd__a31o_1
XFILLER_122_343 VGND VGND VPWR VPWR sky130_fd_sc_hd__decap_8
XFILLER_96_728 VGND VGND VPWR VPWR sky130_fd_sc_hd__fill_2
XTAP_TAPCELL_ROW_56_1076 VGND VPWR sky130_fd_sc_hd__tapvpwrvgnd_1
X_11135_ _03903_ _03906_ _04020_ VGND VGND VPWR VPWR _04022_ sky130_fd_sc_hd__and3_1
XFILLER_135_81 VPWR VGND VPWR VGND sky130_ef_sc_hd__decap_12
XFILLER_95_238 VGND VGND VPWR VPWR sky130_fd_sc_hd__decap_3
XFILLER_1_673 VPWR VGND VPWR VGND sky130_ef_sc_hd__decap_12
X_11066_ net308 _03946_ _03945_ VGND VGND VPWR VPWR _03947_ sky130_fd_sc_hd__a21oi_2
XPHY_EDGE_ROW_97_Right_97 VGND VGND VPWR VPWR sky130_fd_sc_hd__decap_3
XFILLER_95_74 VPWR VGND VPWR VGND sky130_ef_sc_hd__decap_12
XFILLER_76_441 VGND VGND VPWR VPWR sky130_fd_sc_hd__fill_1
X_10017_ net531 net526 net656 net654 VGND VGND VPWR VPWR _02803_ sky130_fd_sc_hd__and4_1
XFILLER_36_305 VGND VGND VPWR VPWR sky130_fd_sc_hd__decap_3
XFILLER_91_444 VGND VGND VPWR VPWR sky130_fd_sc_hd__decap_4
XFILLER_63_113 VGND VGND VPWR VPWR sky130_fd_sc_hd__fill_2
XFILLER_36_338 VGND VGND VPWR VPWR sky130_fd_sc_hd__fill_2
XFILLER_36_349 VGND VGND VPWR VPWR sky130_fd_sc_hd__decap_6
XTAP_TAPCELL_ROW_19_558 VGND VPWR sky130_fd_sc_hd__tapvpwrvgnd_1
X_11968_ _04748_ _04750_ _04926_ VGND VGND VPWR VPWR _04929_ sky130_fd_sc_hd__nor3_1
X_11899_ _04847_ _04853_ VGND VGND VPWR VPWR _00032_ sky130_fd_sc_hd__xor2_1
X_10919_ _03785_ _03786_ VGND VGND VPWR VPWR _03787_ sky130_fd_sc_hd__or2_1
XFILLER_20_728 VGND VGND VPWR VPWR sky130_fd_sc_hd__fill_2
XTAP_TAPCELL_ROW_30_712 VGND VPWR sky130_fd_sc_hd__tapvpwrvgnd_1
XFILLER_74_3 VGND VGND VPWR VPWR sky130_fd_sc_hd__fill_2
XFILLER_117_126 VGND VGND VPWR VPWR sky130_fd_sc_hd__decap_8
X_07090_ net533 net680 _05473_ _05462_ VGND VGND VPWR VPWR _06382_ sky130_fd_sc_hd__a31o_1
XFILLER_126_693 VGND VGND VPWR VPWR sky130_fd_sc_hd__decap_6
XFILLER_125_192 VGND VGND VPWR VPWR sky130_fd_sc_hd__fill_1
XFILLER_125_181 VGND VGND VPWR VPWR sky130_fd_sc_hd__decap_3
XFILLER_113_343 VGND VGND VPWR VPWR sky130_fd_sc_hd__fill_1
X_09800_ _02542_ _02569_ VGND VGND VPWR VPWR _02570_ sky130_fd_sc_hd__xnor2_1
X_07992_ _00727_ _00728_ VGND VGND VPWR VPWR _00729_ sky130_fd_sc_hd__and2b_1
X_09731_ _02236_ _02493_ VGND VGND VPWR VPWR _02495_ sky130_fd_sc_hd__or2_1
XFILLER_101_527 VGND VGND VPWR VPWR sky130_fd_sc_hd__decap_8
X_06943_ _04796_ _04851_ _04861_ VGND VGND VPWR VPWR _04905_ sky130_fd_sc_hd__a21oi_2
XFILLER_67_441 VGND VGND VPWR VPWR sky130_fd_sc_hd__fill_2
X_09662_ _02136_ _02331_ _02333_ VGND VGND VPWR VPWR _02419_ sky130_fd_sc_hd__a21oi_4
XTAP_TAPCELL_ROW_87_1515 VGND VPWR sky130_fd_sc_hd__tapvpwrvgnd_1
X_06874_ net696 net385 VGND VGND VPWR VPWR _04156_ sky130_fd_sc_hd__nand2_1
XFILLER_55_614 VGND VGND VPWR VPWR sky130_fd_sc_hd__fill_2
XFILLER_39_176 VGND VGND VPWR VPWR sky130_fd_sc_hd__decap_4
XFILLER_131_39 VPWR VGND VPWR VGND sky130_ef_sc_hd__decap_12
X_08613_ net692 net669 net259 net257 VGND VGND VPWR VPWR _01341_ sky130_fd_sc_hd__and4_1
XFILLER_94_282 VPWR VGND VPWR VGND sky130_ef_sc_hd__decap_12
X_09593_ _02337_ _02344_ VGND VGND VPWR VPWR _02345_ sky130_fd_sc_hd__xnor2_1
XFILLER_55_647 VPWR VGND VPWR VGND sky130_ef_sc_hd__decap_12
XFILLER_43_809 VGND VGND VPWR VPWR sky130_fd_sc_hd__fill_2
XTAP_TAPCELL_ROW_38_823 VGND VPWR sky130_fd_sc_hd__tapvpwrvgnd_1
XFILLER_82_477 VGND VGND VPWR VPWR sky130_fd_sc_hd__decap_8
X_08544_ _01271_ _01265_ _01272_ VGND VGND VPWR VPWR _01273_ sky130_fd_sc_hd__and3_1
XFILLER_23_500 VGND VGND VPWR VPWR sky130_fd_sc_hd__decap_4
X_08475_ _01179_ _01202_ VGND VGND VPWR VPWR _01204_ sky130_fd_sc_hd__xnor2_1
XFILLER_62_190 VGND VGND VPWR VPWR sky130_fd_sc_hd__decap_6
XFILLER_50_352 VGND VGND VPWR VPWR sky130_fd_sc_hd__fill_1
XFILLER_24_37 VPWR VGND VPWR VGND sky130_ef_sc_hd__decap_12
X_07426_ net521 net505 net680 net104 VGND VGND VPWR VPWR _00167_ sky130_fd_sc_hd__and4_1
XFILLER_23_599 VGND VGND VPWR VPWR sky130_fd_sc_hd__decap_6
X_07357_ _06550_ _06646_ VGND VGND VPWR VPWR _06648_ sky130_fd_sc_hd__xnor2_1
XFILLER_136_413 VGND VGND VPWR VPWR sky130_fd_sc_hd__decap_3
XFILLER_6_209 VPWR VGND VPWR VGND sky130_ef_sc_hd__decap_12
XFILLER_124_608 VGND VGND VPWR VPWR sky130_fd_sc_hd__decap_3
X_09027_ _01635_ _01637_ _01750_ VGND VGND VPWR VPWR _01752_ sky130_fd_sc_hd__and3_1
XTAP_TAPCELL_ROW_98_1666 VGND VPWR sky130_fd_sc_hd__tapvpwrvgnd_1
X_07288_ _06574_ _06575_ _06577_ VGND VGND VPWR VPWR _06579_ sky130_fd_sc_hd__a21o_1
XFILLER_104_365 VGND VGND VPWR VPWR sky130_fd_sc_hd__decap_3
XFILLER_131_184 VGND VGND VPWR VPWR sky130_fd_sc_hd__fill_2
XPHY_EDGE_ROW_130_Right_130 VGND VGND VPWR VPWR sky130_fd_sc_hd__decap_3
X_09929_ _02707_ _02709_ VGND VGND VPWR VPWR _02711_ sky130_fd_sc_hd__nand2_1
X_12940_ _05873_ _05882_ _05881_ VGND VGND VPWR VPWR _05990_ sky130_fd_sc_hd__a21oi_1
XFILLER_85_293 VGND VGND VPWR VPWR sky130_fd_sc_hd__fill_2
XFILLER_65_55 VGND VGND VPWR VPWR sky130_fd_sc_hd__fill_1
X_12871_ _05552_ _05720_ VGND VGND VPWR VPWR _05915_ sky130_fd_sc_hd__or2_1
XFILLER_65_77 VGND VGND VPWR VPWR sky130_fd_sc_hd__fill_1
X_11822_ _04766_ _04767_ _04765_ VGND VGND VPWR VPWR _04769_ sky130_fd_sc_hd__o21ai_1
XFILLER_46_669 VGND VGND VPWR VPWR sky130_fd_sc_hd__decap_4
XTAP_TAPCELL_ROW_107_1795 VGND VPWR sky130_fd_sc_hd__tapvpwrvgnd_1
XFILLER_61_628 VGND VGND VPWR VPWR sky130_fd_sc_hd__decap_8
XTAP_TAPCELL_ROW_16_517 VGND VPWR sky130_fd_sc_hd__tapvpwrvgnd_1
X_11753_ _04691_ _04692_ VGND VGND VPWR VPWR _04693_ sky130_fd_sc_hd__nor2_1
XFILLER_60_138 VGND VGND VPWR VPWR sky130_fd_sc_hd__fill_2
XFILLER_14_533 VGND VGND VPWR VPWR sky130_fd_sc_hd__decap_6
XTAP_TAPCELL_ROW_120_1973 VGND VPWR sky130_fd_sc_hd__tapvpwrvgnd_1
XFILLER_81_76 VGND VGND VPWR VPWR sky130_fd_sc_hd__decap_8
X_11684_ _04616_ _04617_ VGND VGND VPWR VPWR _04618_ sky130_fd_sc_hd__and2b_1
X_10704_ net528 net637 _03367_ _03366_ VGND VGND VPWR VPWR _03551_ sky130_fd_sc_hd__a31o_1
XFILLER_41_363 VGND VGND VPWR VPWR sky130_fd_sc_hd__decap_3
XFILLER_14_70 VGND VGND VPWR VPWR sky130_fd_sc_hd__fill_1
X_10635_ _03458_ _03474_ VGND VGND VPWR VPWR _03476_ sky130_fd_sc_hd__xor2_1
X_13354_ clknet_3_3__leaf_clk _00006_ _00064_ VGND VGND VPWR VPWR net162 sky130_fd_sc_hd__dfrtp_1
XFILLER_127_446 VGND VGND VPWR VPWR sky130_fd_sc_hd__fill_2
XTAP_TAPCELL_ROW_58_1105 VGND VPWR sky130_fd_sc_hd__tapvpwrvgnd_1
X_12305_ _05134_ _05295_ VGND VGND VPWR VPWR _05296_ sky130_fd_sc_hd__nand2_1
X_10566_ _03397_ _03398_ VGND VGND VPWR VPWR _03400_ sky130_fd_sc_hd__or2_1
X_10497_ _03323_ _03322_ _03171_ _03174_ VGND VGND VPWR VPWR _03326_ sky130_fd_sc_hd__a211o_1
X_13285_ _06363_ _06364_ VGND VGND VPWR VPWR _06365_ sky130_fd_sc_hd__xnor2_1
X_12236_ _05217_ _05218_ _05185_ VGND VGND VPWR VPWR _05220_ sky130_fd_sc_hd__a21o_1
X_12167_ net592 net76 net297 net617 VGND VGND VPWR VPWR _05145_ sky130_fd_sc_hd__a22o_1
XFILLER_122_173 VGND VGND VPWR VPWR sky130_fd_sc_hd__decap_6
XFILLER_110_324 VGND VGND VPWR VPWR sky130_fd_sc_hd__decap_3
XFILLER_96_514 VGND VGND VPWR VPWR sky130_fd_sc_hd__decap_4
X_11118_ _04002_ _04004_ VGND VGND VPWR VPWR _04005_ sky130_fd_sc_hd__and2b_1
XFILLER_122_195 VGND VGND VPWR VPWR sky130_fd_sc_hd__fill_1
X_12098_ _05066_ _05067_ _05068_ VGND VGND VPWR VPWR _05070_ sky130_fd_sc_hd__a21o_1
Xinput7 in0[6] VGND VGND VPWR VPWR net7 sky130_fd_sc_hd__buf_2
X_11049_ net442 net153 VGND VGND VPWR VPWR _03929_ sky130_fd_sc_hd__and2b_1
XFILLER_92_731 VGND VGND VPWR VPWR sky130_fd_sc_hd__decap_6
XTAP_TAPCELL_ROW_69_1267 VGND VPWR sky130_fd_sc_hd__tapvpwrvgnd_1
XTAP_TAPCELL_ROW_69_1256 VGND VPWR sky130_fd_sc_hd__tapvpwrvgnd_1
XFILLER_64_477 VPWR VGND VPWR VGND sky130_ef_sc_hd__decap_12
XFILLER_52_606 VGND VGND VPWR VPWR sky130_fd_sc_hd__fill_2
XFILLER_36_157 VGND VGND VPWR VPWR sky130_fd_sc_hd__fill_1
XFILLER_52_639 VGND VGND VPWR VPWR sky130_fd_sc_hd__decap_4
XTAP_TAPCELL_ROW_82_1445 VGND VPWR sky130_fd_sc_hd__tapvpwrvgnd_1
XFILLER_17_393 VGND VGND VPWR VPWR sky130_fd_sc_hd__decap_3
X_08260_ _00785_ _00896_ _00993_ VGND VGND VPWR VPWR _00995_ sky130_fd_sc_hd__and3_1
XFILLER_60_683 VGND VGND VPWR VPWR sky130_fd_sc_hd__fill_2
XFILLER_32_374 VGND VGND VPWR VPWR sky130_fd_sc_hd__fill_2
X_08191_ _00924_ _00925_ VGND VGND VPWR VPWR _00927_ sky130_fd_sc_hd__xnor2_1
X_07211_ _06334_ _06399_ _06401_ VGND VGND VPWR VPWR _06502_ sky130_fd_sc_hd__a21oi_1
XTAP_TAPCELL_ROW_43_892 VGND VPWR sky130_fd_sc_hd__tapvpwrvgnd_1
X_07142_ net461 net452 net606 net604 VGND VGND VPWR VPWR _06434_ sky130_fd_sc_hd__and4_1
XFILLER_118_435 VPWR VGND VPWR VGND sky130_ef_sc_hd__decap_12
X_07073_ _05144_ _05155_ _05298_ _05276_ _03543_ VGND VGND VPWR VPWR _06323_ sky130_fd_sc_hd__a32o_1
XFILLER_133_449 VPWR VGND VPWR VGND sky130_ef_sc_hd__decap_12
XTAP_TAPCELL_ROW_93_1596 VGND VPWR sky130_fd_sc_hd__tapvpwrvgnd_1
X_07975_ net381 _00618_ _00711_ VGND VGND VPWR VPWR _00712_ sky130_fd_sc_hd__a21oi_1
X_09714_ _02474_ _02475_ VGND VGND VPWR VPWR _02476_ sky130_fd_sc_hd__and2b_1
X_06926_ _02446_ _02823_ _02834_ _02867_ VGND VGND VPWR VPWR _04719_ sky130_fd_sc_hd__o2bb2ai_1
XFILLER_74_219 VPWR VGND VPWR VGND sky130_ef_sc_hd__decap_12
X_06857_ _03948_ _03959_ VGND VGND VPWR VPWR _03970_ sky130_fd_sc_hd__and2b_1
X_09645_ _02290_ _02299_ _02298_ VGND VGND VPWR VPWR _02401_ sky130_fd_sc_hd__a21oi_1
XFILLER_27_113 VGND VGND VPWR VPWR sky130_fd_sc_hd__fill_1
XFILLER_27_135 VPWR VGND VPWR VGND sky130_ef_sc_hd__decap_12
XFILLER_55_466 VGND VGND VPWR VPWR sky130_fd_sc_hd__fill_1
XFILLER_43_606 VGND VGND VPWR VPWR sky130_fd_sc_hd__fill_1
XFILLER_35_14 VGND VGND VPWR VPWR sky130_fd_sc_hd__fill_1
X_06788_ _02697_ _03205_ VGND VGND VPWR VPWR _03216_ sky130_fd_sc_hd__nand2b_1
X_09576_ _02324_ _02325_ VGND VGND VPWR VPWR _02326_ sky130_fd_sc_hd__or2_1
XFILLER_35_36 VPWR VGND VPWR VGND sky130_ef_sc_hd__decap_12
X_08527_ _01254_ _01255_ VGND VGND VPWR VPWR _01256_ sky130_fd_sc_hd__nor2_1
XFILLER_42_138 VGND VGND VPWR VPWR sky130_fd_sc_hd__fill_2
X_08458_ net644 net265 net263 net669 VGND VGND VPWR VPWR _01187_ sky130_fd_sc_hd__a22o_1
XFILLER_51_661 VGND VGND VPWR VPWR sky130_fd_sc_hd__decap_8
X_07409_ _06404_ _06533_ VGND VGND VPWR VPWR _00150_ sky130_fd_sc_hd__nor2_1
XFILLER_50_193 VGND VGND VPWR VPWR sky130_fd_sc_hd__decap_3
X_08389_ _01116_ _01119_ VGND VGND VPWR VPWR _01120_ sky130_fd_sc_hd__xnor2_1
XFILLER_51_46 VGND VGND VPWR VPWR sky130_fd_sc_hd__fill_2
X_10420_ net482 net655 _03101_ VGND VGND VPWR VPWR _03241_ sky130_fd_sc_hd__a21o_1
XFILLER_136_210 VPWR VGND VPWR VGND sky130_ef_sc_hd__decap_12
XTAP_TAPCELL_ROW_21_586 VGND VPWR sky130_fd_sc_hd__tapvpwrvgnd_1
XFILLER_136_265 VGND VGND VPWR VPWR sky130_fd_sc_hd__decap_4
XTAP_TAPCELL_ROW_135_2191 VGND VPWR sky130_fd_sc_hd__tapvpwrvgnd_1
XTAP_TAPCELL_ROW_135_2180 VGND VPWR sky130_fd_sc_hd__tapvpwrvgnd_1
XFILLER_109_479 VGND VGND VPWR VPWR sky130_fd_sc_hd__fill_1
X_10351_ _03018_ _03021_ _03165_ _03166_ VGND VGND VPWR VPWR _03167_ sky130_fd_sc_hd__o211a_4
X_10282_ net504 net653 net651 net520 VGND VGND VPWR VPWR _03091_ sky130_fd_sc_hd__a22o_1
X_13070_ _05998_ _06000_ VGND VGND VPWR VPWR _06132_ sky130_fd_sc_hd__nand2_1
X_12021_ net640 net295 VGND VGND VPWR VPWR _04986_ sky130_fd_sc_hd__nand2_1
XFILLER_4_3 VPWR VGND VPWR VGND sky130_ef_sc_hd__decap_12
XFILLER_2_245 VGND VGND VPWR VPWR sky130_fd_sc_hd__decap_6
XFILLER_120_611 VGND VGND VPWR VPWR sky130_fd_sc_hd__decap_3
XFILLER_105_685 VPWR VGND VPWR VGND sky130_ef_sc_hd__decap_12
XFILLER_104_162 VGND VGND VPWR VPWR sky130_fd_sc_hd__decap_4
XTAP_TAPCELL_ROW_53_1035 VGND VPWR sky130_fd_sc_hd__tapvpwrvgnd_1
XFILLER_2_289 VPWR VGND VPWR VGND sky130_ef_sc_hd__decap_12
XFILLER_120_666 VPWR VGND VPWR VGND sky130_ef_sc_hd__decap_12
XFILLER_116_83 VGND VGND VPWR VPWR sky130_fd_sc_hd__fill_1
XFILLER_104_195 VGND VGND VPWR VPWR sky130_fd_sc_hd__fill_1
Xfanout560 net152 VGND VGND VPWR VPWR net560 sky130_fd_sc_hd__buf_1
Xfanout571 net15 VGND VGND VPWR VPWR net571 sky130_fd_sc_hd__buf_2
XFILLER_59_783 VGND VGND VPWR VPWR sky130_fd_sc_hd__fill_1
Xfanout593 net14 VGND VGND VPWR VPWR net593 sky130_fd_sc_hd__clkbuf_4
Xfanout582 net144 VGND VGND VPWR VPWR net582 sky130_fd_sc_hd__buf_1
XTAP_TAPCELL_ROW_109_1824 VGND VPWR sky130_fd_sc_hd__tapvpwrvgnd_1
XFILLER_46_433 VPWR VGND VPWR VGND sky130_ef_sc_hd__decap_12
XFILLER_46_411 VGND VGND VPWR VPWR sky130_fd_sc_hd__decap_8
X_12923_ net359 _02284_ _05875_ _05879_ VGND VGND VPWR VPWR _05971_ sky130_fd_sc_hd__o31ai_2
XFILLER_18_124 VGND VGND VPWR VPWR sky130_fd_sc_hd__decap_4
X_12854_ net420 net581 VGND VGND VPWR VPWR _05896_ sky130_fd_sc_hd__nand2_1
XTAP_TAPCELL_ROW_29_697 VGND VPWR sky130_fd_sc_hd__tapvpwrvgnd_1
XFILLER_61_447 VGND VGND VPWR VPWR sky130_fd_sc_hd__fill_1
X_11805_ net472 net585 _04749_ VGND VGND VPWR VPWR _04750_ sky130_fd_sc_hd__and3_1
X_12785_ _05818_ _05819_ VGND VGND VPWR VPWR _05820_ sky130_fd_sc_hd__nor2_1
X_11736_ _04668_ _04673_ VGND VGND VPWR VPWR _04674_ sky130_fd_sc_hd__xnor2_1
XTAP_TAPCELL_ROW_64_1197 VGND VPWR sky130_fd_sc_hd__tapvpwrvgnd_1
XTAP_TAPCELL_ROW_64_1186 VGND VPWR sky130_fd_sc_hd__tapvpwrvgnd_1
X_11667_ _04593_ _04598_ VGND VGND VPWR VPWR _04601_ sky130_fd_sc_hd__or2_1
XTAP_TAPCELL_ROW_40_851 VGND VPWR sky130_fd_sc_hd__tapvpwrvgnd_1
XFILLER_128_755 VGND VGND VPWR VPWR sky130_fd_sc_hd__fill_1
X_13406_ clknet_3_7__leaf_clk _00058_ _00116_ VGND VGND VPWR VPWR net220 sky130_fd_sc_hd__dfrtp_1
X_11598_ _04525_ _04527_ VGND VGND VPWR VPWR _04528_ sky130_fd_sc_hd__xnor2_1
X_10618_ _03280_ _03457_ VGND VGND VPWR VPWR _03458_ sky130_fd_sc_hd__xnor2_1
XFILLER_127_276 VGND VGND VPWR VPWR sky130_fd_sc_hd__decap_4
X_10549_ _03337_ _03380_ VGND VGND VPWR VPWR _03382_ sky130_fd_sc_hd__xnor2_1
X_13337_ net393 VGND VGND VPWR VPWR _00111_ sky130_fd_sc_hd__inv_2
X_13268_ _05689_ _06286_ _06284_ VGND VGND VPWR VPWR _06347_ sky130_fd_sc_hd__a21oi_1
XFILLER_69_536 VGND VGND VPWR VPWR sky130_fd_sc_hd__decap_6
XFILLER_69_503 VGND VGND VPWR VPWR sky130_fd_sc_hd__fill_1
X_12219_ _05190_ _05201_ VGND VGND VPWR VPWR _05202_ sky130_fd_sc_hd__xnor2_1
X_13199_ net81 net284 net541 VGND VGND VPWR VPWR _06273_ sky130_fd_sc_hd__mux2_1
XFILLER_37_3 VGND VGND VPWR VPWR sky130_fd_sc_hd__decap_4
XFILLER_111_633 VPWR VGND VPWR VGND sky130_ef_sc_hd__decap_12
XFILLER_110_121 VGND VGND VPWR VPWR sky130_fd_sc_hd__decap_4
XFILLER_96_355 VGND VGND VPWR VPWR sky130_fd_sc_hd__decap_8
X_07760_ _00494_ _00497_ VGND VGND VPWR VPWR _00499_ sky130_fd_sc_hd__xnor2_1
XFILLER_37_400 VPWR VGND VPWR VGND sky130_ef_sc_hd__decap_12
X_06711_ _02349_ _02360_ _02371_ VGND VGND VPWR VPWR _02381_ sky130_fd_sc_hd__or3_1
XFILLER_49_293 VGND VGND VPWR VPWR sky130_fd_sc_hd__decap_3
X_07691_ _00428_ _00430_ VGND VGND VPWR VPWR _00431_ sky130_fd_sc_hd__nand2_1
XFILLER_92_550 VGND VGND VPWR VPWR sky130_fd_sc_hd__fill_1
X_09430_ net313 _02167_ _02166_ VGND VGND VPWR VPWR _02168_ sky130_fd_sc_hd__a21oi_2
XTAP_TAPCELL_ROW_48_962 VGND VPWR sky130_fd_sc_hd__tapvpwrvgnd_1
XFILLER_92_594 VPWR VGND VPWR VGND sky130_ef_sc_hd__decap_12
XFILLER_52_403 VPWR VGND VPWR VGND sky130_ef_sc_hd__decap_12
XTAP_TAPCELL_ROW_48_973 VGND VPWR sky130_fd_sc_hd__tapvpwrvgnd_1
XFILLER_25_617 VGND VGND VPWR VPWR sky130_fd_sc_hd__decap_4
X_09361_ _02089_ _02091_ VGND VGND VPWR VPWR _02092_ sky130_fd_sc_hd__or2_1
XFILLER_52_436 VGND VGND VPWR VPWR sky130_fd_sc_hd__decap_8
XFILLER_24_149 VPWR VGND VPWR VGND sky130_ef_sc_hd__decap_12
X_08312_ _00458_ _01045_ VGND VGND VPWR VPWR _01046_ sky130_fd_sc_hd__xnor2_1
X_09292_ _02016_ _02001_ VGND VGND VPWR VPWR _02017_ sky130_fd_sc_hd__and2b_1
X_08243_ _00874_ _00876_ _00977_ VGND VGND VPWR VPWR _00978_ sky130_fd_sc_hd__a21o_1
XANTENNA_23 net207 VGND VGND VPWR VPWR sky130_fd_sc_hd__diode_2
XANTENNA_12 net8 VGND VGND VPWR VPWR sky130_fd_sc_hd__diode_2
XFILLER_32_193 VGND VGND VPWR VPWR sky130_fd_sc_hd__decap_3
XFILLER_119_700 VGND VGND VPWR VPWR sky130_fd_sc_hd__fill_1
XFILLER_118_232 VGND VGND VPWR VPWR sky130_fd_sc_hd__fill_1
X_08174_ _00909_ _00904_ VGND VGND VPWR VPWR _00910_ sky130_fd_sc_hd__and2b_1
XFILLER_20_399 VGND VGND VPWR VPWR sky130_fd_sc_hd__decap_4
XFILLER_21_27 VGND VGND VPWR VPWR sky130_fd_sc_hd__fill_2
X_07125_ _06415_ _06416_ VGND VGND VPWR VPWR _06417_ sky130_fd_sc_hd__nand2b_1
XTAP_TAPCELL_ROW_95_1625 VGND VPWR sky130_fd_sc_hd__tapvpwrvgnd_1
XFILLER_134_725 VPWR VGND VPWR VGND sky130_ef_sc_hd__decap_12
XFILLER_133_202 VPWR VGND VPWR VGND sky130_ef_sc_hd__decap_12
X_07056_ _05626_ _06117_ net937 VGND VGND VPWR VPWR _06139_ sky130_fd_sc_hd__nor3_1
XFILLER_134_769 VPWR VGND VPWR VGND sky130_ef_sc_hd__decap_12
Xoutput174 net174 VGND VGND VPWR VPWR out0[6] sky130_fd_sc_hd__buf_2
Xoutput163 net163 VGND VGND VPWR VPWR out0[10] sky130_fd_sc_hd__buf_2
Xoutput185 net185 VGND VGND VPWR VPWR out1[1] sky130_fd_sc_hd__buf_2
XFILLER_101_110 VGND VGND VPWR VPWR sky130_fd_sc_hd__fill_2
Xoutput196 net196 VGND VGND VPWR VPWR out2[11] sky130_fd_sc_hd__buf_2
XFILLER_102_688 VGND VGND VPWR VPWR sky130_fd_sc_hd__decap_8
X_07958_ _00693_ _00694_ VGND VGND VPWR VPWR _00696_ sky130_fd_sc_hd__xor2_2
X_06909_ _04526_ VGND VGND VPWR VPWR _04537_ sky130_fd_sc_hd__inv_2
XFILLER_83_561 VGND VGND VPWR VPWR sky130_fd_sc_hd__decap_3
XFILLER_71_701 VGND VGND VPWR VPWR sky130_fd_sc_hd__decap_6
X_07889_ net332 net374 VGND VGND VPWR VPWR _00627_ sky130_fd_sc_hd__nand2_1
X_09628_ _02379_ _02380_ VGND VGND VPWR VPWR _02383_ sky130_fd_sc_hd__xor2_1
XFILLER_46_79 VGND VGND VPWR VPWR sky130_fd_sc_hd__decap_4
XFILLER_16_639 VGND VGND VPWR VPWR sky130_fd_sc_hd__decap_4
X_09559_ _02199_ _02201_ _02307_ VGND VGND VPWR VPWR _02308_ sky130_fd_sc_hd__o21ba_2
XFILLER_43_447 VGND VGND VPWR VPWR sky130_fd_sc_hd__fill_1
XTAP_TAPCELL_ROW_26_656 VGND VPWR sky130_fd_sc_hd__tapvpwrvgnd_1
XTAP_TAPCELL_ROW_104_1754 VGND VPWR sky130_fd_sc_hd__tapvpwrvgnd_1
X_12570_ net446 net582 _05584_ _05585_ VGND VGND VPWR VPWR _05586_ sky130_fd_sc_hd__o2bb2a_1
XFILLER_70_288 VPWR VGND VPWR VGND sky130_ef_sc_hd__decap_12
XFILLER_8_805 VGND VGND VPWR VPWR sky130_fd_sc_hd__decap_6
XFILLER_23_182 VGND VGND VPWR VPWR sky130_fd_sc_hd__decap_4
XFILLER_24_683 VGND VGND VPWR VPWR sky130_fd_sc_hd__decap_8
X_11521_ _04322_ _04325_ VGND VGND VPWR VPWR _04444_ sky130_fd_sc_hd__nor2_1
XFILLER_7_337 VPWR VGND VPWR VGND sky130_ef_sc_hd__decap_12
X_11452_ _04365_ _04368_ VGND VGND VPWR VPWR _04369_ sky130_fd_sc_hd__nand2_1
X_10403_ _03186_ _03222_ VGND VGND VPWR VPWR _03223_ sky130_fd_sc_hd__xnor2_1
X_11383_ _03690_ _04290_ _04017_ _04291_ _04293_ VGND VGND VPWR VPWR _04294_ sky130_fd_sc_hd__o311a_4
X_10334_ _03146_ _03145_ _03137_ VGND VGND VPWR VPWR _03148_ sky130_fd_sc_hd__a21o_1
X_13122_ _06178_ _06187_ VGND VGND VPWR VPWR _06189_ sky130_fd_sc_hd__xor2_1
XFILLER_124_257 VGND VGND VPWR VPWR sky130_fd_sc_hd__decap_4
XFILLER_127_93 VPWR VGND VPWR VGND sky130_ef_sc_hd__decap_12
XFILLER_112_419 VGND VGND VPWR VPWR sky130_fd_sc_hd__fill_1
XFILLER_87_31 VGND VGND VPWR VPWR sky130_fd_sc_hd__fill_1
X_10265_ _03070_ _03071_ VGND VGND VPWR VPWR _03072_ sky130_fd_sc_hd__xnor2_1
X_13053_ _06111_ _06112_ VGND VGND VPWR VPWR _06113_ sky130_fd_sc_hd__nor2_1
XFILLER_132_290 VPWR VGND VPWR VGND sky130_ef_sc_hd__decap_12
XFILLER_78_333 VGND VGND VPWR VPWR sky130_fd_sc_hd__decap_8
X_12004_ _04966_ _04965_ net717 _04814_ VGND VGND VPWR VPWR _04968_ sky130_fd_sc_hd__a211oi_4
X_10196_ _02990_ net864 _02967_ VGND VGND VPWR VPWR _02997_ sky130_fd_sc_hd__o21ai_2
XFILLER_120_474 VGND VGND VPWR VPWR sky130_fd_sc_hd__fill_2
XFILLER_66_528 VGND VGND VPWR VPWR sky130_fd_sc_hd__decap_4
XFILLER_38_208 VGND VGND VPWR VPWR sky130_fd_sc_hd__decap_3
Xfanout390 net391 VGND VGND VPWR VPWR net390 sky130_fd_sc_hd__buf_6
XTAP_TAPCELL_ROW_6_381 VGND VPWR sky130_fd_sc_hd__tapvpwrvgnd_1
XFILLER_62_701 VGND VGND VPWR VPWR sky130_fd_sc_hd__decap_4
XFILLER_74_583 VGND VGND VPWR VPWR sky130_fd_sc_hd__decap_4
XTAP_TAPCELL_ROW_66_1215 VGND VPWR sky130_fd_sc_hd__tapvpwrvgnd_1
XFILLER_46_285 VPWR VGND VPWR VGND sky130_ef_sc_hd__decap_12
XTAP_TAPCELL_ROW_45_921 VGND VPWR sky130_fd_sc_hd__tapvpwrvgnd_1
XFILLER_34_414 VGND VGND VPWR VPWR sky130_fd_sc_hd__decap_6
X_12906_ _05950_ _05951_ VGND VGND VPWR VPWR _05953_ sky130_fd_sc_hd__xor2_1
X_12837_ _05875_ _05876_ VGND VGND VPWR VPWR _05878_ sky130_fd_sc_hd__xnor2_1
XFILLER_34_436 VPWR VGND VPWR VGND sky130_ef_sc_hd__decap_12
X_12768_ _05643_ _05645_ VGND VGND VPWR VPWR _05803_ sky130_fd_sc_hd__nand2_1
X_11719_ _04655_ _04656_ VGND VGND VPWR VPWR _04657_ sky130_fd_sc_hd__or2_1
X_12699_ net457 _05386_ _05388_ _05566_ VGND VGND VPWR VPWR _05727_ sky130_fd_sc_hd__a2bb2o_1
Xinput10 in1[1] VGND VGND VPWR VPWR net10 sky130_fd_sc_hd__clkbuf_4
Xinput21 in2[4] VGND VGND VPWR VPWR net21 sky130_fd_sc_hd__clkbuf_4
Xinput32 in3[7] VGND VGND VPWR VPWR net32 sky130_fd_sc_hd__clkbuf_4
Xinput43 w01[1] VGND VGND VPWR VPWR net43 sky130_fd_sc_hd__buf_1
Xinput54 w02[4] VGND VGND VPWR VPWR net54 sky130_fd_sc_hd__clkbuf_1
Xinput98 w20[0] VGND VGND VPWR VPWR net98 sky130_fd_sc_hd__clkbuf_2
XFILLER_116_747 VGND VGND VPWR VPWR sky130_fd_sc_hd__decap_8
XFILLER_116_736 VGND VGND VPWR VPWR sky130_fd_sc_hd__decap_4
XFILLER_116_725 VGND VGND VPWR VPWR sky130_fd_sc_hd__decap_4
Xinput65 w03[7] VGND VGND VPWR VPWR net65 sky130_fd_sc_hd__clkbuf_2
Xinput76 w11[2] VGND VGND VPWR VPWR net76 sky130_fd_sc_hd__dlymetal6s2s_1
Xinput87 w12[5] VGND VGND VPWR VPWR net87 sky130_fd_sc_hd__clkbuf_2
XTAP_TAPCELL_ROW_77_1377 VGND VPWR sky130_fd_sc_hd__tapvpwrvgnd_1
XTAP_TAPCELL_ROW_77_1366 VGND VPWR sky130_fd_sc_hd__tapvpwrvgnd_1
XFILLER_115_279 VGND VGND VPWR VPWR sky130_fd_sc_hd__fill_1
X_08930_ net473 net538 _01522_ _01521_ VGND VGND VPWR VPWR _01656_ sky130_fd_sc_hd__a31o_1
X_08861_ _01327_ _01330_ _01446_ _01445_ VGND VGND VPWR VPWR _01588_ sky130_fd_sc_hd__and4b_1
XTAP_TAPCELL_ROW_90_1555 VGND VPWR sky130_fd_sc_hd__tapvpwrvgnd_1
XFILLER_97_686 VGND VGND VPWR VPWR sky130_fd_sc_hd__decap_8
X_07812_ _00534_ _00550_ VGND VGND VPWR VPWR _00551_ sky130_fd_sc_hd__xor2_1
X_08792_ _01392_ _01400_ _01399_ VGND VGND VPWR VPWR _01519_ sky130_fd_sc_hd__o21ba_1
XFILLER_69_388 VGND VGND VPWR VPWR sky130_fd_sc_hd__decap_4
XFILLER_57_528 VPWR VGND VPWR VGND sky130_ef_sc_hd__decap_12
XFILLER_38_720 VPWR VGND VPWR VGND sky130_ef_sc_hd__decap_12
X_07743_ _00480_ _00481_ VGND VGND VPWR VPWR _00482_ sky130_fd_sc_hd__nor2_1
XFILLER_38_775 VGND VGND VPWR VPWR sky130_fd_sc_hd__fill_1
X_07674_ _00359_ net799 _00413_ VGND VGND VPWR VPWR _00414_ sky130_fd_sc_hd__nand3_1
XFILLER_65_561 VGND VGND VPWR VPWR sky130_fd_sc_hd__decap_4
XFILLER_52_200 VGND VGND VPWR VPWR sky130_fd_sc_hd__fill_2
XFILLER_38_786 VPWR VGND VPWR VGND sky130_ef_sc_hd__decap_12
X_09413_ net447 net161 VGND VGND VPWR VPWR _02149_ sky130_fd_sc_hd__and2b_1
XFILLER_16_27 VGND VGND VPWR VPWR sky130_fd_sc_hd__fill_1
XFILLER_16_49 VGND VGND VPWR VPWR sky130_fd_sc_hd__decap_3
XFILLER_25_447 VGND VGND VPWR VPWR sky130_fd_sc_hd__fill_1
XFILLER_80_586 VGND VGND VPWR VPWR sky130_fd_sc_hd__fill_2
XFILLER_80_564 VGND VGND VPWR VPWR sky130_fd_sc_hd__decap_6
XFILLER_52_277 VGND VGND VPWR VPWR sky130_fd_sc_hd__fill_1
X_09344_ _02072_ _02073_ _01908_ _01910_ VGND VGND VPWR VPWR _02074_ sky130_fd_sc_hd__a211oi_2
XTAP_TAPCELL_ROW_23_615 VGND VPWR sky130_fd_sc_hd__tapvpwrvgnd_1
X_09275_ _01966_ _01998_ VGND VGND VPWR VPWR _01999_ sky130_fd_sc_hd__xor2_2
X_08226_ _00960_ _00959_ VGND VGND VPWR VPWR _00961_ sky130_fd_sc_hd__and2b_1
X_08157_ _00581_ _00783_ _00785_ VGND VGND VPWR VPWR _00893_ sky130_fd_sc_hd__a21boi_1
XFILLER_4_307 VGND VGND VPWR VPWR sky130_fd_sc_hd__fill_1
XFILLER_134_533 VPWR VGND VPWR VGND sky130_ef_sc_hd__decap_12
X_07108_ _06334_ _06399_ VGND VGND VPWR VPWR _06400_ sky130_fd_sc_hd__xnor2_1
X_08088_ _00822_ _00823_ VGND VGND VPWR VPWR _00825_ sky130_fd_sc_hd__and2_1
XFILLER_121_205 VPWR VGND VPWR VGND sky130_ef_sc_hd__decap_12
X_07039_ _05921_ _05932_ _05943_ VGND VGND VPWR VPWR _05954_ sky130_fd_sc_hd__nand3_1
X_10050_ _02797_ _02798_ _02796_ VGND VGND VPWR VPWR _02838_ sky130_fd_sc_hd__o21a_1
XFILLER_0_579 VGND VGND VPWR VPWR sky130_fd_sc_hd__decap_8
XFILLER_57_45 VGND VGND VPWR VPWR sky130_fd_sc_hd__decap_3
XTAP_TAPCELL_ROW_3_340 VGND VPWR sky130_fd_sc_hd__tapvpwrvgnd_1
XFILLER_113_51 VGND VGND VPWR VPWR sky130_fd_sc_hd__decap_4
XFILLER_73_22 VGND VGND VPWR VPWR sky130_fd_sc_hd__decap_8
XFILLER_44_701 VGND VGND VPWR VPWR sky130_fd_sc_hd__fill_1
X_10952_ net425 net342 VGND VGND VPWR VPWR _03823_ sky130_fd_sc_hd__nand2b_1
XFILLER_28_263 VGND VGND VPWR VPWR sky130_fd_sc_hd__decap_8
XFILLER_29_797 VGND VGND VPWR VPWR sky130_fd_sc_hd__decap_8
XFILLER_73_55 VGND VGND VPWR VPWR sky130_fd_sc_hd__fill_1
XFILLER_71_531 VGND VGND VPWR VPWR sky130_fd_sc_hd__fill_1
XFILLER_43_244 VGND VGND VPWR VPWR sky130_fd_sc_hd__fill_1
X_10883_ _03745_ _03746_ VGND VGND VPWR VPWR _03747_ sky130_fd_sc_hd__nand2b_1
X_12622_ _05464_ _05466_ _05641_ _05642_ VGND VGND VPWR VPWR _05643_ sky130_fd_sc_hd__o211ai_2
XTAP_TAPCELL_ROW_61_1145 VGND VPWR sky130_fd_sc_hd__tapvpwrvgnd_1
XFILLER_12_664 VGND VGND VPWR VPWR sky130_fd_sc_hd__decap_4
X_12553_ _05389_ _05566_ VGND VGND VPWR VPWR _05567_ sky130_fd_sc_hd__xnor2_1
X_11504_ _04302_ _04421_ _04423_ _04424_ VGND VGND VPWR VPWR _04425_ sky130_fd_sc_hd__o211a_1
XTAP_TAPCELL_ROW_50_990 VGND VPWR sky130_fd_sc_hd__tapvpwrvgnd_1
X_12484_ _05317_ _05335_ _05334_ VGND VGND VPWR VPWR _05491_ sky130_fd_sc_hd__o21a_1
XFILLER_125_522 VPWR VGND VPWR VGND sky130_ef_sc_hd__decap_12
XTAP_TAPCELL_ROW_117_1934 VGND VPWR sky130_fd_sc_hd__tapvpwrvgnd_1
X_11435_ _04348_ _04349_ VGND VGND VPWR VPWR _04350_ sky130_fd_sc_hd__nor2_1
XFILLER_125_555 VGND VGND VPWR VPWR sky130_fd_sc_hd__decap_4
X_11366_ _04064_ _04147_ _04146_ VGND VGND VPWR VPWR _04275_ sky130_fd_sc_hd__a21bo_1
XFILLER_98_406 VPWR VGND VPWR VGND sky130_ef_sc_hd__decap_12
XFILLER_98_85 VGND VGND VPWR VPWR sky130_fd_sc_hd__fill_1
X_10317_ net417 net579 _02968_ VGND VGND VPWR VPWR _03130_ sky130_fd_sc_hd__and3_1
X_11297_ _04189_ _04198_ VGND VGND VPWR VPWR _04200_ sky130_fd_sc_hd__nand2b_1
X_13105_ _06166_ _06169_ VGND VGND VPWR VPWR _06170_ sky130_fd_sc_hd__nand2_1
X_10248_ _03054_ _03052_ VGND VGND VPWR VPWR _03055_ sky130_fd_sc_hd__nor2_2
X_13036_ net244 _05966_ VGND VGND VPWR VPWR _06094_ sky130_fd_sc_hd__nand2_1
XFILLER_3_373 VPWR VGND VPWR VGND sky130_ef_sc_hd__decap_12
XFILLER_78_141 VGND VGND VPWR VPWR sky130_fd_sc_hd__decap_8
XFILLER_121_783 VGND VGND VPWR VPWR sky130_fd_sc_hd__fill_1
XFILLER_94_645 VPWR VGND VPWR VGND sky130_ef_sc_hd__decap_12
XTAP_TAPCELL_ROW_72_1296 VGND VPWR sky130_fd_sc_hd__tapvpwrvgnd_1
X_10179_ net376 net353 net351 net945 VGND VGND VPWR VPWR _02979_ sky130_fd_sc_hd__a22oi_2
XFILLER_82_807 VGND VGND VPWR VPWR sky130_fd_sc_hd__fill_1
XFILLER_19_263 VGND VGND VPWR VPWR sky130_fd_sc_hd__fill_2
XFILLER_50_704 VGND VGND VPWR VPWR sky130_fd_sc_hd__decap_6
X_07390_ _00129_ _00130_ VGND VGND VPWR VPWR _00131_ sky130_fd_sc_hd__nand2_1
XFILLER_50_748 VGND VGND VPWR VPWR sky130_fd_sc_hd__fill_1
X_09060_ net544 net260 _01782_ _01783_ VGND VGND VPWR VPWR _01785_ sky130_fd_sc_hd__and4_1
XTAP_TAPCELL_ROW_79_1406 VGND VPWR sky130_fd_sc_hd__tapvpwrvgnd_1
XFILLER_136_809 VGND VGND VPWR VPWR sky130_fd_sc_hd__fill_2
X_08011_ _00672_ _00683_ _00682_ VGND VGND VPWR VPWR _00748_ sky130_fd_sc_hd__o21a_1
XFILLER_128_371 VGND VGND VPWR VPWR sky130_fd_sc_hd__decap_4
XFILLER_118_29 VPWR VGND VPWR VGND sky130_ef_sc_hd__decap_12
XFILLER_116_533 VGND VGND VPWR VPWR sky130_fd_sc_hd__decap_8
XFILLER_131_503 VGND VGND VPWR VPWR sky130_fd_sc_hd__fill_1
XFILLER_116_577 VGND VGND VPWR VPWR sky130_fd_sc_hd__decap_4
XFILLER_103_205 VGND VGND VPWR VPWR sky130_fd_sc_hd__decap_8
X_09962_ _02743_ _02744_ VGND VGND VPWR VPWR _02745_ sky130_fd_sc_hd__xor2_1
X_08913_ _01169_ _01220_ _01380_ _01510_ _01513_ VGND VGND VPWR VPWR _01639_ sky130_fd_sc_hd__o41a_1
XFILLER_97_461 VGND VGND VPWR VPWR sky130_fd_sc_hd__fill_2
X_09893_ _02650_ _02670_ VGND VGND VPWR VPWR _02671_ sky130_fd_sc_hd__xnor2_2
X_08844_ _01569_ _01568_ _01430_ _01432_ VGND VGND VPWR VPWR _01571_ sky130_fd_sc_hd__a211o_1
X_08775_ _01499_ _01500_ _01501_ VGND VGND VPWR VPWR _01502_ sky130_fd_sc_hd__and3_1
X_07726_ _00457_ _00463_ VGND VGND VPWR VPWR _00465_ sky130_fd_sc_hd__xnor2_1
XFILLER_26_701 VPWR VGND VPWR VGND sky130_ef_sc_hd__decap_12
XFILLER_72_339 VGND VGND VPWR VPWR sky130_fd_sc_hd__fill_1
X_07657_ net375 net374 VGND VGND VPWR VPWR _00397_ sky130_fd_sc_hd__nand2_1
XFILLER_43_14 VPWR VGND VPWR VGND sky130_ef_sc_hd__decap_12
X_07588_ net497 net505 net679 net104 VGND VGND VPWR VPWR _00328_ sky130_fd_sc_hd__and4_1
XTAP_TAPCELL_ROW_101_1713 VGND VPWR sky130_fd_sc_hd__tapvpwrvgnd_1
XTAP_TAPCELL_ROW_101_1702 VGND VPWR sky130_fd_sc_hd__tapvpwrvgnd_1
XTAP_TAPCELL_ROW_36_795 VGND VPWR sky130_fd_sc_hd__tapvpwrvgnd_1
XFILLER_41_726 VGND VGND VPWR VPWR sky130_fd_sc_hd__fill_2
XFILLER_41_748 VGND VGND VPWR VPWR sky130_fd_sc_hd__fill_2
X_09327_ _02052_ _02053_ _02019_ VGND VGND VPWR VPWR _02056_ sky130_fd_sc_hd__a21o_1
XFILLER_21_461 VGND VGND VPWR VPWR sky130_fd_sc_hd__fill_1
XFILLER_127_809 VGND VGND VPWR VPWR sky130_fd_sc_hd__fill_2
X_09258_ _01980_ _01981_ VGND VGND VPWR VPWR _01982_ sky130_fd_sc_hd__and2b_1
XFILLER_119_382 VGND VGND VPWR VPWR sky130_fd_sc_hd__fill_1
X_09189_ _01911_ _01912_ _01745_ VGND VGND VPWR VPWR _01914_ sky130_fd_sc_hd__a21oi_1
X_08209_ _06587_ _00942_ _00833_ VGND VGND VPWR VPWR _00944_ sky130_fd_sc_hd__o21a_1
XTAP_TAPCELL_ROW_130_2109 VGND VPWR sky130_fd_sc_hd__tapvpwrvgnd_1
XFILLER_119_393 VGND VGND VPWR VPWR sky130_fd_sc_hd__decap_8
X_11220_ _03752_ _03920_ VGND VGND VPWR VPWR _04116_ sky130_fd_sc_hd__or2_1
XFILLER_134_363 VGND VGND VPWR VPWR sky130_fd_sc_hd__fill_1
XTAP_TAPCELL_ROW_8_410 VGND VPWR sky130_fd_sc_hd__tapvpwrvgnd_1
X_11151_ _04034_ _04036_ _04038_ VGND VGND VPWR VPWR _04040_ sky130_fd_sc_hd__or3_1
X_10102_ _02892_ _02893_ VGND VGND VPWR VPWR _02894_ sky130_fd_sc_hd__nor2_1
XFILLER_0_321 VGND VGND VPWR VPWR sky130_fd_sc_hd__decap_4
XFILLER_122_569 VGND VGND VPWR VPWR sky130_fd_sc_hd__fill_1
XTAP_TAPCELL_ROW_112_1864 VGND VPWR sky130_fd_sc_hd__tapvpwrvgnd_1
XFILLER_76_601 VPWR VGND VPWR VGND sky130_ef_sc_hd__decap_12
X_11082_ _03955_ _03964_ VGND VGND VPWR VPWR _03965_ sky130_fd_sc_hd__xnor2_2
XFILLER_102_271 VGND VGND VPWR VPWR sky130_fd_sc_hd__fill_1
XFILLER_75_111 VGND VGND VPWR VPWR sky130_fd_sc_hd__fill_1
X_10033_ _02787_ _02818_ VGND VGND VPWR VPWR _02820_ sky130_fd_sc_hd__and2_1
XFILLER_0_365 VGND VGND VPWR VPWR sky130_fd_sc_hd__fill_2
XFILLER_124_83 VGND VGND VPWR VPWR sky130_fd_sc_hd__fill_1
XFILLER_84_21 VGND VGND VPWR VPWR sky130_fd_sc_hd__decap_6
XFILLER_75_122 VGND VGND VPWR VPWR sky130_fd_sc_hd__fill_1
XFILLER_84_65 VGND VGND VPWR VPWR sky130_fd_sc_hd__decap_8
XFILLER_75_166 VGND VGND VPWR VPWR sky130_fd_sc_hd__fill_2
XFILLER_29_561 VGND VGND VPWR VPWR sky130_fd_sc_hd__decap_8
XFILLER_90_147 VGND VGND VPWR VPWR sky130_fd_sc_hd__decap_8
X_11984_ _04943_ _04942_ _04944_ VGND VGND VPWR VPWR _04946_ sky130_fd_sc_hd__a21o_1
X_10935_ net753 net344 VGND VGND VPWR VPWR _03804_ sky130_fd_sc_hd__nand2_1
XFILLER_31_225 VPWR VGND VPWR VGND sky130_ef_sc_hd__decap_12
X_10866_ _03721_ _03726_ VGND VGND VPWR VPWR _03728_ sky130_fd_sc_hd__xor2_1
X_12605_ net428 net49 VGND VGND VPWR VPWR _05624_ sky130_fd_sc_hd__and2b_1
XFILLER_129_113 VPWR VGND VPWR VGND sky130_ef_sc_hd__decap_12
XFILLER_8_421 VGND VGND VPWR VPWR sky130_fd_sc_hd__decap_3
XTAP_TAPCELL_ROW_14_489 VGND VPWR sky130_fd_sc_hd__tapvpwrvgnd_1
X_10797_ _03652_ VGND VGND VPWR VPWR _03654_ sky130_fd_sc_hd__inv_2
XFILLER_40_781 VGND VGND VPWR VPWR sky130_fd_sc_hd__decap_4
X_12536_ _02044_ net657 VGND VGND VPWR VPWR _05548_ sky130_fd_sc_hd__and2_1
X_12467_ _05468_ _05470_ _05364_ VGND VGND VPWR VPWR _05474_ sky130_fd_sc_hd__a21o_1
X_11418_ _04215_ _04227_ _04226_ VGND VGND VPWR VPWR _04332_ sky130_fd_sc_hd__a21o_1
XFILLER_125_363 VGND VGND VPWR VPWR sky130_fd_sc_hd__fill_2
XTAP_TAPCELL_ROW_74_1336 VGND VPWR sky130_fd_sc_hd__tapvpwrvgnd_1
XTAP_TAPCELL_ROW_74_1325 VGND VPWR sky130_fd_sc_hd__tapvpwrvgnd_1
X_12398_ _05393_ _05394_ VGND VGND VPWR VPWR _05398_ sky130_fd_sc_hd__xnor2_1
XFILLER_99_759 VGND VGND VPWR VPWR sky130_fd_sc_hd__fill_2
XFILLER_4_693 VGND VGND VPWR VPWR sky130_fd_sc_hd__decap_6
XFILLER_3_181 VPWR VGND VPWR VGND sky130_ef_sc_hd__decap_12
X_11349_ _04256_ net247 VGND VGND VPWR VPWR _04257_ sky130_fd_sc_hd__nand2b_1
XFILLER_101_709 VPWR VGND VPWR VGND sky130_ef_sc_hd__decap_12
XFILLER_79_494 VGND VGND VPWR VPWR sky130_fd_sc_hd__decap_3
X_06890_ _04188_ _04308_ _04319_ VGND VGND VPWR VPWR _04330_ sky130_fd_sc_hd__nand3_1
X_13019_ _05862_ _05945_ _05944_ VGND VGND VPWR VPWR _06077_ sky130_fd_sc_hd__a21bo_1
XFILLER_27_509 VGND VGND VPWR VPWR sky130_fd_sc_hd__fill_1
XFILLER_94_464 VPWR VGND VPWR VGND sky130_ef_sc_hd__decap_12
XFILLER_81_147 VGND VGND VPWR VPWR sky130_fd_sc_hd__fill_2
X_08560_ _01279_ _01280_ _01286_ VGND VGND VPWR VPWR _01289_ sky130_fd_sc_hd__a21oi_1
XFILLER_47_391 VGND VGND VPWR VPWR sky130_fd_sc_hd__fill_1
X_08491_ net501 net633 VGND VGND VPWR VPWR _01220_ sky130_fd_sc_hd__nand2_2
XFILLER_81_169 VGND VGND VPWR VPWR sky130_fd_sc_hd__fill_2
X_07511_ _00250_ _00249_ _06630_ _06632_ VGND VGND VPWR VPWR _00252_ sky130_fd_sc_hd__a211o_1
X_07442_ net461 net137 VGND VGND VPWR VPWR _00183_ sky130_fd_sc_hd__and2b_1
XFILLER_90_692 VGND VGND VPWR VPWR sky130_fd_sc_hd__decap_8
XTAP_TAPCELL_ROW_85_1487 VGND VPWR sky130_fd_sc_hd__tapvpwrvgnd_1
XFILLER_23_726 VGND VGND VPWR VPWR sky130_fd_sc_hd__fill_2
X_07373_ _06547_ _06549_ _06661_ VGND VGND VPWR VPWR _06663_ sky130_fd_sc_hd__and3_1
XTAP_TAPCELL_ROW_33_754 VGND VPWR sky130_fd_sc_hd__tapvpwrvgnd_1
X_09112_ _01803_ _01836_ VGND VGND VPWR VPWR _01837_ sky130_fd_sc_hd__xor2_1
XFILLER_50_589 VGND VGND VPWR VPWR sky130_fd_sc_hd__decap_8
XFILLER_50_578 VGND VGND VPWR VPWR sky130_fd_sc_hd__fill_1
XFILLER_31_770 VGND VGND VPWR VPWR sky130_fd_sc_hd__decap_3
XFILLER_136_617 VGND VGND VPWR VPWR sky130_fd_sc_hd__fill_2
XFILLER_129_39 VPWR VGND VPWR VGND sky130_ef_sc_hd__decap_12
XFILLER_109_809 VGND VGND VPWR VPWR sky130_fd_sc_hd__fill_2
XFILLER_136_639 VGND VGND VPWR VPWR sky130_fd_sc_hd__fill_1
XFILLER_135_105 VGND VGND VPWR VPWR sky130_fd_sc_hd__decap_6
X_09043_ net573 net262 _01608_ _01607_ VGND VGND VPWR VPWR _01768_ sky130_fd_sc_hd__a31o_1
XFILLER_135_149 VPWR VGND VPWR VGND sky130_ef_sc_hd__decap_12
XPHY_EDGE_ROW_111_Right_111 VGND VGND VPWR VPWR sky130_fd_sc_hd__decap_3
XFILLER_116_341 VPWR VGND VPWR VGND sky130_ef_sc_hd__decap_12
XFILLER_89_203 VGND VGND VPWR VPWR sky130_fd_sc_hd__fill_2
XFILLER_131_311 VGND VGND VPWR VPWR sky130_fd_sc_hd__decap_4
XFILLER_89_225 VGND VGND VPWR VPWR sky130_fd_sc_hd__fill_1
X_09945_ _02725_ _02726_ VGND VGND VPWR VPWR _02727_ sky130_fd_sc_hd__nand2b_1
XFILLER_89_258 VGND VGND VPWR VPWR sky130_fd_sc_hd__decap_6
X_09876_ _02419_ _02651_ VGND VGND VPWR VPWR _02652_ sky130_fd_sc_hd__xor2_2
XFILLER_98_770 VPWR VGND VPWR VGND sky130_ef_sc_hd__decap_12
XFILLER_58_623 VGND VGND VPWR VPWR sky130_fd_sc_hd__fill_2
X_08827_ _01551_ _01552_ _01553_ VGND VGND VPWR VPWR _01554_ sky130_fd_sc_hd__or3_4
XFILLER_58_667 VGND VGND VPWR VPWR sky130_fd_sc_hd__fill_1
XFILLER_58_645 VGND VGND VPWR VPWR sky130_fd_sc_hd__decap_8
XTAP_TAPCELL_ROW_127_2071 VGND VPWR sky130_fd_sc_hd__tapvpwrvgnd_1
XFILLER_58_678 VGND VGND VPWR VPWR sky130_fd_sc_hd__decap_4
XFILLER_57_155 VPWR VGND VPWR VGND sky130_ef_sc_hd__decap_12
XFILLER_45_306 VPWR VGND VPWR VGND sky130_ef_sc_hd__decap_12
X_08758_ _01481_ _01483_ VGND VGND VPWR VPWR _01485_ sky130_fd_sc_hd__xor2_1
XFILLER_73_637 VGND VGND VPWR VPWR sky130_fd_sc_hd__fill_2
XFILLER_38_380 VGND VGND VPWR VPWR sky130_fd_sc_hd__decap_8
X_07709_ net620 _02077_ net303 net73 VGND VGND VPWR VPWR _00448_ sky130_fd_sc_hd__and4_1
X_08689_ _01414_ _01415_ _01413_ VGND VGND VPWR VPWR _01417_ sky130_fd_sc_hd__o21ai_1
XFILLER_53_350 VGND VGND VPWR VPWR sky130_fd_sc_hd__fill_1
XFILLER_26_553 VPWR VGND VPWR VGND sky130_ef_sc_hd__decap_12
XFILLER_81_692 VGND VGND VPWR VPWR sky130_fd_sc_hd__decap_3
XFILLER_81_670 VGND VGND VPWR VPWR sky130_fd_sc_hd__fill_2
XFILLER_13_225 VGND VGND VPWR VPWR sky130_fd_sc_hd__decap_6
XFILLER_26_597 VGND VGND VPWR VPWR sky130_fd_sc_hd__fill_1
X_10720_ net503 net648 net637 net520 VGND VGND VPWR VPWR _03569_ sky130_fd_sc_hd__a22o_1
XFILLER_41_556 VGND VGND VPWR VPWR sky130_fd_sc_hd__decap_4
XFILLER_41_567 VGND VGND VPWR VPWR sky130_fd_sc_hd__fill_1
XFILLER_110_85 VPWR VGND VPWR VGND sky130_ef_sc_hd__decap_12
X_10651_ _03317_ _03225_ _03316_ VGND VGND VPWR VPWR _03494_ sky130_fd_sc_hd__a21boi_2
X_13370_ clknet_3_4__leaf_clk _00003_ _00080_ VGND VGND VPWR VPWR net178 sky130_fd_sc_hd__dfrtp_1
X_10582_ _03403_ _03416_ _03417_ VGND VGND VPWR VPWR _03418_ sky130_fd_sc_hd__nand3_1
X_12321_ net641 net295 _05145_ _05143_ VGND VGND VPWR VPWR _05313_ sky130_fd_sc_hd__a31oi_1
XTAP_TAPCELL_ROW_11_448 VGND VPWR sky130_fd_sc_hd__tapvpwrvgnd_1
X_12252_ _05062_ _05065_ _05064_ VGND VGND VPWR VPWR _05238_ sky130_fd_sc_hd__o21bai_1
X_11203_ net408 _04096_ _04095_ VGND VGND VPWR VPWR _04097_ sky130_fd_sc_hd__a21oi_1
X_12183_ _05029_ _05039_ _05038_ _05037_ VGND VGND VPWR VPWR _05162_ sky130_fd_sc_hd__a2bb2o_1
XTAP_TAPCELL_ROW_56_1077 VGND VPWR sky130_fd_sc_hd__tapvpwrvgnd_1
XFILLER_1_641 VPWR VGND VPWR VGND sky130_ef_sc_hd__decap_12
X_11134_ _03903_ _03906_ _04020_ VGND VGND VPWR VPWR _04021_ sky130_fd_sc_hd__a21oi_1
XFILLER_49_634 VGND VGND VPWR VPWR sky130_fd_sc_hd__decap_4
XFILLER_1_685 VPWR VGND VPWR VGND sky130_ef_sc_hd__decap_12
X_11065_ net286 net348 net346 VGND VGND VPWR VPWR _03946_ sky130_fd_sc_hd__and3_1
XFILLER_135_93 VPWR VGND VPWR VGND sky130_ef_sc_hd__decap_12
XFILLER_88_291 VGND VGND VPWR VPWR sky130_fd_sc_hd__decap_6
XFILLER_88_280 VGND VGND VPWR VPWR sky130_fd_sc_hd__decap_4
X_10016_ net531 net654 VGND VGND VPWR VPWR _02801_ sky130_fd_sc_hd__nand2_1
XFILLER_49_645 VPWR VGND VPWR VGND sky130_ef_sc_hd__decap_12
XFILLER_95_86 VPWR VGND VPWR VGND sky130_ef_sc_hd__decap_12
XFILLER_63_103 VGND VGND VPWR VPWR sky130_fd_sc_hd__decap_8
XFILLER_29_391 VGND VGND VPWR VPWR sky130_fd_sc_hd__fill_1
X_11967_ _04748_ _04750_ _04926_ VGND VGND VPWR VPWR _04928_ sky130_fd_sc_hd__o21a_1
XTAP_TAPCELL_ROW_19_559 VGND VPWR sky130_fd_sc_hd__tapvpwrvgnd_1
XFILLER_72_670 VGND VGND VPWR VPWR sky130_fd_sc_hd__fill_1
X_10918_ _03782_ _03783_ net442 net560 VGND VGND VPWR VPWR _03786_ sky130_fd_sc_hd__and4bb_1
X_11898_ _04663_ _04850_ _04849_ VGND VGND VPWR VPWR _04853_ sky130_fd_sc_hd__o21bai_4
XTAP_TAPCELL_ROW_30_713 VGND VPWR sky130_fd_sc_hd__tapvpwrvgnd_1
X_10849_ _03708_ _03709_ VGND VGND VPWR VPWR _03710_ sky130_fd_sc_hd__nor2_1
XFILLER_12_280 VPWR VGND VPWR VGND sky130_ef_sc_hd__decap_12
XFILLER_9_741 VPWR VGND VPWR VGND sky130_ef_sc_hd__decap_12
XFILLER_13_781 VGND VGND VPWR VPWR sky130_fd_sc_hd__decap_3
XFILLER_9_785 VPWR VGND VPWR VGND sky130_ef_sc_hd__decap_12
XFILLER_8_273 VGND VGND VPWR VPWR sky130_fd_sc_hd__fill_1
XFILLER_8_251 VGND VGND VPWR VPWR sky130_fd_sc_hd__fill_1
X_12519_ _05519_ _05529_ VGND VGND VPWR VPWR _05530_ sky130_fd_sc_hd__nor2_1
XFILLER_133_609 VGND VGND VPWR VPWR sky130_fd_sc_hd__decap_6
XFILLER_5_51 VGND VGND VPWR VPWR sky130_fd_sc_hd__decap_4
X_07991_ _00624_ _00635_ _00623_ VGND VGND VPWR VPWR _00728_ sky130_fd_sc_hd__a21o_1
XFILLER_59_409 VPWR VGND VPWR VGND sky130_ef_sc_hd__decap_12
X_09730_ _02236_ _02493_ VGND VGND VPWR VPWR _02494_ sky130_fd_sc_hd__nand2_1
X_06942_ _03696_ _04883_ VGND VGND VPWR VPWR _04894_ sky130_fd_sc_hd__and2_1
X_06873_ _04112_ _04134_ VGND VGND VPWR VPWR _04145_ sky130_fd_sc_hd__or2_1
XTAP_TAPCELL_ROW_87_1516 VGND VPWR sky130_fd_sc_hd__tapvpwrvgnd_1
X_09661_ _02306_ _02314_ _02317_ VGND VGND VPWR VPWR _02418_ sky130_fd_sc_hd__a21bo_1
XFILLER_39_144 VGND VGND VPWR VPWR sky130_fd_sc_hd__decap_8
XFILLER_94_294 VGND VGND VPWR VPWR sky130_fd_sc_hd__decap_8
XFILLER_94_272 VGND VGND VPWR VPWR sky130_fd_sc_hd__fill_2
X_09592_ _02339_ _02342_ VGND VGND VPWR VPWR _02344_ sky130_fd_sc_hd__xnor2_1
X_08612_ _01206_ _01209_ _01205_ VGND VGND VPWR VPWR _01340_ sky130_fd_sc_hd__o21ai_1
XFILLER_55_659 VGND VGND VPWR VPWR sky130_fd_sc_hd__decap_8
XPHY_EDGE_ROW_19_Left_156 VGND VGND VPWR VPWR sky130_fd_sc_hd__decap_3
XTAP_TAPCELL_ROW_38_824 VGND VPWR sky130_fd_sc_hd__tapvpwrvgnd_1
X_08543_ net740 _01264_ _01263_ VGND VGND VPWR VPWR _01272_ sky130_fd_sc_hd__o21ai_1
XFILLER_23_512 VGND VGND VPWR VPWR sky130_fd_sc_hd__decap_6
X_08474_ _01179_ _01202_ VGND VGND VPWR VPWR _01203_ sky130_fd_sc_hd__nand2b_1
XFILLER_24_27 VGND VGND VPWR VPWR sky130_fd_sc_hd__fill_1
XFILLER_24_49 VPWR VGND VPWR VGND sky130_ef_sc_hd__decap_12
X_07425_ _06586_ _06606_ _06605_ VGND VGND VPWR VPWR _00166_ sky130_fd_sc_hd__a21oi_1
XFILLER_11_729 VPWR VGND VPWR VGND sky130_ef_sc_hd__decap_12
X_07356_ _06550_ _06646_ VGND VGND VPWR VPWR _06647_ sky130_fd_sc_hd__nor2_1
XFILLER_109_617 VPWR VGND VPWR VGND sky130_ef_sc_hd__decap_12
X_07287_ _06574_ _06575_ _06577_ VGND VGND VPWR VPWR _06578_ sky130_fd_sc_hd__nand3_1
XPHY_EDGE_ROW_28_Left_165 VGND VGND VPWR VPWR sky130_fd_sc_hd__decap_3
X_09026_ _01635_ _01637_ _01750_ VGND VGND VPWR VPWR _01751_ sky130_fd_sc_hd__a21oi_2
XTAP_TAPCELL_ROW_98_1667 VGND VPWR sky130_fd_sc_hd__tapvpwrvgnd_1
XFILLER_40_59 VGND VGND VPWR VPWR sky130_fd_sc_hd__fill_1
XFILLER_104_344 VPWR VGND VPWR VGND sky130_ef_sc_hd__decap_12
XTAP_TAPCELL_ROW_129_2100 VGND VPWR sky130_fd_sc_hd__tapvpwrvgnd_1
X_09928_ _02707_ _02709_ VGND VGND VPWR VPWR _02710_ sky130_fd_sc_hd__nor2_1
XFILLER_105_41 VPWR VGND VPWR VGND sky130_ef_sc_hd__decap_12
XFILLER_92_209 VPWR VGND VPWR VGND sky130_ef_sc_hd__decap_12
XFILLER_86_784 VGND VGND VPWR VPWR sky130_fd_sc_hd__fill_2
X_09859_ _02513_ _02633_ VGND VGND VPWR VPWR _02634_ sky130_fd_sc_hd__xnor2_1
XFILLER_58_464 VGND VGND VPWR VPWR sky130_fd_sc_hd__fill_2
XPHY_EDGE_ROW_37_Left_174 VGND VGND VPWR VPWR sky130_fd_sc_hd__decap_3
XFILLER_45_125 VGND VGND VPWR VPWR sky130_fd_sc_hd__fill_2
XFILLER_45_103 VGND VGND VPWR VPWR sky130_fd_sc_hd__fill_1
X_12870_ _05911_ _05912_ VGND VGND VPWR VPWR _05914_ sky130_fd_sc_hd__xnor2_1
XFILLER_61_607 VGND VGND VPWR VPWR sky130_fd_sc_hd__fill_2
X_11821_ _04765_ _04766_ _04767_ VGND VGND VPWR VPWR _04768_ sky130_fd_sc_hd__or3_4
XFILLER_121_51 VGND VGND VPWR VPWR sky130_fd_sc_hd__decap_4
XFILLER_14_512 VGND VGND VPWR VPWR sky130_fd_sc_hd__fill_1
XTAP_TAPCELL_ROW_16_518 VGND VPWR sky130_fd_sc_hd__tapvpwrvgnd_1
XTAP_TAPCELL_ROW_107_1796 VGND VPWR sky130_fd_sc_hd__tapvpwrvgnd_1
XFILLER_81_44 VGND VGND VPWR VPWR sky130_fd_sc_hd__decap_3
X_11752_ net666 net298 _04689_ _04690_ VGND VGND VPWR VPWR _04692_ sky130_fd_sc_hd__o2bb2a_1
XFILLER_14_556 VPWR VGND VPWR VGND sky130_ef_sc_hd__decap_12
XFILLER_81_55 VGND VGND VPWR VPWR sky130_fd_sc_hd__fill_1
X_11683_ net789 net370 net368 net519 VGND VGND VPWR VPWR _04617_ sky130_fd_sc_hd__a22o_1
X_10703_ _03540_ _03547_ VGND VGND VPWR VPWR _03550_ sky130_fd_sc_hd__xor2_1
XFILLER_14_589 VPWR VGND VPWR VGND sky130_ef_sc_hd__decap_12
XTAP_TAPCELL_ROW_120_1974 VGND VPWR sky130_fd_sc_hd__tapvpwrvgnd_1
XPHY_EDGE_ROW_46_Left_183 VGND VGND VPWR VPWR sky130_fd_sc_hd__decap_3
X_10634_ _03458_ _03474_ VGND VGND VPWR VPWR _03475_ sky130_fd_sc_hd__nor2_1
X_13353_ net399 VGND VGND VPWR VPWR _00127_ sky130_fd_sc_hd__inv_2
XFILLER_14_82 VGND VGND VPWR VPWR sky130_fd_sc_hd__fill_2
XTAP_TAPCELL_ROW_58_1106 VGND VPWR sky130_fd_sc_hd__tapvpwrvgnd_1
X_12304_ _05293_ _05292_ VGND VGND VPWR VPWR _05295_ sky130_fd_sc_hd__xor2_1
X_10565_ _03397_ _03398_ VGND VGND VPWR VPWR _03399_ sky130_fd_sc_hd__nand2_1
X_10496_ _03171_ _03174_ _03322_ _03323_ VGND VGND VPWR VPWR _03324_ sky130_fd_sc_hd__o211ai_2
X_13284_ _06268_ _06299_ _06267_ VGND VGND VPWR VPWR _06364_ sky130_fd_sc_hd__a21oi_1
XFILLER_6_755 VGND VGND VPWR VPWR sky130_fd_sc_hd__fill_1
XFILLER_107_182 VGND VGND VPWR VPWR sky130_fd_sc_hd__decap_8
X_12235_ _05185_ _05217_ _05218_ VGND VGND VPWR VPWR _05219_ sky130_fd_sc_hd__and3_1
XFILLER_69_707 VGND VGND VPWR VPWR sky130_fd_sc_hd__fill_2
X_12166_ net617 net592 net76 net297 VGND VGND VPWR VPWR _05143_ sky130_fd_sc_hd__and4_1
XFILLER_122_163 VGND VGND VPWR VPWR sky130_fd_sc_hd__fill_2
XFILLER_110_303 VGND VGND VPWR VPWR sky130_fd_sc_hd__decap_4
X_11117_ _03742_ _03843_ _03842_ VGND VGND VPWR VPWR _04004_ sky130_fd_sc_hd__a21bo_1
XFILLER_96_559 VPWR VGND VPWR VGND sky130_ef_sc_hd__decap_12
XFILLER_77_740 VPWR VGND VPWR VGND sky130_ef_sc_hd__decap_12
XPHY_EDGE_ROW_55_Left_192 VGND VGND VPWR VPWR sky130_fd_sc_hd__decap_3
X_12097_ _05066_ _05067_ _05068_ VGND VGND VPWR VPWR _05069_ sky130_fd_sc_hd__nand3_1
XFILLER_76_261 VGND VGND VPWR VPWR sky130_fd_sc_hd__fill_1
X_11048_ _03782_ _03786_ VGND VGND VPWR VPWR _03928_ sky130_fd_sc_hd__nor2_1
Xinput8 in0[7] VGND VGND VPWR VPWR net8 sky130_fd_sc_hd__buf_4
XFILLER_64_412 VGND VGND VPWR VPWR sky130_fd_sc_hd__decap_8
XTAP_TAPCELL_ROW_69_1257 VGND VPWR sky130_fd_sc_hd__tapvpwrvgnd_1
XFILLER_24_309 VGND VGND VPWR VPWR sky130_fd_sc_hd__decap_8
XFILLER_64_489 VPWR VGND VPWR VGND sky130_ef_sc_hd__decap_12
XFILLER_52_629 VGND VGND VPWR VPWR sky130_fd_sc_hd__fill_1
XFILLER_51_106 VGND VGND VPWR VPWR sky130_fd_sc_hd__fill_1
X_12999_ _05834_ _06054_ VGND VGND VPWR VPWR _06055_ sky130_fd_sc_hd__xnor2_1
XFILLER_33_810 VGND VGND VPWR VPWR sky130_fd_sc_hd__fill_1
XTAP_TAPCELL_ROW_82_1446 VGND VPWR sky130_fd_sc_hd__tapvpwrvgnd_1
X_07210_ _06500_ _06501_ VGND VGND VPWR VPWR _00047_ sky130_fd_sc_hd__xor2_1
X_08190_ _00925_ _00924_ VGND VGND VPWR VPWR _00926_ sky130_fd_sc_hd__nand2b_1
XFILLER_60_695 VGND VGND VPWR VPWR sky130_fd_sc_hd__decap_4
XTAP_TAPCELL_ROW_43_893 VGND VPWR sky130_fd_sc_hd__tapvpwrvgnd_1
XFILLER_20_537 VGND VGND VPWR VPWR sky130_fd_sc_hd__fill_1
XFILLER_118_414 VGND VGND VPWR VPWR sky130_fd_sc_hd__decap_6
X_07141_ net469 net602 VGND VGND VPWR VPWR _06433_ sky130_fd_sc_hd__nand2_1
XFILLER_118_447 VPWR VGND VPWR VGND sky130_ef_sc_hd__decap_12
X_07072_ _05047_ _06303_ VGND VGND VPWR VPWR _00046_ sky130_fd_sc_hd__xor2_1
XFILLER_105_108 VGND VGND VPWR VPWR sky130_fd_sc_hd__decap_4
XFILLER_133_428 VPWR VGND VPWR VGND sky130_ef_sc_hd__decap_12
XFILLER_10_29 VGND VGND VPWR VPWR sky130_fd_sc_hd__fill_2
XFILLER_126_29 VPWR VGND VPWR VGND sky130_ef_sc_hd__decap_12
XFILLER_113_130 VPWR VGND VPWR VGND sky130_ef_sc_hd__decap_12
XFILLER_101_314 VPWR VGND VPWR VGND sky130_ef_sc_hd__decap_12
XTAP_TAPCELL_ROW_93_1597 VGND VPWR sky130_fd_sc_hd__tapvpwrvgnd_1
XFILLER_87_515 VGND VGND VPWR VPWR sky130_fd_sc_hd__decap_3
X_07974_ net381 net287 _00618_ VGND VGND VPWR VPWR _00711_ sky130_fd_sc_hd__a21oi_1
X_09713_ _02261_ _02269_ _02268_ VGND VGND VPWR VPWR _02475_ sky130_fd_sc_hd__a21bo_1
X_06925_ _04675_ net936 _03915_ VGND VGND VPWR VPWR _04708_ sky130_fd_sc_hd__o21ai_4
XFILLER_83_710 VGND VGND VPWR VPWR sky130_fd_sc_hd__fill_1
XFILLER_68_784 VGND VGND VPWR VPWR sky130_fd_sc_hd__fill_2
XFILLER_68_762 VGND VGND VPWR VPWR sky130_fd_sc_hd__decap_3
XFILLER_67_250 VGND VGND VPWR VPWR sky130_fd_sc_hd__fill_1
X_06856_ net452 net609 net444 net611 VGND VGND VPWR VPWR _03959_ sky130_fd_sc_hd__a22o_1
X_09644_ _02308_ _02313_ _02202_ VGND VGND VPWR VPWR _02400_ sky130_fd_sc_hd__a21oi_1
XFILLER_67_294 VGND VGND VPWR VPWR sky130_fd_sc_hd__fill_1
XFILLER_27_103 VGND VGND VPWR VPWR sky130_fd_sc_hd__decap_8
XTAP_TAPCELL_ROW_124_2030 VGND VPWR sky130_fd_sc_hd__tapvpwrvgnd_1
XFILLER_83_754 VGND VGND VPWR VPWR sky130_fd_sc_hd__decap_6
XFILLER_27_147 VGND VGND VPWR VPWR sky130_fd_sc_hd__decap_6
X_06787_ _03162_ _03173_ VGND VGND VPWR VPWR _03205_ sky130_fd_sc_hd__xnor2_1
X_09575_ net487 net626 net625 net493 VGND VGND VPWR VPWR _02325_ sky130_fd_sc_hd__a22oi_1
XFILLER_27_169 VPWR VGND VPWR VGND sky130_ef_sc_hd__decap_12
XFILLER_35_48 VGND VGND VPWR VPWR sky130_fd_sc_hd__decap_8
X_08526_ net518 net330 net327 net699 VGND VGND VPWR VPWR _01255_ sky130_fd_sc_hd__a22oi_1
X_08457_ _01185_ VGND VGND VPWR VPWR _01186_ sky130_fd_sc_hd__inv_2
XFILLER_51_673 VGND VGND VPWR VPWR sky130_fd_sc_hd__decap_3
X_07408_ _00142_ _00148_ VGND VGND VPWR VPWR _00149_ sky130_fd_sc_hd__xnor2_1
X_08388_ _01117_ _01118_ VGND VGND VPWR VPWR _01119_ sky130_fd_sc_hd__or2_1
XFILLER_11_559 VGND VGND VPWR VPWR sky130_fd_sc_hd__fill_1
XFILLER_136_222 VGND VGND VPWR VPWR sky130_fd_sc_hd__fill_2
XFILLER_109_447 VGND VGND VPWR VPWR sky130_fd_sc_hd__fill_1
X_07339_ _06628_ _06629_ VGND VGND VPWR VPWR _06630_ sky130_fd_sc_hd__nor2_1
XTAP_TAPCELL_ROW_21_587 VGND VPWR sky130_fd_sc_hd__tapvpwrvgnd_1
XTAP_TAPCELL_ROW_135_2181 VGND VPWR sky130_fd_sc_hd__tapvpwrvgnd_1
X_10350_ _03161_ _03163_ _03112_ VGND VGND VPWR VPWR _03166_ sky130_fd_sc_hd__o21ai_2
X_09009_ _01733_ _01732_ VGND VGND VPWR VPWR _01735_ sky130_fd_sc_hd__xor2_2
X_10281_ net520 net504 net653 net651 VGND VGND VPWR VPWR _03090_ sky130_fd_sc_hd__nand4_1
X_12020_ _04757_ _04908_ _04910_ VGND VGND VPWR VPWR _04985_ sky130_fd_sc_hd__o21bai_2
XFILLER_105_697 VGND VGND VPWR VPWR sky130_fd_sc_hd__decap_3
XFILLER_104_141 VGND VGND VPWR VPWR sky130_fd_sc_hd__fill_2
XTAP_TAPCELL_ROW_53_1036 VGND VPWR sky130_fd_sc_hd__tapvpwrvgnd_1
XFILLER_120_645 VPWR VGND VPWR VGND sky130_ef_sc_hd__decap_12
Xfanout550 net158 VGND VGND VPWR VPWR net550 sky130_fd_sc_hd__buf_2
XFILLER_78_559 VGND VGND VPWR VPWR sky130_fd_sc_hd__decap_3
Xfanout572 net573 VGND VGND VPWR VPWR net572 sky130_fd_sc_hd__buf_2
XFILLER_120_678 VGND VGND VPWR VPWR sky130_fd_sc_hd__decap_8
Xfanout561 net151 VGND VGND VPWR VPWR net561 sky130_fd_sc_hd__buf_2
Xfanout583 net143 VGND VGND VPWR VPWR net583 sky130_fd_sc_hd__buf_2
Xfanout594 net595 VGND VGND VPWR VPWR net594 sky130_fd_sc_hd__clkbuf_2
XTAP_TAPCELL_ROW_109_1825 VGND VPWR sky130_fd_sc_hd__tapvpwrvgnd_1
XTAP_TAPCELL_ROW_109_1814 VGND VPWR sky130_fd_sc_hd__tapvpwrvgnd_1
XFILLER_58_261 VPWR VGND VPWR VGND sky130_ef_sc_hd__decap_12
X_12922_ _05967_ _05968_ VGND VGND VPWR VPWR _05970_ sky130_fd_sc_hd__xor2_1
XFILLER_74_754 VGND VGND VPWR VPWR sky130_fd_sc_hd__fill_2
XFILLER_46_445 VGND VGND VPWR VPWR sky130_fd_sc_hd__decap_4
XFILLER_132_83 VGND VGND VPWR VPWR sky130_fd_sc_hd__fill_1
X_12853_ net412 _05894_ _05893_ VGND VGND VPWR VPWR _05895_ sky130_fd_sc_hd__a21oi_1
XTAP_TAPCELL_ROW_29_698 VGND VPWR sky130_fd_sc_hd__tapvpwrvgnd_1
XFILLER_33_106 VGND VGND VPWR VPWR sky130_fd_sc_hd__fill_2
XFILLER_34_618 VGND VGND VPWR VPWR sky130_fd_sc_hd__fill_1
X_11804_ _04743_ _04747_ VGND VGND VPWR VPWR _04749_ sky130_fd_sc_hd__xnor2_1
XFILLER_33_128 VGND VGND VPWR VPWR sky130_fd_sc_hd__decap_3
X_12784_ _05703_ _05706_ _05817_ VGND VGND VPWR VPWR _05819_ sky130_fd_sc_hd__and3_1
X_11735_ _04671_ _04672_ VGND VGND VPWR VPWR _04673_ sky130_fd_sc_hd__xor2_1
XTAP_TAPCELL_ROW_64_1187 VGND VPWR sky130_fd_sc_hd__tapvpwrvgnd_1
XFILLER_128_701 VPWR VGND VPWR VGND sky130_ef_sc_hd__decap_12
X_13405_ clknet_3_7__leaf_clk _00051_ _00115_ VGND VGND VPWR VPWR net219 sky130_fd_sc_hd__dfrtp_1
X_11666_ _04593_ _04598_ VGND VGND VPWR VPWR _04599_ sky130_fd_sc_hd__nand2_1
XTAP_TAPCELL_ROW_40_852 VGND VPWR sky130_fd_sc_hd__tapvpwrvgnd_1
X_11597_ _04480_ _04495_ _04492_ VGND VGND VPWR VPWR _04527_ sky130_fd_sc_hd__o21a_1
X_10617_ _03454_ _03455_ VGND VGND VPWR VPWR _03457_ sky130_fd_sc_hd__and2b_1
X_10548_ _03337_ _03380_ VGND VGND VPWR VPWR _03381_ sky130_fd_sc_hd__nand2b_1
X_13336_ net393 VGND VGND VPWR VPWR _00110_ sky130_fd_sc_hd__inv_2
X_13267_ _06273_ _06274_ _06047_ VGND VGND VPWR VPWR _06346_ sky130_fd_sc_hd__mux2_1
X_10479_ _03302_ _03304_ _03284_ VGND VGND VPWR VPWR _03306_ sky130_fd_sc_hd__a21oi_1
X_12218_ _05196_ _05197_ VGND VGND VPWR VPWR _05201_ sky130_fd_sc_hd__xnor2_1
XPHY_EDGE_ROW_63_Left_200 VGND VGND VPWR VPWR sky130_fd_sc_hd__decap_3
X_13198_ _06131_ _06156_ _06155_ VGND VGND VPWR VPWR _06272_ sky130_fd_sc_hd__a21o_1
XFILLER_111_645 VGND VGND VPWR VPWR sky130_fd_sc_hd__decap_8
XFILLER_96_323 VPWR VGND VPWR VGND sky130_ef_sc_hd__decap_12
XFILLER_69_559 VGND VGND VPWR VPWR sky130_fd_sc_hd__fill_1
X_12149_ _04841_ _05124_ _04977_ _05125_ VGND VGND VPWR VPWR _05126_ sky130_fd_sc_hd__and4_1
XFILLER_2_41 VPWR VGND VPWR VGND sky130_ef_sc_hd__decap_12
X_06710_ net322 net267 VGND VGND VPWR VPWR _02371_ sky130_fd_sc_hd__nand2_1
XFILLER_49_261 VGND VGND VPWR VPWR sky130_fd_sc_hd__decap_4
XFILLER_2_85 VPWR VGND VPWR VGND sky130_ef_sc_hd__decap_12
XFILLER_37_412 VGND VGND VPWR VPWR sky130_fd_sc_hd__fill_2
XFILLER_37_434 VGND VGND VPWR VPWR sky130_fd_sc_hd__fill_2
X_07690_ _00272_ _00274_ _00426_ _00427_ VGND VGND VPWR VPWR _00430_ sky130_fd_sc_hd__o211ai_1
XTAP_TAPCELL_ROW_48_963 VGND VPWR sky130_fd_sc_hd__tapvpwrvgnd_1
XFILLER_25_607 VGND VGND VPWR VPWR sky130_fd_sc_hd__fill_2
XFILLER_64_253 VPWR VGND VPWR VGND sky130_ef_sc_hd__decap_12
XFILLER_52_415 VGND VGND VPWR VPWR sky130_fd_sc_hd__decap_4
XFILLER_24_106 VGND VGND VPWR VPWR sky130_fd_sc_hd__fill_2
X_09360_ net572 net544 net258 net256 VGND VGND VPWR VPWR _02091_ sky130_fd_sc_hd__and4_1
XFILLER_24_139 VGND VGND VPWR VPWR sky130_fd_sc_hd__fill_1
X_08311_ _00750_ _00966_ _00669_ VGND VGND VPWR VPWR _01045_ sky130_fd_sc_hd__o21a_1
X_09291_ _02006_ _02015_ VGND VGND VPWR VPWR _02016_ sky130_fd_sc_hd__xnor2_1
XFILLER_33_673 VPWR VGND VPWR VGND sky130_ef_sc_hd__decap_12
XANTENNA_13 net10 VGND VGND VPWR VPWR sky130_fd_sc_hd__diode_2
X_08242_ _00974_ _00976_ VGND VGND VPWR VPWR _00977_ sky130_fd_sc_hd__xnor2_1
XFILLER_60_470 VGND VGND VPWR VPWR sky130_fd_sc_hd__decap_6
XANTENNA_24 net424 VGND VGND VPWR VPWR sky130_fd_sc_hd__diode_2
X_08173_ _00459_ _00907_ VGND VGND VPWR VPWR _00909_ sky130_fd_sc_hd__xnor2_1
X_07124_ _06412_ _06413_ _06414_ VGND VGND VPWR VPWR _06416_ sky130_fd_sc_hd__a21o_1
XTAP_TAPCELL_ROW_95_1626 VGND VPWR sky130_fd_sc_hd__tapvpwrvgnd_1
XFILLER_134_737 VPWR VGND VPWR VGND sky130_ef_sc_hd__decap_12
XFILLER_133_225 VPWR VGND VPWR VGND sky130_ef_sc_hd__decap_12
XFILLER_133_214 VGND VGND VPWR VPWR sky130_fd_sc_hd__decap_8
X_07055_ net242 _06106_ _04537_ _04570_ VGND VGND VPWR VPWR _06128_ sky130_fd_sc_hd__o211a_1
Xoutput175 net175 VGND VGND VPWR VPWR out0[7] sky130_fd_sc_hd__buf_2
Xoutput164 net164 VGND VGND VPWR VPWR out0[11] sky130_fd_sc_hd__buf_2
Xoutput186 net186 VGND VGND VPWR VPWR out1[2] sky130_fd_sc_hd__buf_2
XFILLER_87_334 VGND VGND VPWR VPWR sky130_fd_sc_hd__fill_2
Xoutput197 net197 VGND VGND VPWR VPWR out2[12] sky130_fd_sc_hd__buf_2
X_07957_ _00693_ _00694_ VGND VGND VPWR VPWR _00695_ sky130_fd_sc_hd__nor2_1
XFILLER_101_177 VGND VGND VPWR VPWR sky130_fd_sc_hd__fill_1
XFILLER_101_166 VGND VGND VPWR VPWR sky130_fd_sc_hd__fill_2
X_06908_ _04439_ _04516_ _04450_ VGND VGND VPWR VPWR _04526_ sky130_fd_sc_hd__and3_4
X_07888_ _00509_ _00512_ VGND VGND VPWR VPWR _00626_ sky130_fd_sc_hd__nor2_1
XFILLER_55_231 VGND VGND VPWR VPWR sky130_fd_sc_hd__decap_3
X_06839_ _03248_ _03762_ VGND VGND VPWR VPWR _03773_ sky130_fd_sc_hd__and2_1
X_09627_ _02380_ _02379_ VGND VGND VPWR VPWR _02382_ sky130_fd_sc_hd__and2b_1
XFILLER_55_264 VPWR VGND VPWR VGND sky130_ef_sc_hd__decap_12
XFILLER_16_618 VGND VGND VPWR VPWR sky130_fd_sc_hd__decap_8
X_09558_ _02008_ _02200_ VGND VGND VPWR VPWR _02307_ sky130_fd_sc_hd__and2_1
XFILLER_43_437 VGND VGND VPWR VPWR sky130_fd_sc_hd__decap_3
XTAP_TAPCELL_ROW_104_1755 VGND VPWR sky130_fd_sc_hd__tapvpwrvgnd_1
XTAP_TAPCELL_ROW_104_1744 VGND VPWR sky130_fd_sc_hd__tapvpwrvgnd_1
X_08509_ net464 net455 net556 net554 VGND VGND VPWR VPWR _01238_ sky130_fd_sc_hd__and4_1
XTAP_TAPCELL_ROW_26_657 VGND VPWR sky130_fd_sc_hd__tapvpwrvgnd_1
X_09489_ _01916_ _02079_ _01917_ _02232_ VGND VGND VPWR VPWR _02233_ sky130_fd_sc_hd__o31a_1
XFILLER_11_323 VPWR VGND VPWR VGND sky130_ef_sc_hd__decap_12
X_11520_ _04339_ _04351_ _04350_ VGND VGND VPWR VPWR _04443_ sky130_fd_sc_hd__a21o_1
XFILLER_134_3 VPWR VGND VPWR VGND sky130_ef_sc_hd__decap_12
XFILLER_7_305 VPWR VGND VPWR VGND sky130_ef_sc_hd__decap_12
XFILLER_109_222 VGND VGND VPWR VPWR sky130_fd_sc_hd__fill_2
X_11451_ _04366_ _04367_ VGND VGND VPWR VPWR _04368_ sky130_fd_sc_hd__nor2_1
XFILLER_109_244 VGND VGND VPWR VPWR sky130_fd_sc_hd__fill_1
X_10402_ _03202_ _03221_ VGND VGND VPWR VPWR _03222_ sky130_fd_sc_hd__xor2_1
X_11382_ _04157_ _04158_ _04292_ VGND VGND VPWR VPWR _04293_ sky130_fd_sc_hd__a21o_1
XFILLER_7_349 VPWR VGND VPWR VGND sky130_ef_sc_hd__decap_12
XFILLER_124_225 VGND VGND VPWR VPWR sky130_fd_sc_hd__decap_3
XFILLER_109_288 VGND VGND VPWR VPWR sky130_fd_sc_hd__decap_3
XFILLER_109_277 VGND VGND VPWR VPWR sky130_fd_sc_hd__decap_3
X_10333_ _03137_ _03145_ net711 VGND VGND VPWR VPWR _03147_ sky130_fd_sc_hd__nand3_1
X_13121_ _06187_ _06178_ VGND VGND VPWR VPWR _06188_ sky130_fd_sc_hd__and2b_1
XFILLER_124_236 VGND VGND VPWR VPWR sky130_fd_sc_hd__decap_3
XFILLER_78_301 VGND VGND VPWR VPWR sky130_fd_sc_hd__fill_2
X_10264_ net639 net279 VGND VGND VPWR VPWR _03071_ sky130_fd_sc_hd__nand2_1
X_13052_ _05969_ _05982_ _06110_ VGND VGND VPWR VPWR _06112_ sky130_fd_sc_hd__nor3_1
XFILLER_87_76 VPWR VGND VPWR VGND sky130_ef_sc_hd__decap_12
X_12003_ net718 _04814_ net776 _04966_ VGND VGND VPWR VPWR _04967_ sky130_fd_sc_hd__o211a_4
X_10195_ net433 net579 _02993_ _02994_ VGND VGND VPWR VPWR _02996_ sky130_fd_sc_hd__a22o_1
XFILLER_120_486 VGND VGND VPWR VPWR sky130_fd_sc_hd__decap_8
XFILLER_93_337 VGND VGND VPWR VPWR sky130_fd_sc_hd__decap_4
Xfanout391 net34 VGND VGND VPWR VPWR net391 sky130_fd_sc_hd__buf_6
XTAP_TAPCELL_ROW_6_382 VGND VPWR sky130_fd_sc_hd__tapvpwrvgnd_1
XFILLER_19_423 VGND VGND VPWR VPWR sky130_fd_sc_hd__fill_1
Xfanout380 net4 VGND VGND VPWR VPWR net380 sky130_fd_sc_hd__buf_8
XFILLER_46_231 VGND VGND VPWR VPWR sky130_fd_sc_hd__decap_8
XTAP_TAPCELL_ROW_66_1216 VGND VPWR sky130_fd_sc_hd__tapvpwrvgnd_1
XTAP_TAPCELL_ROW_45_922 VGND VPWR sky130_fd_sc_hd__tapvpwrvgnd_1
X_12905_ _05950_ _05951_ VGND VGND VPWR VPWR _05952_ sky130_fd_sc_hd__nor2_1
XFILLER_46_297 VGND VGND VPWR VPWR sky130_fd_sc_hd__decap_8
X_12836_ net359 net360 VGND VGND VPWR VPWR _05876_ sky130_fd_sc_hd__and2b_1
XFILLER_34_448 VPWR VGND VPWR VGND sky130_ef_sc_hd__decap_12
XFILLER_15_673 VPWR VGND VPWR VGND sky130_ef_sc_hd__decap_12
X_12767_ _05707_ _05800_ VGND VGND VPWR VPWR _05802_ sky130_fd_sc_hd__xnor2_1
X_11718_ _04607_ _04653_ VGND VGND VPWR VPWR _04656_ sky130_fd_sc_hd__nor2_1
XFILLER_14_194 VGND VGND VPWR VPWR sky130_fd_sc_hd__fill_2
X_12698_ _05715_ _05725_ VGND VGND VPWR VPWR _05726_ sky130_fd_sc_hd__xnor2_1
XFILLER_30_643 VGND VGND VPWR VPWR sky130_fd_sc_hd__fill_1
Xinput11 in1[2] VGND VGND VPWR VPWR net11 sky130_fd_sc_hd__clkbuf_1
XFILLER_128_531 VGND VGND VPWR VPWR sky130_fd_sc_hd__fill_1
Xinput22 in2[5] VGND VGND VPWR VPWR net22 sky130_fd_sc_hd__clkbuf_2
X_11649_ net245 _04578_ _04580_ VGND VGND VPWR VPWR _04582_ sky130_fd_sc_hd__o21ai_1
Xinput44 w01[2] VGND VGND VPWR VPWR net44 sky130_fd_sc_hd__clkbuf_4
Xinput33 rst VGND VGND VPWR VPWR net33 sky130_fd_sc_hd__buf_4
Xinput55 w02[5] VGND VGND VPWR VPWR net55 sky130_fd_sc_hd__buf_1
Xinput66 w10[0] VGND VGND VPWR VPWR net66 sky130_fd_sc_hd__clkbuf_1
Xinput88 w12[6] VGND VGND VPWR VPWR net88 sky130_fd_sc_hd__buf_1
Xinput77 w11[3] VGND VGND VPWR VPWR net77 sky130_fd_sc_hd__buf_1
X_13319_ net397 VGND VGND VPWR VPWR _00093_ sky130_fd_sc_hd__inv_2
Xinput99 w20[1] VGND VGND VPWR VPWR net99 sky130_fd_sc_hd__clkbuf_2
XTAP_TAPCELL_ROW_77_1378 VGND VPWR sky130_fd_sc_hd__tapvpwrvgnd_1
XTAP_TAPCELL_ROW_77_1367 VGND VPWR sky130_fd_sc_hd__tapvpwrvgnd_1
XFILLER_131_729 VPWR VGND VPWR VGND sky130_ef_sc_hd__decap_12
XFILLER_124_781 VPWR VGND VPWR VGND sky130_ef_sc_hd__decap_12
X_08860_ _01585_ _01586_ VGND VGND VPWR VPWR _01587_ sky130_fd_sc_hd__and2b_1
XTAP_TAPCELL_ROW_90_1556 VGND VPWR sky130_fd_sc_hd__tapvpwrvgnd_1
X_07811_ _00535_ _00548_ VGND VGND VPWR VPWR _00550_ sky130_fd_sc_hd__xnor2_1
X_08791_ _01490_ _01517_ VGND VGND VPWR VPWR _01518_ sky130_fd_sc_hd__xor2_1
XFILLER_38_732 VPWR VGND VPWR VGND sky130_ef_sc_hd__decap_12
X_07742_ net505 _02153_ _00478_ _00479_ VGND VGND VPWR VPWR _00481_ sky130_fd_sc_hd__nor4_1
XFILLER_37_231 VPWR VGND VPWR VGND sky130_ef_sc_hd__decap_12
XFILLER_38_754 VGND VGND VPWR VPWR sky130_fd_sc_hd__fill_2
X_07673_ _00410_ _00411_ _00251_ _00254_ VGND VGND VPWR VPWR _00413_ sky130_fd_sc_hd__o211ai_2
XFILLER_38_798 VPWR VGND VPWR VGND sky130_ef_sc_hd__decap_12
XFILLER_92_381 VPWR VGND VPWR VGND sky130_ef_sc_hd__decap_12
X_09412_ _02002_ _02005_ VGND VGND VPWR VPWR _02148_ sky130_fd_sc_hd__nor2_1
X_09343_ _02071_ _02070_ _01751_ VGND VGND VPWR VPWR _02073_ sky130_fd_sc_hd__a21o_1
XFILLER_25_459 VGND VGND VPWR VPWR sky130_fd_sc_hd__decap_4
XFILLER_40_418 VGND VGND VPWR VPWR sky130_fd_sc_hd__fill_2
XTAP_TAPCELL_ROW_23_616 VGND VPWR sky130_fd_sc_hd__tapvpwrvgnd_1
X_09274_ _01967_ _01996_ VGND VGND VPWR VPWR _01998_ sky130_fd_sc_hd__xnor2_2
XFILLER_32_27 VGND VGND VPWR VPWR sky130_fd_sc_hd__fill_1
X_08225_ _00846_ _00856_ _00844_ VGND VGND VPWR VPWR _00960_ sky130_fd_sc_hd__o21a_1
XFILLER_120_9 VPWR VGND VPWR VGND sky130_ef_sc_hd__decap_12
XFILLER_119_553 VGND VGND VPWR VPWR sky130_fd_sc_hd__decap_6
X_08156_ _00770_ _00772_ VGND VGND VPWR VPWR _00892_ sky130_fd_sc_hd__nor2_1
XFILLER_5_809 VGND VGND VPWR VPWR sky130_fd_sc_hd__fill_2
XFILLER_20_186 VGND VGND VPWR VPWR sky130_fd_sc_hd__decap_8
XFILLER_134_501 VPWR VGND VPWR VGND sky130_ef_sc_hd__decap_12
XTAP_TAPCELL_ROW_132_2140 VGND VPWR sky130_fd_sc_hd__tapvpwrvgnd_1
X_07107_ _06381_ _06398_ VGND VGND VPWR VPWR _06399_ sky130_fd_sc_hd__xor2_1
XFILLER_106_203 VGND VGND VPWR VPWR sky130_fd_sc_hd__decap_3
XFILLER_134_545 VPWR VGND VPWR VGND sky130_ef_sc_hd__decap_12
X_08087_ _00822_ _00823_ VGND VGND VPWR VPWR _00824_ sky130_fd_sc_hd__nor2_1
XFILLER_106_225 VGND VGND VPWR VPWR sky130_fd_sc_hd__decap_4
XFILLER_106_7 VPWR VGND VPWR VGND sky130_ef_sc_hd__decap_12
XFILLER_134_589 VPWR VGND VPWR VGND sky130_ef_sc_hd__decap_12
XFILLER_121_217 VGND VGND VPWR VPWR sky130_fd_sc_hd__decap_6
X_07038_ _04199_ _04221_ _04210_ VGND VGND VPWR VPWR _05943_ sky130_fd_sc_hd__a21bo_1
XFILLER_88_643 VGND VGND VPWR VPWR sky130_fd_sc_hd__fill_1
XFILLER_87_120 VPWR VGND VPWR VGND sky130_ef_sc_hd__decap_12
XFILLER_76_805 VGND VGND VPWR VPWR sky130_fd_sc_hd__decap_3
XFILLER_102_475 VGND VGND VPWR VPWR sky130_fd_sc_hd__fill_1
XFILLER_75_337 VGND VGND VPWR VPWR sky130_fd_sc_hd__decap_8
X_08989_ _01713_ _01714_ VGND VGND VPWR VPWR _01715_ sky130_fd_sc_hd__and2b_1
XFILLER_29_721 VGND VGND VPWR VPWR sky130_fd_sc_hd__decap_6
XTAP_TAPCELL_ROW_3_341 VGND VPWR sky130_fd_sc_hd__tapvpwrvgnd_1
XTAP_TAPCELL_ROW_3_330 VGND VPWR sky130_fd_sc_hd__tapvpwrvgnd_1
XFILLER_113_63 VGND VGND VPWR VPWR sky130_fd_sc_hd__fill_1
X_10951_ net375 net343 VGND VGND VPWR VPWR _03822_ sky130_fd_sc_hd__nand2_1
XFILLER_28_242 VGND VGND VPWR VPWR sky130_fd_sc_hd__decap_8
X_10882_ net496 net647 net636 net503 VGND VGND VPWR VPWR _03746_ sky130_fd_sc_hd__a22o_1
X_12621_ _05639_ _05640_ _05580_ VGND VGND VPWR VPWR _05642_ sky130_fd_sc_hd__a21o_1
XPHY_EDGE_ROW_125_Right_125 VGND VGND VPWR VPWR sky130_fd_sc_hd__decap_3
XTAP_TAPCELL_ROW_61_1146 VGND VPWR sky130_fd_sc_hd__tapvpwrvgnd_1
XFILLER_24_492 VPWR VGND VPWR VGND sky130_ef_sc_hd__decap_12
X_12552_ _05195_ _05565_ VGND VGND VPWR VPWR _05566_ sky130_fd_sc_hd__xnor2_1
X_12483_ _05311_ _05362_ _05361_ VGND VGND VPWR VPWR _05490_ sky130_fd_sc_hd__a21oi_1
X_11503_ _03426_ _04302_ _04420_ VGND VGND VPWR VPWR _04424_ sky130_fd_sc_hd__or3_1
XFILLER_7_102 VGND VGND VPWR VPWR sky130_fd_sc_hd__decap_3
XFILLER_12_698 VGND VGND VPWR VPWR sky130_fd_sc_hd__fill_2
XTAP_TAPCELL_ROW_50_991 VGND VPWR sky130_fd_sc_hd__tapvpwrvgnd_1
X_11434_ _04217_ _04220_ _04223_ VGND VGND VPWR VPWR _04349_ sky130_fd_sc_hd__a21oi_1
XTAP_TAPCELL_ROW_117_1935 VGND VPWR sky130_fd_sc_hd__tapvpwrvgnd_1
XFILLER_22_82 VGND VGND VPWR VPWR sky130_fd_sc_hd__fill_2
XFILLER_125_534 VGND VGND VPWR VPWR sky130_fd_sc_hd__decap_8
X_11365_ _04237_ _04273_ VGND VGND VPWR VPWR _04274_ sky130_fd_sc_hd__xnor2_1
XFILLER_113_718 VGND VGND VPWR VPWR sky130_fd_sc_hd__decap_6
XFILLER_98_418 VGND VGND VPWR VPWR sky130_fd_sc_hd__fill_2
XFILLER_98_64 VPWR VGND VPWR VGND sky130_ef_sc_hd__decap_12
X_10316_ _02955_ _02957_ _03126_ VGND VGND VPWR VPWR _03128_ sky130_fd_sc_hd__nor3_1
X_11296_ _04190_ _04196_ VGND VGND VPWR VPWR _04198_ sky130_fd_sc_hd__xnor2_1
X_13104_ _06167_ _06168_ VGND VGND VPWR VPWR _06169_ sky130_fd_sc_hd__nor2_1
X_10247_ _03048_ _03051_ _02866_ VGND VGND VPWR VPWR _03054_ sky130_fd_sc_hd__a21oi_2
XFILLER_3_385 VGND VGND VPWR VPWR sky130_fd_sc_hd__decap_6
X_13035_ _06090_ _06093_ VGND VGND VPWR VPWR _00028_ sky130_fd_sc_hd__xor2_1
XTAP_TAPCELL_ROW_72_1297 VGND VPWR sky130_fd_sc_hd__tapvpwrvgnd_1
X_10178_ net513 net52 VGND VGND VPWR VPWR _02978_ sky130_fd_sc_hd__nand2_1
XFILLER_94_657 VPWR VGND VPWR VGND sky130_ef_sc_hd__decap_12
XFILLER_93_167 VGND VGND VPWR VPWR sky130_fd_sc_hd__fill_1
XFILLER_34_223 VGND VGND VPWR VPWR sky130_fd_sc_hd__fill_2
XFILLER_34_234 VGND VGND VPWR VPWR sky130_fd_sc_hd__fill_1
XFILLER_35_757 VPWR VGND VPWR VGND sky130_ef_sc_hd__decap_12
XFILLER_22_418 VGND VGND VPWR VPWR sky130_fd_sc_hd__fill_2
X_12819_ _05854_ _05857_ VGND VGND VPWR VPWR _05858_ sky130_fd_sc_hd__nor2_1
XTAP_TAPCELL_ROW_79_1407 VGND VPWR sky130_fd_sc_hd__tapvpwrvgnd_1
X_08010_ _00744_ _00745_ VGND VGND VPWR VPWR _00747_ sky130_fd_sc_hd__xnor2_1
XFILLER_128_361 VGND VGND VPWR VPWR sky130_fd_sc_hd__decap_3
XFILLER_116_512 VGND VGND VPWR VPWR sky130_fd_sc_hd__fill_2
XFILLER_128_394 VGND VGND VPWR VPWR sky130_fd_sc_hd__fill_1
XFILLER_116_556 VGND VGND VPWR VPWR sky130_fd_sc_hd__fill_2
X_09961_ _02528_ _02529_ _02203_ VGND VGND VPWR VPWR _02744_ sky130_fd_sc_hd__mux2_1
X_08912_ _01593_ _01636_ VGND VGND VPWR VPWR _01638_ sky130_fd_sc_hd__xnor2_1
XFILLER_134_29 VPWR VGND VPWR VGND sky130_ef_sc_hd__decap_12
XFILLER_131_559 VGND VGND VPWR VPWR sky130_fd_sc_hd__fill_1
X_09892_ _02668_ _02669_ VGND VGND VPWR VPWR _02670_ sky130_fd_sc_hd__nor2_1
XFILLER_69_131 VGND VGND VPWR VPWR sky130_fd_sc_hd__fill_2
X_08843_ _01430_ _01432_ _01568_ _01569_ VGND VGND VPWR VPWR _01570_ sky130_fd_sc_hd__o211ai_2
X_08774_ _01368_ _01370_ _01369_ VGND VGND VPWR VPWR _01501_ sky130_fd_sc_hd__o21bai_1
XFILLER_84_123 VGND VGND VPWR VPWR sky130_fd_sc_hd__decap_8
XFILLER_57_337 VPWR VGND VPWR VGND sky130_ef_sc_hd__decap_12
XFILLER_38_540 VGND VGND VPWR VPWR sky130_fd_sc_hd__decap_6
X_07725_ _00457_ _00463_ VGND VGND VPWR VPWR _00464_ sky130_fd_sc_hd__and2b_1
XFILLER_72_318 VGND VGND VPWR VPWR sky130_fd_sc_hd__fill_2
XFILLER_72_307 VGND VGND VPWR VPWR sky130_fd_sc_hd__fill_1
XTAP_TAPCELL_ROW_0_300 VGND VPWR sky130_fd_sc_hd__tapvpwrvgnd_1
XFILLER_26_713 VGND VGND VPWR VPWR sky130_fd_sc_hd__fill_1
XFILLER_26_757 VGND VGND VPWR VPWR sky130_fd_sc_hd__fill_1
X_07656_ net375 net381 _00238_ _00237_ VGND VGND VPWR VPWR _00396_ sky130_fd_sc_hd__a31o_1
XTAP_TAPCELL_ROW_101_1714 VGND VPWR sky130_fd_sc_hd__tapvpwrvgnd_1
XTAP_TAPCELL_ROW_101_1703 VGND VPWR sky130_fd_sc_hd__tapvpwrvgnd_1
X_07587_ _00216_ _00218_ VGND VGND VPWR VPWR _00327_ sky130_fd_sc_hd__nor2_1
XFILLER_13_418 VPWR VGND VPWR VGND sky130_ef_sc_hd__decap_12
XTAP_TAPCELL_ROW_36_796 VGND VPWR sky130_fd_sc_hd__tapvpwrvgnd_1
XFILLER_43_26 VGND VGND VPWR VPWR sky130_fd_sc_hd__decap_4
X_09326_ _02019_ _02052_ _02053_ VGND VGND VPWR VPWR _02054_ sky130_fd_sc_hd__nand3_1
X_09257_ _01977_ _01978_ _01979_ VGND VGND VPWR VPWR _01981_ sky130_fd_sc_hd__a21o_1
X_08208_ _06587_ _00942_ VGND VGND VPWR VPWR _00943_ sky130_fd_sc_hd__nand2_1
X_09188_ _01911_ _01745_ _01912_ VGND VGND VPWR VPWR _01913_ sky130_fd_sc_hd__and3_4
XFILLER_107_512 VPWR VGND VPWR VGND sky130_ef_sc_hd__decap_12
XFILLER_5_617 VPWR VGND VPWR VGND sky130_ef_sc_hd__decap_12
X_08139_ _00870_ _00873_ VGND VGND VPWR VPWR _00875_ sky130_fd_sc_hd__xor2_1
XFILLER_108_41 VGND VGND VPWR VPWR sky130_fd_sc_hd__decap_3
XTAP_TAPCELL_ROW_8_411 VGND VPWR sky130_fd_sc_hd__tapvpwrvgnd_1
XTAP_TAPCELL_ROW_8_400 VGND VPWR sky130_fd_sc_hd__tapvpwrvgnd_1
X_11150_ _04036_ _04038_ VGND VGND VPWR VPWR _04039_ sky130_fd_sc_hd__nor2_1
XFILLER_108_85 VGND VGND VPWR VPWR sky130_fd_sc_hd__fill_1
X_10101_ net638 net283 net280 net664 VGND VGND VPWR VPWR _02893_ sky130_fd_sc_hd__a22oi_1
XFILLER_0_300 VGND VGND VPWR VPWR sky130_fd_sc_hd__decap_4
XTAP_TAPCELL_ROW_112_1865 VGND VPWR sky130_fd_sc_hd__tapvpwrvgnd_1
XFILLER_88_440 VGND VGND VPWR VPWR sky130_fd_sc_hd__fill_1
X_11081_ _03956_ _03962_ VGND VGND VPWR VPWR _03964_ sky130_fd_sc_hd__xor2_2
XFILLER_130_581 VGND VGND VPWR VPWR sky130_fd_sc_hd__decap_6
XFILLER_88_473 VGND VGND VPWR VPWR sky130_fd_sc_hd__decap_3
XFILLER_76_613 VGND VGND VPWR VPWR sky130_fd_sc_hd__decap_8
X_10032_ _02787_ _02818_ VGND VGND VPWR VPWR _02819_ sky130_fd_sc_hd__nor2_1
XFILLER_75_134 VGND VGND VPWR VPWR sky130_fd_sc_hd__decap_3
XFILLER_0_399 VGND VGND VPWR VPWR sky130_fd_sc_hd__decap_3
XFILLER_84_55 VGND VGND VPWR VPWR sky130_fd_sc_hd__decap_6
XFILLER_17_702 VGND VGND VPWR VPWR sky130_fd_sc_hd__decap_8
XFILLER_90_115 VPWR VGND VPWR VGND sky130_ef_sc_hd__decap_12
XFILLER_84_99 VGND VGND VPWR VPWR sky130_fd_sc_hd__fill_1
XFILLER_84_77 VGND VGND VPWR VPWR sky130_fd_sc_hd__fill_1
X_11983_ _04942_ _04943_ _04944_ VGND VGND VPWR VPWR _04945_ sky130_fd_sc_hd__nand3_1
XFILLER_17_746 VGND VGND VPWR VPWR sky130_fd_sc_hd__decap_4
XFILLER_44_543 VGND VGND VPWR VPWR sky130_fd_sc_hd__decap_4
XFILLER_16_234 VGND VGND VPWR VPWR sky130_fd_sc_hd__decap_8
XFILLER_17_757 VGND VGND VPWR VPWR sky130_fd_sc_hd__fill_2
X_10934_ _03801_ _03802_ VGND VGND VPWR VPWR _03803_ sky130_fd_sc_hd__and2b_1
X_10865_ _03721_ _03726_ VGND VGND VPWR VPWR _03727_ sky130_fd_sc_hd__and2b_1
X_12604_ net379 net361 VGND VGND VPWR VPWR _05623_ sky130_fd_sc_hd__nand2_1
XFILLER_31_237 VPWR VGND VPWR VGND sky130_ef_sc_hd__decap_12
XFILLER_129_125 VPWR VGND VPWR VGND sky130_ef_sc_hd__decap_12
X_12535_ _05545_ _05546_ VGND VGND VPWR VPWR _05547_ sky130_fd_sc_hd__nand2b_1
X_10796_ _03649_ _03650_ _03651_ VGND VGND VPWR VPWR _03652_ sky130_fd_sc_hd__nand3_1
XFILLER_8_455 VGND VGND VPWR VPWR sky130_fd_sc_hd__fill_2
XFILLER_69_7 VPWR VGND VPWR VGND sky130_ef_sc_hd__decap_12
X_12466_ _05364_ _05468_ _05470_ VGND VGND VPWR VPWR _05472_ sky130_fd_sc_hd__nand3_1
XFILLER_8_477 VPWR VGND VPWR VGND sky130_ef_sc_hd__decap_12
XFILLER_125_320 VPWR VGND VPWR VGND sky130_ef_sc_hd__decap_12
X_11417_ _04327_ _04328_ VGND VGND VPWR VPWR _04331_ sky130_fd_sc_hd__xor2_1
X_12397_ _05393_ _05394_ VGND VGND VPWR VPWR _05397_ sky130_fd_sc_hd__and2b_1
XFILLER_125_353 VGND VGND VPWR VPWR sky130_fd_sc_hd__decap_4
XFILLER_98_204 VGND VGND VPWR VPWR sky130_fd_sc_hd__decap_4
XTAP_TAPCELL_ROW_74_1337 VGND VPWR sky130_fd_sc_hd__tapvpwrvgnd_1
XTAP_TAPCELL_ROW_74_1326 VGND VPWR sky130_fd_sc_hd__tapvpwrvgnd_1
X_11348_ _04111_ _04114_ _04110_ VGND VGND VPWR VPWR _04256_ sky130_fd_sc_hd__a21oi_1
XFILLER_98_215 VPWR VGND VPWR VGND sky130_ef_sc_hd__decap_12
XFILLER_79_440 VGND VGND VPWR VPWR sky130_fd_sc_hd__decap_8
XFILLER_3_193 VPWR VGND VPWR VGND sky130_ef_sc_hd__decap_12
X_11279_ _04173_ _04178_ VGND VGND VPWR VPWR _04180_ sky130_fd_sc_hd__xor2_1
XFILLER_121_581 VPWR VGND VPWR VGND sky130_ef_sc_hd__decap_12
XFILLER_67_613 VGND VGND VPWR VPWR sky130_fd_sc_hd__decap_3
X_13018_ _06038_ _06075_ VGND VGND VPWR VPWR _06076_ sky130_fd_sc_hd__xnor2_1
XFILLER_39_304 VPWR VGND VPWR VGND sky130_ef_sc_hd__decap_12
XFILLER_94_421 VPWR VGND VPWR VGND sky130_ef_sc_hd__decap_12
XFILLER_12_3 VPWR VGND VPWR VGND sky130_ef_sc_hd__decap_12
XFILLER_39_337 VGND VGND VPWR VPWR sky130_fd_sc_hd__decap_8
XFILLER_66_156 VGND VGND VPWR VPWR sky130_fd_sc_hd__decap_3
XFILLER_54_307 VGND VGND VPWR VPWR sky130_fd_sc_hd__fill_1
XFILLER_81_126 VGND VGND VPWR VPWR sky130_fd_sc_hd__fill_2
X_07510_ _06630_ _06632_ _00249_ _00250_ VGND VGND VPWR VPWR _00251_ sky130_fd_sc_hd__o211ai_4
XFILLER_47_370 VGND VGND VPWR VPWR sky130_fd_sc_hd__decap_4
X_08490_ net501 net634 net633 net509 VGND VGND VPWR VPWR _01219_ sky130_fd_sc_hd__a22o_1
XFILLER_23_705 VGND VGND VPWR VPWR sky130_fd_sc_hd__decap_3
XTAP_TAPCELL_ROW_85_1488 VGND VPWR sky130_fd_sc_hd__tapvpwrvgnd_1
X_07441_ net609 net418 _06591_ _06590_ VGND VGND VPWR VPWR _00182_ sky130_fd_sc_hd__a31o_1
X_07372_ _06547_ _06549_ _06661_ VGND VGND VPWR VPWR _06662_ sky130_fd_sc_hd__a21oi_2
XTAP_TAPCELL_ROW_33_755 VGND VPWR sky130_fd_sc_hd__tapvpwrvgnd_1
X_09111_ _01804_ _01834_ VGND VGND VPWR VPWR _01836_ sky130_fd_sc_hd__xnor2_1
X_09042_ _01765_ _01766_ VGND VGND VPWR VPWR _01767_ sky130_fd_sc_hd__xnor2_1
XFILLER_108_309 VGND VGND VPWR VPWR sky130_fd_sc_hd__decap_6
XFILLER_116_353 VGND VGND VPWR VPWR sky130_fd_sc_hd__fill_2
X_09944_ _02723_ _02724_ VGND VGND VPWR VPWR _02726_ sky130_fd_sc_hd__nand2_1
X_09875_ _02175_ net624 _02546_ VGND VGND VPWR VPWR _02651_ sky130_fd_sc_hd__a21o_1
XFILLER_100_743 VPWR VGND VPWR VGND sky130_ef_sc_hd__decap_12
XFILLER_97_281 VGND VGND VPWR VPWR sky130_fd_sc_hd__decap_6
X_08826_ net313 net340 net338 net335 VGND VGND VPWR VPWR _01553_ sky130_fd_sc_hd__a22oi_2
XTAP_TAPCELL_ROW_127_2072 VGND VPWR sky130_fd_sc_hd__tapvpwrvgnd_1
XFILLER_57_167 VGND VGND VPWR VPWR sky130_fd_sc_hd__fill_1
XFILLER_45_318 VGND VGND VPWR VPWR sky130_fd_sc_hd__decap_8
X_08757_ _01483_ _01481_ VGND VGND VPWR VPWR _01484_ sky130_fd_sc_hd__and2b_1
X_07708_ _00445_ _00446_ VGND VGND VPWR VPWR _00447_ sky130_fd_sc_hd__xnor2_1
X_08688_ _01413_ _01414_ _01415_ VGND VGND VPWR VPWR _01416_ sky130_fd_sc_hd__or3_4
XFILLER_26_565 VGND VGND VPWR VPWR sky130_fd_sc_hd__decap_4
X_07639_ net383 net332 net309 net385 VGND VGND VPWR VPWR _00379_ sky130_fd_sc_hd__a22o_1
XFILLER_26_587 VGND VGND VPWR VPWR sky130_fd_sc_hd__fill_1
XFILLER_41_513 VGND VGND VPWR VPWR sky130_fd_sc_hd__decap_8
XFILLER_110_42 VPWR VGND VPWR VGND sky130_ef_sc_hd__decap_12
X_10650_ _03384_ _03491_ VGND VGND VPWR VPWR _03493_ sky130_fd_sc_hd__xnor2_1
X_09309_ _01873_ _01878_ _01872_ VGND VGND VPWR VPWR _02036_ sky130_fd_sc_hd__a21bo_1
XFILLER_110_97 VGND VGND VPWR VPWR sky130_fd_sc_hd__decap_3
X_10581_ _03411_ _03413_ _03415_ VGND VGND VPWR VPWR _03417_ sky130_fd_sc_hd__a21o_1
XFILLER_126_117 VGND VGND VPWR VPWR sky130_fd_sc_hd__fill_1
X_12320_ _05184_ _05222_ _05219_ VGND VGND VPWR VPWR _05312_ sky130_fd_sc_hd__o21ba_1
XTAP_TAPCELL_ROW_11_449 VGND VPWR sky130_fd_sc_hd__tapvpwrvgnd_1
XFILLER_126_139 VGND VGND VPWR VPWR sky130_fd_sc_hd__fill_1
XFILLER_119_51 VGND VGND VPWR VPWR sky130_fd_sc_hd__decap_4
XFILLER_5_447 VGND VGND VPWR VPWR sky130_fd_sc_hd__fill_1
X_12251_ net698 _02284_ _05233_ _05235_ VGND VGND VPWR VPWR _05237_ sky130_fd_sc_hd__or4b_4
XFILLER_135_673 VPWR VGND VPWR VGND sky130_ef_sc_hd__decap_12
X_11202_ net400 net563 net561 VGND VGND VPWR VPWR _04096_ sky130_fd_sc_hd__and3_1
XFILLER_79_88 VPWR VGND VPWR VGND sky130_ef_sc_hd__decap_12
X_12182_ _05142_ _05160_ VGND VGND VPWR VPWR _05161_ sky130_fd_sc_hd__xnor2_2
XTAP_TAPCELL_ROW_56_1078 VGND VPWR sky130_fd_sc_hd__tapvpwrvgnd_1
XFILLER_1_653 VPWR VGND VPWR VGND sky130_ef_sc_hd__decap_12
X_11133_ _03708_ _03885_ _03883_ VGND VGND VPWR VPWR _04020_ sky130_fd_sc_hd__a21oi_1
XFILLER_110_518 VPWR VGND VPWR VGND sky130_ef_sc_hd__decap_12
XFILLER_89_771 VPWR VGND VPWR VGND sky130_ef_sc_hd__decap_12
XFILLER_48_101 VGND VGND VPWR VPWR sky130_fd_sc_hd__decap_4
XFILLER_0_141 VPWR VGND VPWR VGND sky130_ef_sc_hd__decap_12
X_11064_ net286 net348 net346 net308 VGND VGND VPWR VPWR _03945_ sky130_fd_sc_hd__a22oi_1
XFILLER_103_581 VGND VGND VPWR VPWR sky130_fd_sc_hd__decap_3
XFILLER_76_421 VPWR VGND VPWR VGND sky130_ef_sc_hd__decap_12
X_10015_ net526 net655 VGND VGND VPWR VPWR _02800_ sky130_fd_sc_hd__nand2_1
XFILLER_49_657 VGND VGND VPWR VPWR sky130_fd_sc_hd__decap_4
XFILLER_48_123 VGND VGND VPWR VPWR sky130_fd_sc_hd__decap_8
XFILLER_1_697 VPWR VGND VPWR VGND sky130_ef_sc_hd__decap_12
XFILLER_95_98 VGND VGND VPWR VPWR sky130_fd_sc_hd__fill_2
XFILLER_49_668 VGND VGND VPWR VPWR sky130_fd_sc_hd__decap_4
XFILLER_36_318 VGND VGND VPWR VPWR sky130_fd_sc_hd__decap_3
X_11966_ _04915_ _04925_ VGND VGND VPWR VPWR _04926_ sky130_fd_sc_hd__xnor2_1
XFILLER_17_532 VPWR VGND VPWR VGND sky130_ef_sc_hd__decap_12
X_10917_ net442 net560 _03782_ _03783_ VGND VGND VPWR VPWR _03785_ sky130_fd_sc_hd__o2bb2a_1
XFILLER_71_181 VGND VGND VPWR VPWR sky130_fd_sc_hd__fill_1
X_11897_ _04849_ _04850_ VGND VGND VPWR VPWR _04852_ sky130_fd_sc_hd__nor2_1
XFILLER_32_546 VGND VGND VPWR VPWR sky130_fd_sc_hd__fill_1
XFILLER_9_720 VGND VGND VPWR VPWR sky130_fd_sc_hd__decap_8
X_10848_ net638 net273 _02230_ net663 VGND VGND VPWR VPWR _03709_ sky130_fd_sc_hd__o2bb2a_1
XFILLER_9_753 VPWR VGND VPWR VGND sky130_ef_sc_hd__decap_12
XTAP_TAPCELL_ROW_30_714 VGND VPWR sky130_fd_sc_hd__tapvpwrvgnd_1
X_10779_ _03625_ _03633_ VGND VGND VPWR VPWR _03634_ sky130_fd_sc_hd__xor2_1
XFILLER_12_292 VGND VGND VPWR VPWR sky130_fd_sc_hd__decap_8
X_12518_ _05520_ _05526_ VGND VGND VPWR VPWR _05529_ sky130_fd_sc_hd__xor2_1
XFILLER_9_797 VPWR VGND VPWR VGND sky130_ef_sc_hd__decap_12
X_12449_ _05448_ _05449_ _05450_ VGND VGND VPWR VPWR _05454_ sky130_fd_sc_hd__a21o_1
XFILLER_132_109 VPWR VGND VPWR VGND sky130_ef_sc_hd__decap_12
XFILLER_99_535 VGND VGND VPWR VPWR sky130_fd_sc_hd__decap_8
X_07990_ _00716_ _00726_ VGND VGND VPWR VPWR _00727_ sky130_fd_sc_hd__xnor2_1
X_06941_ _03357_ _03686_ VGND VGND VPWR VPWR _04883_ sky130_fd_sc_hd__nand2_1
XFILLER_113_389 VGND VGND VPWR VPWR sky130_fd_sc_hd__decap_3
XFILLER_39_101 VGND VGND VPWR VPWR sky130_fd_sc_hd__decap_8
X_09660_ _02336_ _02348_ _02347_ VGND VGND VPWR VPWR _02417_ sky130_fd_sc_hd__o21ai_1
XFILLER_95_785 VGND VGND VPWR VPWR sky130_fd_sc_hd__decap_6
X_08611_ _01338_ _01339_ VGND VGND VPWR VPWR _00058_ sky130_fd_sc_hd__and2_1
X_06872_ _04068_ _04101_ VGND VGND VPWR VPWR _04134_ sky130_fd_sc_hd__nor2_1
XTAP_TAPCELL_ROW_87_1517 VGND VPWR sky130_fd_sc_hd__tapvpwrvgnd_1
XTAP_TAPCELL_ROW_87_1506 VGND VPWR sky130_fd_sc_hd__tapvpwrvgnd_1
XFILLER_39_167 VGND VGND VPWR VPWR sky130_fd_sc_hd__fill_1
X_09591_ _02339_ _02342_ VGND VGND VPWR VPWR _02343_ sky130_fd_sc_hd__and2b_1
XTAP_TAPCELL_ROW_38_825 VGND VPWR sky130_fd_sc_hd__tapvpwrvgnd_1
X_08542_ net700 net60 _01125_ _01124_ VGND VGND VPWR VPWR _01271_ sky130_fd_sc_hd__a31o_1
XFILLER_54_137 VGND VGND VPWR VPWR sky130_fd_sc_hd__decap_3
X_08473_ _01197_ _01200_ VGND VGND VPWR VPWR _01202_ sky130_fd_sc_hd__xor2_1
X_07424_ _06578_ _06580_ VGND VGND VPWR VPWR _00165_ sky130_fd_sc_hd__nand2_1
XFILLER_50_365 VPWR VGND VPWR VGND sky130_ef_sc_hd__decap_12
X_07355_ _06643_ _06644_ VGND VGND VPWR VPWR _06646_ sky130_fd_sc_hd__xor2_2
XFILLER_109_629 VPWR VGND VPWR VGND sky130_ef_sc_hd__decap_12
X_07286_ _06421_ _06576_ VGND VGND VPWR VPWR _06577_ sky130_fd_sc_hd__nor2_1
XFILLER_40_27 VGND VGND VPWR VPWR sky130_fd_sc_hd__fill_1
X_09025_ _01600_ _01616_ _01614_ VGND VGND VPWR VPWR _01750_ sky130_fd_sc_hd__o21a_1
XTAP_TAPCELL_ROW_98_1668 VGND VPWR sky130_fd_sc_hd__tapvpwrvgnd_1
XFILLER_117_673 VPWR VGND VPWR VGND sky130_ef_sc_hd__decap_12
XFILLER_116_161 VPWR VGND VPWR VGND sky130_ef_sc_hd__decap_12
XFILLER_132_643 VGND VGND VPWR VPWR sky130_fd_sc_hd__fill_1
XFILLER_116_194 VGND VGND VPWR VPWR sky130_fd_sc_hd__fill_2
XFILLER_104_356 VGND VGND VPWR VPWR sky130_fd_sc_hd__decap_8
XTAP_TAPCELL_ROW_129_2101 VGND VPWR sky130_fd_sc_hd__tapvpwrvgnd_1
X_09927_ _02574_ _02609_ _02573_ VGND VGND VPWR VPWR _02709_ sky130_fd_sc_hd__a21oi_1
XFILLER_58_421 VPWR VGND VPWR VGND sky130_ef_sc_hd__decap_12
XFILLER_105_53 VGND VGND VPWR VPWR sky130_fd_sc_hd__decap_3
X_09858_ _01676_ _02632_ VGND VGND VPWR VPWR _02633_ sky130_fd_sc_hd__xnor2_1
XFILLER_18_307 VGND VGND VPWR VPWR sky130_fd_sc_hd__fill_1
XFILLER_100_595 VGND VGND VPWR VPWR sky130_fd_sc_hd__decap_3
X_09789_ _02557_ _02553_ VGND VGND VPWR VPWR _02558_ sky130_fd_sc_hd__nand2b_1
X_08809_ _01405_ _01534_ _01535_ VGND VGND VPWR VPWR _01536_ sky130_fd_sc_hd__and3_1
X_11820_ net357 net370 net368 net783 VGND VGND VPWR VPWR _04767_ sky130_fd_sc_hd__a22oi_2
XTAP_TAPCELL_ROW_107_1786 VGND VPWR sky130_fd_sc_hd__tapvpwrvgnd_1
X_11751_ _04689_ _04690_ net665 net298 VGND VGND VPWR VPWR _04691_ sky130_fd_sc_hd__and4bb_1
XFILLER_60_118 VPWR VGND VPWR VGND sky130_ef_sc_hd__decap_12
XTAP_TAPCELL_ROW_16_519 VGND VPWR sky130_fd_sc_hd__tapvpwrvgnd_1
XFILLER_26_362 VGND VGND VPWR VPWR sky130_fd_sc_hd__fill_2
XTAP_TAPCELL_ROW_107_1797 VGND VPWR sky130_fd_sc_hd__tapvpwrvgnd_1
XFILLER_14_546 VGND VGND VPWR VPWR sky130_fd_sc_hd__fill_2
X_10702_ _03540_ _03547_ VGND VGND VPWR VPWR _03549_ sky130_fd_sc_hd__nand2b_1
XFILLER_41_321 VPWR VGND VPWR VGND sky130_ef_sc_hd__decap_12
X_11682_ net516 net789 net370 net368 VGND VGND VPWR VPWR _04616_ sky130_fd_sc_hd__and4_1
XFILLER_14_568 VPWR VGND VPWR VGND sky130_ef_sc_hd__decap_12
XFILLER_41_376 VGND VGND VPWR VPWR sky130_fd_sc_hd__fill_1
XTAP_TAPCELL_ROW_120_1975 VGND VPWR sky130_fd_sc_hd__tapvpwrvgnd_1
X_10633_ _03471_ _03472_ VGND VGND VPWR VPWR _03474_ sky130_fd_sc_hd__xnor2_1
X_13352_ net399 VGND VGND VPWR VPWR _00126_ sky130_fd_sc_hd__inv_2
X_10564_ _03232_ _03234_ VGND VGND VPWR VPWR _03398_ sky130_fd_sc_hd__nand2_1
XFILLER_6_701 VPWR VGND VPWR VGND sky130_ef_sc_hd__decap_12
XTAP_TAPCELL_ROW_58_1107 VGND VPWR sky130_fd_sc_hd__tapvpwrvgnd_1
X_12303_ _05292_ _05293_ VGND VGND VPWR VPWR _05294_ sky130_fd_sc_hd__or2_1
XFILLER_108_640 VGND VGND VPWR VPWR sky130_fd_sc_hd__decap_4
X_10495_ _03321_ _03320_ _03184_ VGND VGND VPWR VPWR _03323_ sky130_fd_sc_hd__a21o_1
X_13283_ _06272_ _06294_ _06295_ _06298_ VGND VGND VPWR VPWR _06363_ sky130_fd_sc_hd__a31o_1
XFILLER_114_109 VGND VGND VPWR VPWR sky130_fd_sc_hd__decap_4
X_12234_ _05215_ _05216_ _05202_ VGND VGND VPWR VPWR _05218_ sky130_fd_sc_hd__a21o_1
XFILLER_123_654 VGND VGND VPWR VPWR sky130_fd_sc_hd__decap_4
X_12165_ _05141_ VGND VGND VPWR VPWR _05142_ sky130_fd_sc_hd__inv_2
XFILLER_1_461 VPWR VGND VPWR VGND sky130_ef_sc_hd__decap_12
X_11116_ _03907_ _04001_ VGND VGND VPWR VPWR _04002_ sky130_fd_sc_hd__xnor2_1
XFILLER_110_348 VGND VGND VPWR VPWR sky130_fd_sc_hd__decap_8
X_12096_ _04917_ _04919_ _04918_ VGND VGND VPWR VPWR _05068_ sky130_fd_sc_hd__o21bai_1
XFILLER_49_421 VGND VGND VPWR VPWR sky130_fd_sc_hd__fill_1
XFILLER_77_785 VPWR VGND VPWR VGND sky130_ef_sc_hd__decap_12
XFILLER_77_752 VGND VGND VPWR VPWR sky130_fd_sc_hd__fill_2
X_11047_ net450 _03586_ _03589_ _03766_ VGND VGND VPWR VPWR _03927_ sky130_fd_sc_hd__a2bb2o_1
XFILLER_49_487 VPWR VGND VPWR VGND sky130_ef_sc_hd__decap_12
Xinput9 in1[0] VGND VGND VPWR VPWR net9 sky130_fd_sc_hd__clkbuf_2
XFILLER_92_755 VGND VGND VPWR VPWR sky130_fd_sc_hd__fill_1
XTAP_TAPCELL_ROW_69_1258 VGND VPWR sky130_fd_sc_hd__tapvpwrvgnd_1
XFILLER_91_276 VGND VGND VPWR VPWR sky130_fd_sc_hd__decap_4
XFILLER_51_118 VGND VGND VPWR VPWR sky130_fd_sc_hd__fill_1
XFILLER_45_671 VGND VGND VPWR VPWR sky130_fd_sc_hd__fill_1
XFILLER_17_351 VGND VGND VPWR VPWR sky130_fd_sc_hd__decap_3
XFILLER_17_373 VPWR VGND VPWR VGND sky130_ef_sc_hd__decap_12
X_12998_ _06051_ _06053_ VGND VGND VPWR VPWR _06054_ sky130_fd_sc_hd__nand2_1
XTAP_TAPCELL_ROW_82_1447 VGND VPWR sky130_fd_sc_hd__tapvpwrvgnd_1
XTAP_TAPCELL_ROW_82_1436 VGND VPWR sky130_fd_sc_hd__tapvpwrvgnd_1
XFILLER_60_630 VGND VGND VPWR VPWR sky130_fd_sc_hd__fill_1
X_11949_ _04899_ _04907_ VGND VGND VPWR VPWR _04908_ sky130_fd_sc_hd__xnor2_1
XTAP_TAPCELL_ROW_43_894 VGND VPWR sky130_fd_sc_hd__tapvpwrvgnd_1
XFILLER_20_527 VGND VGND VPWR VPWR sky130_fd_sc_hd__decap_4
X_07140_ _05659_ _05746_ _05735_ VGND VGND VPWR VPWR _06432_ sky130_fd_sc_hd__o21ba_1
XFILLER_9_561 VGND VGND VPWR VPWR sky130_fd_sc_hd__fill_1
X_07071_ _06292_ _06281_ VGND VGND VPWR VPWR _06303_ sky130_fd_sc_hd__or2_4
XFILLER_118_459 VGND VGND VPWR VPWR sky130_fd_sc_hd__decap_8
XFILLER_126_492 VGND VGND VPWR VPWR sky130_fd_sc_hd__fill_1
XFILLER_114_665 VGND VGND VPWR VPWR sky130_fd_sc_hd__decap_6
XFILLER_113_142 VGND VGND VPWR VPWR sky130_fd_sc_hd__decap_3
XFILLER_102_805 VGND VGND VPWR VPWR sky130_fd_sc_hd__decap_3
XTAP_TAPCELL_ROW_93_1598 VGND VPWR sky130_fd_sc_hd__tapvpwrvgnd_1
X_07973_ _00708_ _00709_ VGND VGND VPWR VPWR _00710_ sky130_fd_sc_hd__and2b_1
X_09712_ _02465_ _02473_ VGND VGND VPWR VPWR _02474_ sky130_fd_sc_hd__xnor2_1
XFILLER_101_326 VGND VGND VPWR VPWR sky130_fd_sc_hd__decap_6
X_06924_ _03915_ net936 _04675_ VGND VGND VPWR VPWR _04697_ sky130_fd_sc_hd__or3_4
XFILLER_68_774 VGND VGND VPWR VPWR sky130_fd_sc_hd__decap_6
X_06855_ net611 net452 net609 net444 VGND VGND VPWR VPWR _03948_ sky130_fd_sc_hd__and4_1
XFILLER_82_210 VGND VGND VPWR VPWR sky130_fd_sc_hd__decap_6
X_09643_ _02396_ _02397_ VGND VGND VPWR VPWR _02399_ sky130_fd_sc_hd__xnor2_1
XFILLER_28_627 VGND VGND VPWR VPWR sky130_fd_sc_hd__decap_3
XFILLER_28_649 VGND VGND VPWR VPWR sky130_fd_sc_hd__fill_1
XTAP_TAPCELL_ROW_124_2031 VGND VPWR sky130_fd_sc_hd__tapvpwrvgnd_1
X_09574_ net493 net487 net626 net625 VGND VGND VPWR VPWR _02324_ sky130_fd_sc_hd__and4_1
XFILLER_83_777 VGND VGND VPWR VPWR sky130_fd_sc_hd__decap_6
XFILLER_82_221 VGND VGND VPWR VPWR sky130_fd_sc_hd__fill_1
X_06786_ _03183_ VGND VGND VPWR VPWR _03194_ sky130_fd_sc_hd__inv_2
X_08525_ net699 net518 net330 net327 VGND VGND VPWR VPWR _01254_ sky130_fd_sc_hd__and4_1
XFILLER_42_118 VPWR VGND VPWR VGND sky130_ef_sc_hd__decap_12
XFILLER_51_641 VGND VGND VPWR VPWR sky130_fd_sc_hd__decap_6
X_08456_ net669 net644 net265 net263 VGND VGND VPWR VPWR _01185_ sky130_fd_sc_hd__and4_1
XFILLER_11_505 VGND VGND VPWR VPWR sky130_fd_sc_hd__decap_6
X_07407_ net571 _00147_ _00146_ VGND VGND VPWR VPWR _00148_ sky130_fd_sc_hd__a21oi_1
X_08387_ net270 net692 net265 net263 VGND VGND VPWR VPWR _01118_ sky130_fd_sc_hd__and4_1
XFILLER_50_162 VPWR VGND VPWR VGND sky130_ef_sc_hd__decap_12
X_07338_ _06471_ _06463_ _06470_ VGND VGND VPWR VPWR _06629_ sky130_fd_sc_hd__a21boi_2
XTAP_TAPCELL_ROW_21_588 VGND VPWR sky130_fd_sc_hd__tapvpwrvgnd_1
XFILLER_136_245 VGND VGND VPWR VPWR sky130_fd_sc_hd__decap_3
XTAP_TAPCELL_ROW_135_2182 VGND VPWR sky130_fd_sc_hd__tapvpwrvgnd_1
X_07269_ _06557_ _06558_ VGND VGND VPWR VPWR _06560_ sky130_fd_sc_hd__xnor2_1
XFILLER_117_481 VGND VGND VPWR VPWR sky130_fd_sc_hd__fill_1
X_09008_ _01732_ _01733_ VGND VGND VPWR VPWR _01734_ sky130_fd_sc_hd__and2b_1
XFILLER_105_610 VGND VGND VPWR VPWR sky130_fd_sc_hd__fill_2
X_10280_ net526 net649 VGND VGND VPWR VPWR _03089_ sky130_fd_sc_hd__nand2_1
XFILLER_132_473 VGND VGND VPWR VPWR sky130_fd_sc_hd__decap_3
XFILLER_116_41 VPWR VGND VPWR VGND sky130_ef_sc_hd__decap_12
XFILLER_105_665 VGND VGND VPWR VPWR sky130_fd_sc_hd__decap_6
XFILLER_78_516 VGND VGND VPWR VPWR sky130_fd_sc_hd__fill_1
XTAP_TAPCELL_ROW_53_1037 VGND VPWR sky130_fd_sc_hd__tapvpwrvgnd_1
XFILLER_116_85 VGND VGND VPWR VPWR sky130_fd_sc_hd__decap_4
Xfanout551 net158 VGND VGND VPWR VPWR net551 sky130_fd_sc_hd__clkbuf_2
Xfanout540 net547 VGND VGND VPWR VPWR net540 sky130_fd_sc_hd__dlymetal6s2s_1
Xfanout573 net15 VGND VGND VPWR VPWR net573 sky130_fd_sc_hd__buf_2
XFILLER_120_657 VGND VGND VPWR VPWR sky130_fd_sc_hd__decap_6
XFILLER_116_96 VPWR VGND VPWR VGND sky130_ef_sc_hd__decap_12
Xfanout562 net151 VGND VGND VPWR VPWR net562 sky130_fd_sc_hd__buf_1
Xfanout584 net143 VGND VGND VPWR VPWR net584 sky130_fd_sc_hd__buf_1
Xfanout595 net14 VGND VGND VPWR VPWR net595 sky130_fd_sc_hd__clkbuf_2
XTAP_TAPCELL_ROW_109_1826 VGND VPWR sky130_fd_sc_hd__tapvpwrvgnd_1
XTAP_TAPCELL_ROW_109_1815 VGND VPWR sky130_fd_sc_hd__tapvpwrvgnd_1
XFILLER_100_370 VPWR VGND VPWR VGND sky130_ef_sc_hd__decap_12
XFILLER_59_785 VGND VGND VPWR VPWR sky130_fd_sc_hd__decap_6
XFILLER_58_273 VPWR VGND VPWR VGND sky130_ef_sc_hd__decap_12
X_12921_ _05968_ _05967_ VGND VGND VPWR VPWR _05969_ sky130_fd_sc_hd__and2b_1
XFILLER_19_638 VGND VGND VPWR VPWR sky130_fd_sc_hd__fill_1
XFILLER_18_159 VGND VGND VPWR VPWR sky130_fd_sc_hd__fill_1
XFILLER_73_265 VGND VGND VPWR VPWR sky130_fd_sc_hd__fill_2
XFILLER_61_405 VPWR VGND VPWR VGND sky130_ef_sc_hd__decap_12
X_12852_ net404 net585 net583 VGND VGND VPWR VPWR _05894_ sky130_fd_sc_hd__and3_1
XFILLER_27_671 VGND VGND VPWR VPWR sky130_fd_sc_hd__fill_1
XFILLER_92_66 VGND VGND VPWR VPWR sky130_fd_sc_hd__decap_8
XFILLER_92_55 VGND VGND VPWR VPWR sky130_fd_sc_hd__decap_4
XFILLER_61_449 VGND VGND VPWR VPWR sky130_fd_sc_hd__fill_2
X_11803_ _04747_ _04743_ VGND VGND VPWR VPWR _04748_ sky130_fd_sc_hd__and2b_1
XFILLER_14_321 VPWR VGND VPWR VGND sky130_ef_sc_hd__decap_12
XTAP_TAPCELL_ROW_29_699 VGND VPWR sky130_fd_sc_hd__tapvpwrvgnd_1
X_12783_ _05703_ _05706_ _05817_ VGND VGND VPWR VPWR _05818_ sky130_fd_sc_hd__a21oi_1
X_11734_ _04594_ _04636_ _04638_ VGND VGND VPWR VPWR _04672_ sky130_fd_sc_hd__o21ai_1
XPHY_EDGE_ROW_1_Left_138 VGND VGND VPWR VPWR sky130_fd_sc_hd__decap_3
XFILLER_14_354 VGND VGND VPWR VPWR sky130_fd_sc_hd__decap_8
XFILLER_14_365 VGND VGND VPWR VPWR sky130_fd_sc_hd__decap_4
XFILLER_25_71 VPWR VGND VPWR VGND sky130_ef_sc_hd__decap_12
XFILLER_42_641 VGND VGND VPWR VPWR sky130_fd_sc_hd__decap_3
X_11665_ _04597_ VGND VGND VPWR VPWR _04598_ sky130_fd_sc_hd__inv_2
XTAP_TAPCELL_ROW_64_1188 VGND VPWR sky130_fd_sc_hd__tapvpwrvgnd_1
XFILLER_128_713 VPWR VGND VPWR VGND sky130_ef_sc_hd__decap_12
X_13404_ clknet_3_7__leaf_clk _00011_ _00114_ VGND VGND VPWR VPWR net218 sky130_fd_sc_hd__dfrtp_1
X_10616_ _03452_ _03453_ _03449_ VGND VGND VPWR VPWR _03455_ sky130_fd_sc_hd__a21o_1
XTAP_TAPCELL_ROW_40_853 VGND VPWR sky130_fd_sc_hd__tapvpwrvgnd_1
XFILLER_128_757 VPWR VGND VPWR VGND sky130_ef_sc_hd__decap_12
XFILLER_127_223 VGND VGND VPWR VPWR sky130_fd_sc_hd__fill_1
X_11596_ _04366_ _04479_ _04477_ VGND VGND VPWR VPWR _04525_ sky130_fd_sc_hd__a21o_1
X_10547_ _03362_ _03378_ VGND VGND VPWR VPWR _03380_ sky130_fd_sc_hd__xnor2_1
XFILLER_6_531 VGND VGND VPWR VPWR sky130_fd_sc_hd__fill_1
X_13335_ net393 VGND VGND VPWR VPWR _00109_ sky130_fd_sc_hd__inv_2
XFILLER_51_7 VGND VGND VPWR VPWR sky130_fd_sc_hd__fill_1
X_10478_ _03284_ _03302_ _03304_ VGND VGND VPWR VPWR _03305_ sky130_fd_sc_hd__and3_1
X_13266_ _06283_ _06287_ _06289_ VGND VGND VPWR VPWR _06344_ sky130_fd_sc_hd__a21oi_1
X_12217_ _05196_ _05197_ VGND VGND VPWR VPWR _05200_ sky130_fd_sc_hd__or2_1
XFILLER_97_803 VGND VGND VPWR VPWR sky130_fd_sc_hd__fill_1
XFILLER_69_505 VPWR VGND VPWR VGND sky130_ef_sc_hd__decap_12
X_13197_ _06190_ _06192_ VGND VGND VPWR VPWR _06271_ sky130_fd_sc_hd__and2b_1
XFILLER_123_484 VGND VGND VPWR VPWR sky130_fd_sc_hd__fill_1
XFILLER_96_335 VGND VGND VPWR VPWR sky130_fd_sc_hd__fill_2
X_12148_ _05122_ _05121_ _04972_ _04974_ VGND VGND VPWR VPWR _05125_ sky130_fd_sc_hd__a211o_1
XFILLER_2_781 VPWR VGND VPWR VGND sky130_ef_sc_hd__decap_12
XFILLER_110_145 VGND VGND VPWR VPWR sky130_fd_sc_hd__fill_1
X_12079_ _05040_ _05048_ VGND VGND VPWR VPWR _05050_ sky130_fd_sc_hd__xor2_1
XFILLER_49_251 VGND VGND VPWR VPWR sky130_fd_sc_hd__decap_3
XPHY_EDGE_ROW_10_Right_10 VGND VGND VPWR VPWR sky130_fd_sc_hd__decap_3
XFILLER_2_53 VPWR VGND VPWR VGND sky130_ef_sc_hd__decap_12
XFILLER_110_178 VPWR VGND VPWR VGND sky130_ef_sc_hd__decap_12
XFILLER_65_744 VPWR VGND VPWR VGND sky130_ef_sc_hd__decap_12
XFILLER_64_221 VGND VGND VPWR VPWR sky130_fd_sc_hd__fill_2
XFILLER_2_97 VPWR VGND VPWR VGND sky130_ef_sc_hd__decap_12
XFILLER_80_725 VGND VGND VPWR VPWR sky130_fd_sc_hd__decap_3
XFILLER_64_265 VGND VGND VPWR VPWR sky130_fd_sc_hd__decap_8
XTAP_TAPCELL_ROW_48_964 VGND VPWR sky130_fd_sc_hd__tapvpwrvgnd_1
XFILLER_17_181 VGND VGND VPWR VPWR sky130_fd_sc_hd__decap_4
X_08310_ _00990_ _00991_ _00785_ VGND VGND VPWR VPWR _01044_ sky130_fd_sc_hd__mux2_1
X_09290_ _02012_ _02013_ VGND VGND VPWR VPWR _02015_ sky130_fd_sc_hd__xnor2_1
XFILLER_33_641 VGND VGND VPWR VPWR sky130_fd_sc_hd__fill_1
XFILLER_33_652 VGND VGND VPWR VPWR sky130_fd_sc_hd__decap_4
XANTENNA_14 net15 VGND VGND VPWR VPWR sky130_fd_sc_hd__diode_2
X_08241_ _00975_ VGND VGND VPWR VPWR _00976_ sky130_fd_sc_hd__inv_2
XFILLER_20_324 VGND VGND VPWR VPWR sky130_fd_sc_hd__fill_2
XFILLER_33_685 VGND VGND VPWR VPWR sky130_fd_sc_hd__decap_4
XFILLER_33_696 VGND VGND VPWR VPWR sky130_fd_sc_hd__decap_6
XANTENNA_25 net441 VGND VGND VPWR VPWR sky130_fd_sc_hd__diode_2
XFILLER_32_184 VGND VGND VPWR VPWR sky130_fd_sc_hd__decap_3
XFILLER_118_212 VGND VGND VPWR VPWR sky130_fd_sc_hd__decap_4
X_08172_ _00459_ _00907_ VGND VGND VPWR VPWR _00908_ sky130_fd_sc_hd__nand2_1
XFILLER_119_757 VGND VGND VPWR VPWR sky130_fd_sc_hd__fill_1
X_07123_ _06412_ _06413_ _06414_ VGND VGND VPWR VPWR _06415_ sky130_fd_sc_hd__and3_1
XTAP_TAPCELL_ROW_95_1627 VGND VPWR sky130_fd_sc_hd__tapvpwrvgnd_1
XFILLER_9_391 VGND VGND VPWR VPWR sky130_fd_sc_hd__fill_1
XFILLER_134_749 VGND VGND VPWR VPWR sky130_fd_sc_hd__decap_6
X_07054_ _04570_ _04537_ net242 _06106_ VGND VGND VPWR VPWR _06117_ sky130_fd_sc_hd__a211oi_4
Xoutput176 net176 VGND VGND VPWR VPWR out0[8] sky130_fd_sc_hd__buf_2
Xoutput165 net165 VGND VGND VPWR VPWR out0[12] sky130_fd_sc_hd__buf_2
XFILLER_0_729 VPWR VGND VPWR VGND sky130_ef_sc_hd__decap_12
Xoutput187 net187 VGND VGND VPWR VPWR out1[3] sky130_fd_sc_hd__buf_2
Xoutput198 net198 VGND VGND VPWR VPWR out2[13] sky130_fd_sc_hd__buf_2
X_07956_ _00475_ _00559_ _00558_ VGND VGND VPWR VPWR _00694_ sky130_fd_sc_hd__a21oi_2
XFILLER_87_346 VPWR VGND VPWR VGND sky130_ef_sc_hd__decap_12
X_06907_ _04494_ _04483_ _04472_ VGND VGND VPWR VPWR _04516_ sky130_fd_sc_hd__a21bo_1
XPHY_EDGE_ROW_106_Right_106 VGND VGND VPWR VPWR sky130_fd_sc_hd__decap_3
X_07887_ _06588_ _00524_ _00523_ VGND VGND VPWR VPWR _00625_ sky130_fd_sc_hd__o21ba_1
XFILLER_56_755 VGND VGND VPWR VPWR sky130_fd_sc_hd__fill_1
XFILLER_55_221 VGND VGND VPWR VPWR sky130_fd_sc_hd__decap_3
X_06838_ _03718_ _03751_ VGND VGND VPWR VPWR _03762_ sky130_fd_sc_hd__xnor2_1
X_09626_ _02163_ _02285_ _02031_ VGND VGND VPWR VPWR _02380_ sky130_fd_sc_hd__o21a_1
XFILLER_55_276 VGND VGND VPWR VPWR sky130_fd_sc_hd__decap_4
XFILLER_43_405 VPWR VGND VPWR VGND sky130_ef_sc_hd__decap_12
XFILLER_28_468 VGND VGND VPWR VPWR sky130_fd_sc_hd__fill_2
X_06769_ _02987_ _02998_ VGND VGND VPWR VPWR _03009_ sky130_fd_sc_hd__and2_1
XFILLER_70_235 VGND VGND VPWR VPWR sky130_fd_sc_hd__fill_2
X_09557_ _02176_ _02184_ _02183_ VGND VGND VPWR VPWR _02306_ sky130_fd_sc_hd__a21o_1
XFILLER_43_449 VPWR VGND VPWR VGND sky130_ef_sc_hd__decap_12
X_09488_ _01913_ _02075_ _02076_ VGND VGND VPWR VPWR _02232_ sky130_fd_sc_hd__a21oi_2
XTAP_TAPCELL_ROW_104_1756 VGND VPWR sky130_fd_sc_hd__tapvpwrvgnd_1
XTAP_TAPCELL_ROW_104_1745 VGND VPWR sky130_fd_sc_hd__tapvpwrvgnd_1
X_08508_ _01233_ _01236_ VGND VGND VPWR VPWR _01237_ sky130_fd_sc_hd__xnor2_1
XTAP_TAPCELL_ROW_26_658 VGND VPWR sky130_fd_sc_hd__tapvpwrvgnd_1
X_08439_ _01166_ _01167_ VGND VGND VPWR VPWR _01168_ sky130_fd_sc_hd__or2_1
XFILLER_11_335 VGND VGND VPWR VPWR sky130_fd_sc_hd__fill_1
XFILLER_127_3 VPWR VGND VPWR VGND sky130_ef_sc_hd__decap_12
XFILLER_109_201 VGND VGND VPWR VPWR sky130_fd_sc_hd__decap_3
XFILLER_7_317 VPWR VGND VPWR VGND sky130_ef_sc_hd__decap_12
X_11450_ net540 net272 _02230_ net565 VGND VGND VPWR VPWR _04367_ sky130_fd_sc_hd__o2bb2a_1
X_10401_ _03219_ _03220_ VGND VGND VPWR VPWR _03221_ sky130_fd_sc_hd__or2_1
X_11381_ _04011_ _04012_ _04157_ _04158_ VGND VGND VPWR VPWR _04292_ sky130_fd_sc_hd__o22a_1
XFILLER_125_727 VGND VGND VPWR VPWR sky130_fd_sc_hd__fill_1
XFILLER_124_204 VGND VGND VPWR VPWR sky130_fd_sc_hd__fill_1
X_10332_ _03143_ _03142_ _03144_ VGND VGND VPWR VPWR _03146_ sky130_fd_sc_hd__a21o_1
XFILLER_11_51 VGND VGND VPWR VPWR sky130_fd_sc_hd__fill_2
X_13120_ _06179_ _06185_ VGND VGND VPWR VPWR _06187_ sky130_fd_sc_hd__xor2_1
XFILLER_127_51 VGND VGND VPWR VPWR sky130_fd_sc_hd__decap_4
X_13051_ _05969_ _05982_ _06110_ VGND VGND VPWR VPWR _06111_ sky130_fd_sc_hd__o21a_1
XFILLER_11_84 VGND VGND VPWR VPWR sky130_fd_sc_hd__decap_6
X_12002_ _04962_ _04963_ _04912_ VGND VGND VPWR VPWR _04966_ sky130_fd_sc_hd__o21ai_4
X_10263_ _03068_ _03069_ VGND VGND VPWR VPWR _03070_ sky130_fd_sc_hd__and2b_1
X_10194_ net433 net579 _02993_ _02994_ VGND VGND VPWR VPWR _02995_ sky130_fd_sc_hd__nand4_4
Xfanout381 net39 VGND VGND VPWR VPWR net381 sky130_fd_sc_hd__buf_2
Xfanout392 net395 VGND VGND VPWR VPWR net392 sky130_fd_sc_hd__clkbuf_8
Xfanout370 net371 VGND VGND VPWR VPWR net370 sky130_fd_sc_hd__buf_4
XTAP_TAPCELL_ROW_6_383 VGND VPWR sky130_fd_sc_hd__tapvpwrvgnd_1
XTAP_TAPCELL_ROW_6_372 VGND VPWR sky130_fd_sc_hd__tapvpwrvgnd_1
XFILLER_59_593 VGND VGND VPWR VPWR sky130_fd_sc_hd__decap_3
XFILLER_19_446 VGND VGND VPWR VPWR sky130_fd_sc_hd__fill_2
XTAP_TAPCELL_ROW_66_1217 VGND VPWR sky130_fd_sc_hd__tapvpwrvgnd_1
X_12904_ _05665_ _05805_ _05804_ VGND VGND VPWR VPWR _05951_ sky130_fd_sc_hd__a21oi_1
XTAP_TAPCELL_ROW_45_923 VGND VPWR sky130_fd_sc_hd__tapvpwrvgnd_1
X_12835_ net334 net361 VGND VGND VPWR VPWR _05875_ sky130_fd_sc_hd__nand2_1
XFILLER_99_7 VPWR VGND VPWR VGND sky130_ef_sc_hd__decap_12
XFILLER_70_780 VGND VGND VPWR VPWR sky130_fd_sc_hd__decap_8
XFILLER_15_685 VGND VGND VPWR VPWR sky130_fd_sc_hd__decap_6
X_12766_ _05798_ _05799_ VGND VGND VPWR VPWR _05800_ sky130_fd_sc_hd__nor2_1
X_11717_ _04607_ _04653_ VGND VGND VPWR VPWR _04655_ sky130_fd_sc_hd__and2_1
X_12697_ _05721_ _05722_ VGND VGND VPWR VPWR _05725_ sky130_fd_sc_hd__xnor2_1
Xinput12 in1[3] VGND VGND VPWR VPWR net12 sky130_fd_sc_hd__buf_1
X_11648_ net245 _04578_ _04580_ VGND VGND VPWR VPWR _04581_ sky130_fd_sc_hd__or3_1
XFILLER_30_699 VGND VGND VPWR VPWR sky130_fd_sc_hd__fill_1
Xinput23 in2[6] VGND VGND VPWR VPWR net23 sky130_fd_sc_hd__buf_2
Xinput34 w00[0] VGND VGND VPWR VPWR net34 sky130_fd_sc_hd__buf_2
Xinput45 w01[3] VGND VGND VPWR VPWR net45 sky130_fd_sc_hd__buf_1
X_11579_ _04393_ _04395_ _04507_ VGND VGND VPWR VPWR _04508_ sky130_fd_sc_hd__o21ba_1
Xinput67 w10[1] VGND VGND VPWR VPWR net67 sky130_fd_sc_hd__buf_1
XFILLER_128_587 VGND VGND VPWR VPWR sky130_fd_sc_hd__fill_1
Xinput89 w12[7] VGND VGND VPWR VPWR net89 sky130_fd_sc_hd__buf_4
Xinput56 w02[6] VGND VGND VPWR VPWR net56 sky130_fd_sc_hd__dlymetal6s2s_1
Xinput78 w11[4] VGND VGND VPWR VPWR net78 sky130_fd_sc_hd__buf_1
X_13318_ net397 VGND VGND VPWR VPWR _00092_ sky130_fd_sc_hd__inv_2
XTAP_TAPCELL_ROW_77_1379 VGND VPWR sky130_fd_sc_hd__tapvpwrvgnd_1
XTAP_TAPCELL_ROW_77_1368 VGND VPWR sky130_fd_sc_hd__tapvpwrvgnd_1
X_13249_ _06097_ _06229_ _06094_ VGND VGND VPWR VPWR _06326_ sky130_fd_sc_hd__o21a_1
XFILLER_124_793 VPWR VGND VPWR VGND sky130_ef_sc_hd__decap_12
XFILLER_123_281 VPWR VGND VPWR VGND sky130_ef_sc_hd__decap_12
XTAP_TAPCELL_ROW_90_1557 VGND VPWR sky130_fd_sc_hd__tapvpwrvgnd_1
XFILLER_69_335 VGND VGND VPWR VPWR sky130_fd_sc_hd__fill_1
X_08790_ _01515_ _01516_ VGND VGND VPWR VPWR _01517_ sky130_fd_sc_hd__nand2_1
X_07810_ _00548_ _00535_ VGND VGND VPWR VPWR _00549_ sky130_fd_sc_hd__and2b_1
X_07741_ net505 _02153_ _00478_ _00479_ VGND VGND VPWR VPWR _00480_ sky130_fd_sc_hd__o22a_1
XFILLER_84_349 VGND VGND VPWR VPWR sky130_fd_sc_hd__fill_2
XFILLER_38_744 VGND VGND VPWR VPWR sky130_fd_sc_hd__decap_6
X_07672_ _00251_ _00254_ _00411_ _00410_ VGND VGND VPWR VPWR _00412_ sky130_fd_sc_hd__a211o_1
XFILLER_25_416 VPWR VGND VPWR VGND sky130_ef_sc_hd__decap_12
XFILLER_92_393 VGND VGND VPWR VPWR sky130_fd_sc_hd__decap_6
X_09411_ net456 _01822_ _01824_ _01987_ VGND VGND VPWR VPWR _02147_ sky130_fd_sc_hd__a2bb2o_1
XFILLER_16_29 VPWR VGND VPWR VGND sky130_ef_sc_hd__decap_12
X_09342_ _01751_ _02070_ _02071_ VGND VGND VPWR VPWR _02072_ sky130_fd_sc_hd__nand3_1
XFILLER_80_599 VPWR VGND VPWR VGND sky130_ef_sc_hd__decap_12
XTAP_TAPCELL_ROW_23_617 VGND VPWR sky130_fd_sc_hd__tapvpwrvgnd_1
X_09273_ _01967_ _01996_ VGND VGND VPWR VPWR _01997_ sky130_fd_sc_hd__and2b_1
X_08224_ _00952_ _00957_ VGND VGND VPWR VPWR _00959_ sky130_fd_sc_hd__xnor2_1
XFILLER_20_154 VPWR VGND VPWR VGND sky130_ef_sc_hd__decap_12
X_08155_ _00792_ _00806_ _00805_ VGND VGND VPWR VPWR _00891_ sky130_fd_sc_hd__o21ai_1
XFILLER_134_513 VPWR VGND VPWR VGND sky130_ef_sc_hd__decap_12
X_07106_ _06396_ _06397_ VGND VGND VPWR VPWR _06398_ sky130_fd_sc_hd__or2_1
XFILLER_107_727 VGND VGND VPWR VPWR sky130_fd_sc_hd__fill_1
XFILLER_4_309 VPWR VGND VPWR VGND sky130_ef_sc_hd__decap_12
XFILLER_134_557 VPWR VGND VPWR VGND sky130_ef_sc_hd__decap_12
XTAP_TAPCELL_ROW_132_2141 VGND VPWR sky130_fd_sc_hd__tapvpwrvgnd_1
X_08086_ _00435_ _00700_ _00699_ VGND VGND VPWR VPWR _00823_ sky130_fd_sc_hd__a21oi_1
XFILLER_107_749 VGND VGND VPWR VPWR sky130_fd_sc_hd__decap_8
XFILLER_106_237 VPWR VGND VPWR VGND sky130_ef_sc_hd__decap_12
X_07037_ net805 _05910_ _05888_ VGND VGND VPWR VPWR _05932_ sky130_fd_sc_hd__o21ai_2
XFILLER_102_421 VPWR VGND VPWR VGND sky130_ef_sc_hd__decap_12
XFILLER_88_633 VGND VGND VPWR VPWR sky130_fd_sc_hd__fill_1
XFILLER_88_622 VGND VGND VPWR VPWR sky130_fd_sc_hd__decap_3
XFILLER_87_132 VGND VGND VPWR VPWR sky130_fd_sc_hd__decap_6
XFILLER_102_487 VGND VGND VPWR VPWR sky130_fd_sc_hd__decap_6
XFILLER_87_176 VPWR VGND VPWR VGND sky130_ef_sc_hd__decap_12
XFILLER_87_165 VGND VGND VPWR VPWR sky130_fd_sc_hd__decap_3
X_08988_ _01551_ _01553_ _01552_ VGND VGND VPWR VPWR _01714_ sky130_fd_sc_hd__o21bai_1
XFILLER_48_519 VPWR VGND VPWR VGND sky130_ef_sc_hd__decap_12
X_07939_ _00187_ _00676_ VGND VGND VPWR VPWR _00677_ sky130_fd_sc_hd__xnor2_1
XPHY_EDGE_ROW_82_Left_219 VGND VGND VPWR VPWR sky130_fd_sc_hd__decap_3
XTAP_TAPCELL_ROW_3_342 VGND VPWR sky130_fd_sc_hd__tapvpwrvgnd_1
XTAP_TAPCELL_ROW_3_331 VGND VPWR sky130_fd_sc_hd__tapvpwrvgnd_1
XFILLER_29_733 VGND VGND VPWR VPWR sky130_fd_sc_hd__fill_1
XFILLER_16_405 VGND VGND VPWR VPWR sky130_fd_sc_hd__decap_4
X_10950_ net375 net344 _03645_ _03644_ VGND VGND VPWR VPWR _03821_ sky130_fd_sc_hd__a31o_1
X_09609_ _02359_ _02361_ VGND VGND VPWR VPWR _02363_ sky130_fd_sc_hd__xor2_2
XFILLER_83_393 VPWR VGND VPWR VGND sky130_ef_sc_hd__decap_12
XFILLER_56_585 VGND VGND VPWR VPWR sky130_fd_sc_hd__decap_3
XFILLER_43_202 VPWR VGND VPWR VGND sky130_ef_sc_hd__decap_12
X_10881_ net496 net503 net647 net636 VGND VGND VPWR VPWR _03745_ sky130_fd_sc_hd__and4_1
XFILLER_44_769 VGND VGND VPWR VPWR sky130_fd_sc_hd__decap_3
X_12620_ _05580_ _05639_ _05640_ VGND VGND VPWR VPWR _05641_ sky130_fd_sc_hd__nand3_1
XTAP_TAPCELL_ROW_61_1147 VGND VPWR sky130_fd_sc_hd__tapvpwrvgnd_1
XFILLER_52_791 VPWR VGND VPWR VGND sky130_ef_sc_hd__decap_12
X_12551_ net454 net145 VGND VGND VPWR VPWR _05565_ sky130_fd_sc_hd__and2b_1
XPHY_EDGE_ROW_91_Left_228 VGND VGND VPWR VPWR sky130_fd_sc_hd__decap_3
X_12482_ _05489_ _05488_ VGND VGND VPWR VPWR _00036_ sky130_fd_sc_hd__and2_4
X_11502_ _04421_ _04422_ VGND VGND VPWR VPWR _04423_ sky130_fd_sc_hd__nand2_1
XTAP_TAPCELL_ROW_50_992 VGND VPWR sky130_fd_sc_hd__tapvpwrvgnd_1
X_11433_ _04340_ _04347_ VGND VGND VPWR VPWR _04348_ sky130_fd_sc_hd__xnor2_1
XFILLER_125_502 VGND VGND VPWR VPWR sky130_fd_sc_hd__fill_2
XTAP_TAPCELL_ROW_117_1936 VGND VPWR sky130_fd_sc_hd__tapvpwrvgnd_1
XFILLER_7_169 VPWR VGND VPWR VGND sky130_ef_sc_hd__decap_12
XFILLER_125_546 VGND VGND VPWR VPWR sky130_fd_sc_hd__fill_2
XFILLER_98_43 VGND VGND VPWR VPWR sky130_fd_sc_hd__fill_2
X_11364_ _04238_ _04271_ VGND VGND VPWR VPWR _04273_ sky130_fd_sc_hd__xnor2_1
XFILLER_98_76 VGND VGND VPWR VPWR sky130_fd_sc_hd__decap_4
X_10315_ _02955_ _02957_ _03126_ VGND VGND VPWR VPWR _03127_ sky130_fd_sc_hd__o21a_1
X_11295_ _04190_ _04196_ VGND VGND VPWR VPWR _04197_ sky130_fd_sc_hd__nand2b_1
X_13103_ net541 net284 _02273_ net567 VGND VGND VPWR VPWR _06168_ sky130_fd_sc_hd__o2bb2a_1
X_10246_ _02866_ _03048_ _03051_ VGND VGND VPWR VPWR _03052_ sky130_fd_sc_hd__and3_1
X_13034_ _06091_ _05815_ _06092_ _05957_ VGND VGND VPWR VPWR _06093_ sky130_fd_sc_hd__o211a_4
XFILLER_121_741 VPWR VGND VPWR VGND sky130_ef_sc_hd__decap_12
XFILLER_105_281 VPWR VGND VPWR VGND sky130_ef_sc_hd__decap_12
XFILLER_94_603 VPWR VGND VPWR VGND sky130_ef_sc_hd__decap_12
XFILLER_121_785 VPWR VGND VPWR VGND sky130_ef_sc_hd__decap_12
XFILLER_120_251 VGND VGND VPWR VPWR sky130_fd_sc_hd__fill_1
XFILLER_93_113 VPWR VGND VPWR VGND sky130_ef_sc_hd__decap_12
XFILLER_78_165 VGND VGND VPWR VPWR sky130_fd_sc_hd__decap_8
XTAP_TAPCELL_ROW_72_1298 VGND VPWR sky130_fd_sc_hd__tapvpwrvgnd_1
X_10177_ net426 net376 net353 net351 VGND VGND VPWR VPWR _02977_ sky130_fd_sc_hd__and4_1
XFILLER_39_519 VGND VGND VPWR VPWR sky130_fd_sc_hd__decap_8
XFILLER_94_669 VPWR VGND VPWR VGND sky130_ef_sc_hd__decap_12
XFILLER_81_308 VPWR VGND VPWR VGND sky130_ef_sc_hd__decap_12
XFILLER_19_254 VGND VGND VPWR VPWR sky130_fd_sc_hd__fill_1
XFILLER_35_747 VGND VGND VPWR VPWR sky130_fd_sc_hd__fill_1
X_12818_ _05852_ _05853_ VGND VGND VPWR VPWR _05857_ sky130_fd_sc_hd__and2_1
XFILLER_43_791 VGND VGND VPWR VPWR sky130_fd_sc_hd__fill_2
X_12749_ net404 net587 VGND VGND VPWR VPWR _05782_ sky130_fd_sc_hd__nand2_1
XFILLER_8_41 VPWR VGND VPWR VGND sky130_ef_sc_hd__decap_12
XFILLER_8_85 VGND VGND VPWR VPWR sky130_fd_sc_hd__decap_6
XFILLER_116_502 VGND VGND VPWR VPWR sky130_fd_sc_hd__decap_3
XFILLER_131_505 VPWR VGND VPWR VGND sky130_ef_sc_hd__decap_12
X_09960_ _02513_ _02630_ _02633_ _02742_ VGND VGND VPWR VPWR _02743_ sky130_fd_sc_hd__o31a_1
X_08911_ _01593_ _01636_ VGND VGND VPWR VPWR _01637_ sky130_fd_sc_hd__nand2_1
XFILLER_112_741 VPWR VGND VPWR VGND sky130_ef_sc_hd__decap_12
X_09891_ _02532_ _02536_ _02667_ VGND VGND VPWR VPWR _02669_ sky130_fd_sc_hd__and3_1
XFILLER_85_614 VGND VGND VPWR VPWR sky130_fd_sc_hd__fill_2
X_08842_ _01566_ _01567_ _01539_ VGND VGND VPWR VPWR _01569_ sky130_fd_sc_hd__a21o_1
X_08773_ _01497_ _01498_ _01495_ VGND VGND VPWR VPWR _01500_ sky130_fd_sc_hd__a21bo_1
XFILLER_57_349 VGND VGND VPWR VPWR sky130_fd_sc_hd__fill_2
X_07724_ _00459_ _00462_ VGND VGND VPWR VPWR _00463_ sky130_fd_sc_hd__xnor2_1
XTAP_TAPCELL_ROW_0_301 VGND VPWR sky130_fd_sc_hd__tapvpwrvgnd_1
X_07655_ _06593_ _00222_ _00224_ VGND VGND VPWR VPWR _00395_ sky130_fd_sc_hd__o21bai_1
XFILLER_38_585 VGND VGND VPWR VPWR sky130_fd_sc_hd__decap_3
XFILLER_92_190 VGND VGND VPWR VPWR sky130_fd_sc_hd__decap_6
XFILLER_53_566 VPWR VGND VPWR VGND sky130_ef_sc_hd__decap_12
XTAP_TAPCELL_ROW_101_1715 VGND VPWR sky130_fd_sc_hd__tapvpwrvgnd_1
XTAP_TAPCELL_ROW_101_1704 VGND VPWR sky130_fd_sc_hd__tapvpwrvgnd_1
X_07586_ _00180_ _00194_ _00193_ VGND VGND VPWR VPWR _00326_ sky130_fd_sc_hd__o21ai_1
XFILLER_80_363 VGND VGND VPWR VPWR sky130_fd_sc_hd__fill_1
XTAP_TAPCELL_ROW_36_797 VGND VPWR sky130_fd_sc_hd__tapvpwrvgnd_1
X_09325_ _02050_ _02051_ _01883_ _01885_ VGND VGND VPWR VPWR _02053_ sky130_fd_sc_hd__a211o_1
X_09256_ _01977_ _01978_ _01979_ VGND VGND VPWR VPWR _01980_ sky130_fd_sc_hd__and3_1
X_08207_ net373 net374 net287 VGND VGND VPWR VPWR _00942_ sky130_fd_sc_hd__mux2_1
X_09187_ _01908_ _01909_ _01591_ VGND VGND VPWR VPWR _01912_ sky130_fd_sc_hd__o21ai_1
XFILLER_5_629 VPWR VGND VPWR VGND sky130_ef_sc_hd__decap_12
XFILLER_134_321 VPWR VGND VPWR VGND sky130_ef_sc_hd__decap_12
XFILLER_107_524 VGND VGND VPWR VPWR sky130_fd_sc_hd__fill_1
X_08138_ _00870_ _00873_ VGND VGND VPWR VPWR _00874_ sky130_fd_sc_hd__or2_1
XFILLER_4_139 VGND VGND VPWR VPWR sky130_fd_sc_hd__fill_1
XFILLER_134_365 VPWR VGND VPWR VGND sky130_ef_sc_hd__decap_12
X_08069_ _00803_ _00804_ VGND VGND VPWR VPWR _00806_ sky130_fd_sc_hd__xor2_1
XTAP_TAPCELL_ROW_8_412 VGND VPWR sky130_fd_sc_hd__tapvpwrvgnd_1
XTAP_TAPCELL_ROW_8_401 VGND VPWR sky130_fd_sc_hd__tapvpwrvgnd_1
XFILLER_134_398 VPWR VGND VPWR VGND sky130_ef_sc_hd__decap_12
XFILLER_122_549 VPWR VGND VPWR VGND sky130_ef_sc_hd__decap_12
XFILLER_108_75 VGND VGND VPWR VPWR sky130_fd_sc_hd__fill_1
X_10100_ net664 net638 net282 net280 VGND VGND VPWR VPWR _02892_ sky130_fd_sc_hd__and4_1
X_11080_ _03956_ _03962_ VGND VGND VPWR VPWR _03963_ sky130_fd_sc_hd__and2_1
XTAP_TAPCELL_ROW_112_1866 VGND VPWR sky130_fd_sc_hd__tapvpwrvgnd_1
XFILLER_88_452 VGND VGND VPWR VPWR sky130_fd_sc_hd__fill_2
X_10031_ _02816_ _02817_ VGND VGND VPWR VPWR _02818_ sky130_fd_sc_hd__nand2_1
XFILLER_103_763 VGND VGND VPWR VPWR sky130_fd_sc_hd__decap_8
XFILLER_102_251 VGND VGND VPWR VPWR sky130_fd_sc_hd__fill_1
XFILLER_48_316 VGND VGND VPWR VPWR sky130_fd_sc_hd__decap_4
XFILLER_124_41 VPWR VGND VPWR VGND sky130_ef_sc_hd__decap_12
XFILLER_124_85 VGND VGND VPWR VPWR sky130_fd_sc_hd__decap_8
XFILLER_29_541 VGND VGND VPWR VPWR sky130_fd_sc_hd__decap_4
XFILLER_29_552 VGND VGND VPWR VPWR sky130_fd_sc_hd__decap_8
XFILLER_90_127 VPWR VGND VPWR VGND sky130_ef_sc_hd__decap_12
X_11982_ _04765_ _04767_ net792 VGND VGND VPWR VPWR _04944_ sky130_fd_sc_hd__o21bai_1
XFILLER_29_596 VGND VGND VPWR VPWR sky130_fd_sc_hd__decap_3
XFILLER_71_330 VGND VGND VPWR VPWR sky130_fd_sc_hd__fill_1
XFILLER_17_61 VGND VGND VPWR VPWR sky130_fd_sc_hd__fill_1
X_10933_ net308 net348 net346 net331 VGND VGND VPWR VPWR _03802_ sky130_fd_sc_hd__a22o_1
X_10864_ _03722_ net247 VGND VGND VPWR VPWR _03726_ sky130_fd_sc_hd__xor2_1
X_12603_ net791 net363 _05444_ _05443_ VGND VGND VPWR VPWR _05622_ sky130_fd_sc_hd__a31o_1
XFILLER_31_249 VGND VGND VPWR VPWR sky130_fd_sc_hd__decap_4
X_10795_ _03463_ _03470_ _03469_ VGND VGND VPWR VPWR _03651_ sky130_fd_sc_hd__a21o_1
XFILLER_8_401 VPWR VGND VPWR VGND sky130_ef_sc_hd__decap_12
X_12534_ net499 net660 net658 net507 VGND VGND VPWR VPWR _05546_ sky130_fd_sc_hd__a22o_1
XFILLER_129_137 VPWR VGND VPWR VGND sky130_ef_sc_hd__decap_12
X_12465_ _05364_ _05468_ _05470_ VGND VGND VPWR VPWR _05471_ sky130_fd_sc_hd__and3_1
XFILLER_8_489 VGND VGND VPWR VPWR sky130_fd_sc_hd__fill_1
XFILLER_125_332 VGND VGND VPWR VPWR sky130_fd_sc_hd__decap_4
X_11416_ _04327_ _04328_ VGND VGND VPWR VPWR _04329_ sky130_fd_sc_hd__and2b_1
X_12396_ _05394_ _05393_ VGND VGND VPWR VPWR _05395_ sky130_fd_sc_hd__nand2b_1
XTAP_TAPCELL_ROW_74_1327 VGND VPWR sky130_fd_sc_hd__tapvpwrvgnd_1
X_11347_ _03890_ _04051_ _04050_ VGND VGND VPWR VPWR _04255_ sky130_fd_sc_hd__a21bo_1
XFILLER_125_387 VGND VGND VPWR VPWR sky130_fd_sc_hd__decap_4
XFILLER_125_376 VGND VGND VPWR VPWR sky130_fd_sc_hd__decap_8
XFILLER_98_227 VPWR VGND VPWR VGND sky130_ef_sc_hd__decap_12
XFILLER_3_161 VGND VGND VPWR VPWR sky130_fd_sc_hd__decap_6
X_11278_ _04173_ _04178_ VGND VGND VPWR VPWR _04179_ sky130_fd_sc_hd__or2_1
XFILLER_94_400 VGND VGND VPWR VPWR sky130_fd_sc_hd__decap_8
XFILLER_67_603 VGND VGND VPWR VPWR sky130_fd_sc_hd__fill_1
X_10229_ _02920_ _03032_ _03033_ VGND VGND VPWR VPWR _03034_ sky130_fd_sc_hd__nand3b_2
X_13017_ _06039_ _06072_ VGND VGND VPWR VPWR _06075_ sky130_fd_sc_hd__xnor2_1
XFILLER_39_316 VGND VGND VPWR VPWR sky130_fd_sc_hd__decap_8
XFILLER_121_593 VGND VGND VPWR VPWR sky130_fd_sc_hd__fill_2
XFILLER_94_433 VPWR VGND VPWR VGND sky130_ef_sc_hd__decap_12
XFILLER_94_477 VPWR VGND VPWR VGND sky130_ef_sc_hd__decap_12
XFILLER_82_606 VPWR VGND VPWR VGND sky130_ef_sc_hd__decap_12
XFILLER_67_669 VGND VGND VPWR VPWR sky130_fd_sc_hd__decap_3
XFILLER_35_500 VGND VGND VPWR VPWR sky130_fd_sc_hd__decap_4
XFILLER_62_330 VGND VGND VPWR VPWR sky130_fd_sc_hd__fill_1
XFILLER_47_393 VPWR VGND VPWR VGND sky130_ef_sc_hd__decap_12
XFILLER_35_533 VGND VGND VPWR VPWR sky130_fd_sc_hd__fill_2
X_07440_ _06568_ _06571_ VGND VGND VPWR VPWR _00181_ sky130_fd_sc_hd__nand2_1
XTAP_TAPCELL_ROW_85_1489 VGND VPWR sky130_fd_sc_hd__tapvpwrvgnd_1
XTAP_TAPCELL_ROW_85_1478 VGND VPWR sky130_fd_sc_hd__tapvpwrvgnd_1
XFILLER_50_525 VGND VGND VPWR VPWR sky130_fd_sc_hd__fill_2
XPHY_EDGE_ROW_8_Right_8 VGND VGND VPWR VPWR sky130_fd_sc_hd__decap_3
X_07371_ _06512_ _06528_ _06526_ VGND VGND VPWR VPWR _06661_ sky130_fd_sc_hd__o21a_1
XFILLER_22_249 VGND VGND VPWR VPWR sky130_fd_sc_hd__decap_3
X_09110_ _01804_ _01834_ VGND VGND VPWR VPWR _01835_ sky130_fd_sc_hd__and2b_1
XFILLER_15_290 VGND VGND VPWR VPWR sky130_fd_sc_hd__decap_8
XTAP_TAPCELL_ROW_33_756 VGND VPWR sky130_fd_sc_hd__tapvpwrvgnd_1
X_09041_ net645 net95 VGND VGND VPWR VPWR _01766_ sky130_fd_sc_hd__nand2_1
XFILLER_30_271 VGND VGND VPWR VPWR sky130_fd_sc_hd__decap_6
XFILLER_31_783 VGND VGND VPWR VPWR sky130_fd_sc_hd__fill_1
XFILLER_129_671 VGND VGND VPWR VPWR sky130_fd_sc_hd__fill_1
XTAP_TAPCELL_ROW_13_480 VGND VPWR sky130_fd_sc_hd__tapvpwrvgnd_1
XFILLER_128_181 VGND VGND VPWR VPWR sky130_fd_sc_hd__fill_1
X_09943_ _02723_ _02724_ VGND VGND VPWR VPWR _02725_ sky130_fd_sc_hd__nor2_1
XPHY_EDGE_ROW_39_Right_39 VGND VGND VPWR VPWR sky130_fd_sc_hd__decap_3
X_09874_ _02551_ _02565_ _02564_ VGND VGND VPWR VPWR _02650_ sky130_fd_sc_hd__o21a_1
XFILLER_85_400 VPWR VGND VPWR VGND sky130_ef_sc_hd__decap_12
XFILLER_38_27 VGND VGND VPWR VPWR sky130_fd_sc_hd__fill_1
X_08825_ net335 net313 net340 net338 VGND VGND VPWR VPWR _01552_ sky130_fd_sc_hd__and4_1
XTAP_TAPCELL_ROW_127_2073 VGND VPWR sky130_fd_sc_hd__tapvpwrvgnd_1
XFILLER_100_755 VGND VGND VPWR VPWR sky130_fd_sc_hd__fill_1
X_08756_ _01216_ _01357_ _01482_ VGND VGND VPWR VPWR _01483_ sky130_fd_sc_hd__a21oi_1
X_07707_ _00289_ _00291_ _00288_ VGND VGND VPWR VPWR _00446_ sky130_fd_sc_hd__o21ba_1
XFILLER_81_650 VPWR VGND VPWR VGND sky130_ef_sc_hd__decap_12
X_08687_ net335 net340 net338 net793 VGND VGND VPWR VPWR _01415_ sky130_fd_sc_hd__a22oi_2
XFILLER_53_341 VGND VGND VPWR VPWR sky130_fd_sc_hd__fill_1
XFILLER_26_533 VPWR VGND VPWR VGND sky130_ef_sc_hd__decap_12
X_07638_ net385 net383 net332 net309 VGND VGND VPWR VPWR _00378_ sky130_fd_sc_hd__and4_1
XFILLER_14_728 VGND VGND VPWR VPWR sky130_fd_sc_hd__decap_3
X_07569_ net318 net543 _00144_ _00145_ VGND VGND VPWR VPWR _00309_ sky130_fd_sc_hd__a22o_1
XFILLER_80_193 VGND VGND VPWR VPWR sky130_fd_sc_hd__decap_3
XPHY_EDGE_ROW_48_Right_48 VGND VGND VPWR VPWR sky130_fd_sc_hd__decap_3
XFILLER_41_536 VGND VGND VPWR VPWR sky130_fd_sc_hd__fill_2
XFILLER_110_54 VPWR VGND VPWR VGND sky130_ef_sc_hd__decap_12
X_09308_ _02031_ _02032_ _02025_ VGND VGND VPWR VPWR _02035_ sky130_fd_sc_hd__a21o_1
X_10580_ _03411_ _03413_ _03415_ VGND VGND VPWR VPWR _03416_ sky130_fd_sc_hd__nand3_1
X_09239_ _01924_ _01961_ VGND VGND VPWR VPWR _01963_ sky130_fd_sc_hd__xnor2_1
X_12250_ _02011_ net360 _05234_ _05235_ VGND VGND VPWR VPWR _05236_ sky130_fd_sc_hd__a22o_1
XFILLER_135_641 VPWR VGND VPWR VGND sky130_ef_sc_hd__decap_12
XFILLER_119_192 VGND VGND VPWR VPWR sky130_fd_sc_hd__decap_8
X_12181_ _05158_ _05159_ VGND VGND VPWR VPWR _05160_ sky130_fd_sc_hd__nand2_1
X_11201_ net400 net563 net561 net408 VGND VGND VPWR VPWR _04095_ sky130_fd_sc_hd__a22oi_1
XFILLER_135_685 VPWR VGND VPWR VGND sky130_ef_sc_hd__decap_12
XPHY_EDGE_ROW_57_Right_57 VGND VGND VPWR VPWR sky130_fd_sc_hd__decap_3
X_11132_ _04016_ _04019_ VGND VGND VPWR VPWR _00013_ sky130_fd_sc_hd__xnor2_1
XFILLER_134_195 VGND VGND VPWR VPWR sky130_fd_sc_hd__fill_1
XFILLER_122_335 VGND VGND VPWR VPWR sky130_fd_sc_hd__decap_3
XTAP_TAPCELL_ROW_56_1079 VGND VPWR sky130_fd_sc_hd__tapvpwrvgnd_1
XFILLER_135_51 VGND VGND VPWR VPWR sky130_fd_sc_hd__decap_4
XFILLER_89_783 VGND VGND VPWR VPWR sky130_fd_sc_hd__fill_1
XFILLER_88_260 VGND VGND VPWR VPWR sky130_fd_sc_hd__decap_8
XFILLER_0_153 VPWR VGND VPWR VGND sky130_ef_sc_hd__decap_12
XFILLER_1_665 VGND VGND VPWR VPWR sky130_fd_sc_hd__decap_6
X_11063_ _03807_ _03809_ _03810_ _03808_ _03636_ VGND VGND VPWR VPWR _03944_ sky130_fd_sc_hd__o32a_2
XFILLER_95_55 VGND VGND VPWR VPWR sky130_fd_sc_hd__fill_1
XFILLER_95_33 VPWR VGND VPWR VGND sky130_ef_sc_hd__decap_12
XFILLER_76_433 VGND VGND VPWR VPWR sky130_fd_sc_hd__decap_8
X_10014_ _02797_ _02798_ VGND VGND VPWR VPWR _02799_ sky130_fd_sc_hd__xor2_1
XFILLER_0_197 VPWR VGND VPWR VGND sky130_ef_sc_hd__decap_12
XFILLER_76_477 VPWR VGND VPWR VGND sky130_ef_sc_hd__decap_12
XFILLER_76_455 VGND VGND VPWR VPWR sky130_fd_sc_hd__fill_1
XFILLER_28_60 VGND VGND VPWR VPWR sky130_fd_sc_hd__fill_1
X_11965_ _04923_ _04924_ VGND VGND VPWR VPWR _04925_ sky130_fd_sc_hd__nor2_1
XFILLER_17_544 VPWR VGND VPWR VGND sky130_ef_sc_hd__decap_12
XFILLER_29_393 VPWR VGND VPWR VGND sky130_ef_sc_hd__decap_12
XPHY_EDGE_ROW_66_Right_66 VGND VGND VPWR VPWR sky130_fd_sc_hd__decap_3
XFILLER_44_374 VPWR VGND VPWR VGND sky130_ef_sc_hd__decap_12
X_10916_ net416 net563 net561 net433 VGND VGND VPWR VPWR _03783_ sky130_fd_sc_hd__a22oi_1
X_11896_ _04846_ _04848_ _04661_ VGND VGND VPWR VPWR _04850_ sky130_fd_sc_hd__a21oi_1
X_10847_ _02055_ net638 net273 net89 VGND VGND VPWR VPWR _03708_ sky130_fd_sc_hd__and4_1
XFILLER_12_260 VGND VGND VPWR VPWR sky130_fd_sc_hd__decap_4
XTAP_TAPCELL_ROW_30_715 VGND VPWR sky130_fd_sc_hd__tapvpwrvgnd_1
X_10778_ _03626_ _03630_ VGND VGND VPWR VPWR _03633_ sky130_fd_sc_hd__xor2_1
XFILLER_118_608 VPWR VGND VPWR VGND sky130_ef_sc_hd__decap_12
XFILLER_9_765 VPWR VGND VPWR VGND sky130_ef_sc_hd__decap_12
XFILLER_8_253 VPWR VGND VPWR VGND sky130_ef_sc_hd__decap_12
X_12517_ _05520_ _05526_ VGND VGND VPWR VPWR _05528_ sky130_fd_sc_hd__and2b_1
X_12448_ _05452_ VGND VGND VPWR VPWR _05453_ sky130_fd_sc_hd__inv_2
XPHY_EDGE_ROW_75_Right_75 VGND VGND VPWR VPWR sky130_fd_sc_hd__decap_3
X_12379_ _05375_ _05376_ VGND VGND VPWR VPWR _05377_ sky130_fd_sc_hd__xnor2_1
XFILLER_101_519 VGND VGND VPWR VPWR sky130_fd_sc_hd__fill_1
X_06940_ _04796_ _04851_ _04861_ VGND VGND VPWR VPWR _04872_ sky130_fd_sc_hd__and3_4
X_06871_ _04112_ VGND VGND VPWR VPWR _04123_ sky130_fd_sc_hd__inv_2
XFILLER_39_113 VGND VGND VPWR VPWR sky130_fd_sc_hd__decap_3
X_08610_ _01331_ _01337_ VGND VGND VPWR VPWR _01339_ sky130_fd_sc_hd__or2_1
XTAP_TAPCELL_ROW_87_1518 VGND VPWR sky130_fd_sc_hd__tapvpwrvgnd_1
XTAP_TAPCELL_ROW_87_1507 VGND VPWR sky130_fd_sc_hd__tapvpwrvgnd_1
XFILLER_55_617 VGND VGND VPWR VPWR sky130_fd_sc_hd__decap_6
X_09590_ _01825_ _02341_ VGND VGND VPWR VPWR _02342_ sky130_fd_sc_hd__xnor2_1
XPHY_EDGE_ROW_84_Right_84 VGND VGND VPWR VPWR sky130_fd_sc_hd__decap_3
XFILLER_82_425 VGND VGND VPWR VPWR sky130_fd_sc_hd__fill_1
XFILLER_48_680 VGND VGND VPWR VPWR sky130_fd_sc_hd__decap_8
XTAP_TAPCELL_ROW_38_826 VGND VPWR sky130_fd_sc_hd__tapvpwrvgnd_1
X_08541_ _01267_ _01268_ _01256_ VGND VGND VPWR VPWR _01270_ sky130_fd_sc_hd__a21o_1
X_08472_ _01197_ _01200_ VGND VGND VPWR VPWR _01201_ sky130_fd_sc_hd__nand2_1
XFILLER_63_661 VGND VGND VPWR VPWR sky130_fd_sc_hd__decap_8
XTAP_TAPCELL_ROW_18_550 VGND VPWR sky130_fd_sc_hd__tapvpwrvgnd_1
X_07423_ _06665_ _00163_ VGND VGND VPWR VPWR _00164_ sky130_fd_sc_hd__xor2_1
XFILLER_24_29 VGND VGND VPWR VPWR sky130_fd_sc_hd__fill_1
X_07354_ _06643_ _06644_ VGND VGND VPWR VPWR _06645_ sky130_fd_sc_hd__and2b_1
XFILLER_50_377 VGND VGND VPWR VPWR sky130_fd_sc_hd__decap_4
XFILLER_108_107 VPWR VGND VPWR VGND sky130_ef_sc_hd__decap_12
X_07285_ _05516_ _06422_ VGND VGND VPWR VPWR _06576_ sky130_fd_sc_hd__nor2_1
XFILLER_136_449 VPWR VGND VPWR VGND sky130_ef_sc_hd__decap_12
XFILLER_136_427 VGND VGND VPWR VPWR sky130_fd_sc_hd__decap_3
XFILLER_117_630 VGND VGND VPWR VPWR sky130_fd_sc_hd__decap_6
X_09024_ _01748_ _01749_ VGND VGND VPWR VPWR _00061_ sky130_fd_sc_hd__xor2_1
XTAP_TAPCELL_ROW_98_1669 VGND VPWR sky130_fd_sc_hd__tapvpwrvgnd_1
XPHY_EDGE_ROW_93_Right_93 VGND VGND VPWR VPWR sky130_fd_sc_hd__decap_3
XFILLER_117_652 VPWR VGND VPWR VGND sky130_ef_sc_hd__decap_12
XFILLER_117_685 VPWR VGND VPWR VGND sky130_ef_sc_hd__decap_12
XFILLER_116_173 VGND VGND VPWR VPWR sky130_fd_sc_hd__fill_1
XFILLER_78_709 VGND VGND VPWR VPWR sky130_fd_sc_hd__decap_4
Xfanout700 net1 VGND VGND VPWR VPWR net700 sky130_fd_sc_hd__buf_2
XFILLER_132_699 VGND VGND VPWR VPWR sky130_fd_sc_hd__fill_1
XTAP_TAPCELL_ROW_129_2102 VGND VPWR sky130_fd_sc_hd__tapvpwrvgnd_1
X_09926_ _02676_ _02705_ VGND VGND VPWR VPWR _02707_ sky130_fd_sc_hd__xor2_1
XFILLER_104_379 VGND VGND VPWR VPWR sky130_fd_sc_hd__fill_1
XFILLER_77_208 VGND VGND VPWR VPWR sky130_fd_sc_hd__fill_1
XFILLER_131_176 VGND VGND VPWR VPWR sky130_fd_sc_hd__fill_1
XFILLER_58_433 VGND VGND VPWR VPWR sky130_fd_sc_hd__decap_4
XFILLER_100_530 VGND VGND VPWR VPWR sky130_fd_sc_hd__fill_2
X_09857_ net324 net325 net291 VGND VGND VPWR VPWR _02632_ sky130_fd_sc_hd__mux2_1
XFILLER_58_444 VGND VGND VPWR VPWR sky130_fd_sc_hd__fill_1
X_09788_ _01824_ _02556_ VGND VGND VPWR VPWR _02557_ sky130_fd_sc_hd__xnor2_1
X_08808_ _01532_ _01533_ _01524_ VGND VGND VPWR VPWR _01535_ sky130_fd_sc_hd__a21o_1
XFILLER_65_47 VGND VGND VPWR VPWR sky130_fd_sc_hd__decap_8
X_08739_ _01346_ _01465_ VGND VGND VPWR VPWR _01466_ sky130_fd_sc_hd__nor2_1
XFILLER_73_447 VGND VGND VPWR VPWR sky130_fd_sc_hd__fill_1
X_11750_ net618 net301 net299 net641 VGND VGND VPWR VPWR _04690_ sky130_fd_sc_hd__a22oi_1
XFILLER_54_672 VPWR VGND VPWR VGND sky130_ef_sc_hd__decap_12
XTAP_TAPCELL_ROW_107_1798 VGND VPWR sky130_fd_sc_hd__tapvpwrvgnd_1
XTAP_TAPCELL_ROW_107_1787 VGND VPWR sky130_fd_sc_hd__tapvpwrvgnd_1
XFILLER_81_491 VGND VGND VPWR VPWR sky130_fd_sc_hd__fill_1
XFILLER_54_694 VGND VGND VPWR VPWR sky130_fd_sc_hd__decap_6
XFILLER_53_182 VPWR VGND VPWR VGND sky130_ef_sc_hd__decap_12
XFILLER_26_396 VGND VGND VPWR VPWR sky130_fd_sc_hd__decap_4
XFILLER_41_333 VGND VGND VPWR VPWR sky130_fd_sc_hd__decap_3
X_10701_ _03547_ _03540_ VGND VGND VPWR VPWR _03548_ sky130_fd_sc_hd__and2b_1
X_11681_ net700 net44 VGND VGND VPWR VPWR _04615_ sky130_fd_sc_hd__nand2_1
XTAP_TAPCELL_ROW_120_1976 VGND VPWR sky130_fd_sc_hd__tapvpwrvgnd_1
X_10632_ _03471_ _03472_ VGND VGND VPWR VPWR _03473_ sky130_fd_sc_hd__nor2_1
X_13351_ net399 VGND VGND VPWR VPWR _00125_ sky130_fd_sc_hd__inv_2
X_10563_ _03395_ _03396_ VGND VGND VPWR VPWR _03397_ sky130_fd_sc_hd__xnor2_1
XFILLER_127_449 VPWR VGND VPWR VGND sky130_ef_sc_hd__decap_12
XFILLER_127_438 VGND VGND VPWR VPWR sky130_fd_sc_hd__decap_8
X_12302_ _05024_ _05116_ _05115_ VGND VGND VPWR VPWR _05293_ sky130_fd_sc_hd__a21boi_2
XTAP_TAPCELL_ROW_58_1108 VGND VPWR sky130_fd_sc_hd__tapvpwrvgnd_1
XFILLER_6_713 VPWR VGND VPWR VGND sky130_ef_sc_hd__decap_12
X_10494_ _03184_ _03320_ _03321_ VGND VGND VPWR VPWR _03322_ sky130_fd_sc_hd__nand3_2
X_13282_ _06342_ _06361_ VGND VGND VPWR VPWR _06362_ sky130_fd_sc_hd__xnor2_1
XFILLER_6_757 VPWR VGND VPWR VGND sky130_ef_sc_hd__decap_12
XFILLER_5_223 VGND VGND VPWR VPWR sky130_fd_sc_hd__fill_1
X_12233_ _05202_ _05215_ _05216_ VGND VGND VPWR VPWR _05217_ sky130_fd_sc_hd__nand3_1
X_12164_ _05139_ _05140_ VGND VGND VPWR VPWR _05141_ sky130_fd_sc_hd__xnor2_1
X_12095_ _05064_ _05065_ _05062_ VGND VGND VPWR VPWR _05067_ sky130_fd_sc_hd__o21ai_1
X_11115_ _03998_ _03999_ VGND VGND VPWR VPWR _04001_ sky130_fd_sc_hd__xnor2_1
XFILLER_110_316 VGND VGND VPWR VPWR sky130_fd_sc_hd__decap_8
XFILLER_1_473 VPWR VGND VPWR VGND sky130_ef_sc_hd__decap_12
X_11046_ _03914_ _03924_ VGND VGND VPWR VPWR _03925_ sky130_fd_sc_hd__xnor2_1
XFILLER_77_797 VGND VGND VPWR VPWR sky130_fd_sc_hd__decap_8
XFILLER_64_425 VGND VGND VPWR VPWR sky130_fd_sc_hd__fill_1
XFILLER_49_499 VGND VGND VPWR VPWR sky130_fd_sc_hd__decap_4
XFILLER_37_617 VGND VGND VPWR VPWR sky130_fd_sc_hd__decap_6
XFILLER_91_222 VGND VGND VPWR VPWR sky130_fd_sc_hd__fill_2
XTAP_TAPCELL_ROW_69_1259 VGND VPWR sky130_fd_sc_hd__tapvpwrvgnd_1
XFILLER_29_190 VPWR VGND VPWR VGND sky130_ef_sc_hd__decap_12
X_12997_ _05829_ _05836_ _06050_ VGND VGND VPWR VPWR _06053_ sky130_fd_sc_hd__nand3_1
XTAP_TAPCELL_ROW_82_1448 VGND VPWR sky130_fd_sc_hd__tapvpwrvgnd_1
XTAP_TAPCELL_ROW_82_1437 VGND VPWR sky130_fd_sc_hd__tapvpwrvgnd_1
X_11948_ _04902_ _04903_ VGND VGND VPWR VPWR _04907_ sky130_fd_sc_hd__xnor2_1
XFILLER_17_385 VGND VGND VPWR VPWR sky130_fd_sc_hd__decap_6
X_11879_ _04820_ _04823_ _04822_ VGND VGND VPWR VPWR _04832_ sky130_fd_sc_hd__o21ai_1
XTAP_TAPCELL_ROW_43_895 VGND VPWR sky130_fd_sc_hd__tapvpwrvgnd_1
XFILLER_118_405 VGND VGND VPWR VPWR sky130_fd_sc_hd__fill_1
X_07070_ _06237_ _06248_ _06270_ VGND VGND VPWR VPWR _06292_ sky130_fd_sc_hd__a21oi_1
XFILLER_118_427 VGND VGND VPWR VPWR sky130_fd_sc_hd__fill_1
XFILLER_113_110 VGND VGND VPWR VPWR sky130_fd_sc_hd__fill_2
XFILLER_114_688 VPWR VGND VPWR VGND sky130_ef_sc_hd__decap_12
XFILLER_99_366 VPWR VGND VPWR VGND sky130_ef_sc_hd__decap_12
XFILLER_99_355 VGND VGND VPWR VPWR sky130_fd_sc_hd__decap_4
XTAP_TAPCELL_ROW_93_1599 VGND VPWR sky130_fd_sc_hd__tapvpwrvgnd_1
X_07972_ _00612_ _00614_ _00707_ VGND VGND VPWR VPWR _00709_ sky130_fd_sc_hd__or3b_1
X_09711_ _02466_ _02471_ VGND VGND VPWR VPWR _02473_ sky130_fd_sc_hd__xnor2_1
XFILLER_87_539 VGND VGND VPWR VPWR sky130_fd_sc_hd__decap_6
X_06923_ _03915_ _04675_ _04665_ VGND VGND VPWR VPWR _04686_ sky130_fd_sc_hd__nor3_4
X_06854_ net460 net607 VGND VGND VPWR VPWR _03937_ sky130_fd_sc_hd__nand2_1
X_09642_ _02397_ _02396_ VGND VGND VPWR VPWR _02398_ sky130_fd_sc_hd__nand2b_1
XFILLER_67_285 VGND VGND VPWR VPWR sky130_fd_sc_hd__fill_1
X_06785_ _03162_ _03173_ VGND VGND VPWR VPWR _03183_ sky130_fd_sc_hd__and2b_1
XTAP_TAPCELL_ROW_124_2032 VGND VPWR sky130_fd_sc_hd__tapvpwrvgnd_1
X_09573_ _02191_ _02207_ _02206_ VGND VGND VPWR VPWR _02323_ sky130_fd_sc_hd__a21oi_1
X_08524_ net700 net329 VGND VGND VPWR VPWR _01253_ sky130_fd_sc_hd__nand2_1
X_08455_ _01182_ _01183_ VGND VGND VPWR VPWR _01184_ sky130_fd_sc_hd__nor2_1
X_07406_ net318 _00144_ _00145_ VGND VGND VPWR VPWR _00147_ sky130_fd_sc_hd__and3_1
X_08386_ net692 net265 net262 net270 VGND VGND VPWR VPWR _01117_ sky130_fd_sc_hd__a22oi_1
XFILLER_50_185 VGND VGND VPWR VPWR sky130_fd_sc_hd__decap_8
XFILLER_50_174 VGND VGND VPWR VPWR sky130_fd_sc_hd__decap_4
XFILLER_50_152 VGND VGND VPWR VPWR sky130_fd_sc_hd__fill_2
XFILLER_109_405 VPWR VGND VPWR VGND sky130_ef_sc_hd__decap_12
X_07337_ _06621_ _06627_ VGND VGND VPWR VPWR _06628_ sky130_fd_sc_hd__xnor2_1
XTAP_TAPCELL_ROW_135_2183 VGND VPWR sky130_fd_sc_hd__tapvpwrvgnd_1
XFILLER_109_449 VPWR VGND VPWR VGND sky130_ef_sc_hd__decap_12
X_07268_ net461 net602 _06558_ VGND VGND VPWR VPWR _06559_ sky130_fd_sc_hd__and3_1
XTAP_TAPCELL_ROW_21_589 VGND VPWR sky130_fd_sc_hd__tapvpwrvgnd_1
XFILLER_136_279 VGND VGND VPWR VPWR sky130_fd_sc_hd__fill_1
XFILLER_124_419 VGND VGND VPWR VPWR sky130_fd_sc_hd__fill_1
X_07199_ net916 _06194_ _06489_ _06490_ VGND VGND VPWR VPWR _06491_ sky130_fd_sc_hd__o211a_1
X_09007_ _01518_ _01571_ _01570_ VGND VGND VPWR VPWR _01733_ sky130_fd_sc_hd__a21bo_1
XFILLER_3_727 VGND VGND VPWR VPWR sky130_fd_sc_hd__fill_1
XFILLER_132_441 VPWR VGND VPWR VGND sky130_ef_sc_hd__decap_12
XTAP_TAPCELL_ROW_53_1038 VGND VPWR sky130_fd_sc_hd__tapvpwrvgnd_1
XFILLER_116_53 VGND VGND VPWR VPWR sky130_fd_sc_hd__decap_8
Xfanout530 net18 VGND VGND VPWR VPWR net530 sky130_fd_sc_hd__clkbuf_4
Xfanout541 net547 VGND VGND VPWR VPWR net541 sky130_fd_sc_hd__buf_2
X_09909_ _02421_ _02547_ VGND VGND VPWR VPWR _02689_ sky130_fd_sc_hd__or2_1
Xfanout552 net157 VGND VGND VPWR VPWR net552 sky130_fd_sc_hd__buf_2
XFILLER_59_775 VGND VGND VPWR VPWR sky130_fd_sc_hd__fill_2
XFILLER_59_742 VGND VGND VPWR VPWR sky130_fd_sc_hd__decap_6
Xfanout563 net150 VGND VGND VPWR VPWR net563 sky130_fd_sc_hd__buf_2
Xfanout574 net149 VGND VGND VPWR VPWR net574 sky130_fd_sc_hd__buf_2
Xfanout596 net597 VGND VGND VPWR VPWR net596 sky130_fd_sc_hd__buf_2
XTAP_TAPCELL_ROW_109_1827 VGND VPWR sky130_fd_sc_hd__tapvpwrvgnd_1
XTAP_TAPCELL_ROW_109_1816 VGND VPWR sky130_fd_sc_hd__tapvpwrvgnd_1
XFILLER_74_734 VPWR VGND VPWR VGND sky130_ef_sc_hd__decap_12
XFILLER_74_701 VGND VGND VPWR VPWR sky130_fd_sc_hd__decap_8
XFILLER_58_285 VGND VGND VPWR VPWR sky130_fd_sc_hd__fill_1
Xfanout585 net142 VGND VGND VPWR VPWR net585 sky130_fd_sc_hd__buf_2
XFILLER_18_105 VGND VGND VPWR VPWR sky130_fd_sc_hd__decap_3
X_12920_ _05744_ _05868_ _05613_ VGND VGND VPWR VPWR _05968_ sky130_fd_sc_hd__o21a_1
XFILLER_132_41 VPWR VGND VPWR VGND sky130_ef_sc_hd__decap_12
XFILLER_100_382 VPWR VGND VPWR VGND sky130_ef_sc_hd__decap_12
X_12851_ net404 net585 net583 net412 VGND VGND VPWR VPWR _05893_ sky130_fd_sc_hd__a22oi_1
XFILLER_132_85 VPWR VGND VPWR VGND sky130_ef_sc_hd__decap_12
XFILLER_61_417 VPWR VGND VPWR VGND sky130_ef_sc_hd__decap_12
X_11802_ _04744_ _04746_ VGND VGND VPWR VPWR _04747_ sky130_fd_sc_hd__nor2_1
Xrebuffer90 _04773_ VGND VGND VPWR VPWR net790 sky130_fd_sc_hd__dlymetal6s2s_1
XFILLER_54_491 VGND VGND VPWR VPWR sky130_fd_sc_hd__decap_3
X_12782_ _05507_ _05684_ _05682_ VGND VGND VPWR VPWR _05817_ sky130_fd_sc_hd__a21oi_1
X_11733_ _04636_ _04669_ _04670_ VGND VGND VPWR VPWR _04671_ sky130_fd_sc_hd__a21o_1
XFILLER_14_333 VPWR VGND VPWR VGND sky130_ef_sc_hd__decap_12
XTAP_TAPCELL_ROW_64_1189 VGND VPWR sky130_fd_sc_hd__tapvpwrvgnd_1
X_11664_ net534 net106 _04596_ _04595_ _04594_ VGND VGND VPWR VPWR _04597_ sky130_fd_sc_hd__a32o_1
XFILLER_25_83 VGND VGND VPWR VPWR sky130_fd_sc_hd__decap_6
XFILLER_42_697 VGND VGND VPWR VPWR sky130_fd_sc_hd__decap_3
X_13403_ clknet_3_7__leaf_clk _00010_ _00113_ VGND VGND VPWR VPWR net217 sky130_fd_sc_hd__dfrtp_1
X_10615_ _03449_ _03452_ _03453_ VGND VGND VPWR VPWR _03454_ sky130_fd_sc_hd__and3_1
XTAP_TAPCELL_ROW_40_854 VGND VPWR sky130_fd_sc_hd__tapvpwrvgnd_1
XFILLER_128_725 VPWR VGND VPWR VGND sky130_ef_sc_hd__decap_12
X_11595_ _04497_ _04500_ VGND VGND VPWR VPWR _04524_ sky130_fd_sc_hd__or2_1
XFILLER_128_769 VPWR VGND VPWR VGND sky130_ef_sc_hd__decap_12
X_10546_ _03374_ _03375_ VGND VGND VPWR VPWR _03378_ sky130_fd_sc_hd__xor2_1
X_13334_ net393 VGND VGND VPWR VPWR _00108_ sky130_fd_sc_hd__inv_2
X_10477_ _03299_ _03300_ _03301_ VGND VGND VPWR VPWR _03304_ sky130_fd_sc_hd__a21o_1
XFILLER_6_587 VGND VGND VPWR VPWR sky130_fd_sc_hd__fill_1
X_13265_ _06291_ _06294_ VGND VGND VPWR VPWR _06343_ sky130_fd_sc_hd__and2b_1
X_12216_ _05196_ _05197_ VGND VGND VPWR VPWR _05198_ sky130_fd_sc_hd__nand2_1
XFILLER_123_452 VPWR VGND VPWR VGND sky130_ef_sc_hd__decap_12
XPHY_EDGE_ROW_102_Left_239 VGND VGND VPWR VPWR sky130_fd_sc_hd__decap_3
XFILLER_96_303 VGND VGND VPWR VPWR sky130_fd_sc_hd__decap_4
XFILLER_69_517 VGND VGND VPWR VPWR sky130_fd_sc_hd__fill_2
X_13196_ _06267_ _06268_ VGND VGND VPWR VPWR _06269_ sky130_fd_sc_hd__and2b_1
X_12147_ net777 _04974_ _05121_ _05122_ VGND VGND VPWR VPWR _05124_ sky130_fd_sc_hd__o211ai_4
XFILLER_2_793 VPWR VGND VPWR VGND sky130_ef_sc_hd__decap_12
XFILLER_111_658 VGND VGND VPWR VPWR sky130_fd_sc_hd__decap_6
XFILLER_77_550 VGND VGND VPWR VPWR sky130_fd_sc_hd__decap_8
X_12078_ _05040_ _05048_ VGND VGND VPWR VPWR _05049_ sky130_fd_sc_hd__nand2_1
XFILLER_1_281 VPWR VGND VPWR VGND sky130_ef_sc_hd__decap_12
XFILLER_77_561 VGND VGND VPWR VPWR sky130_fd_sc_hd__fill_2
XFILLER_2_65 VPWR VGND VPWR VGND sky130_ef_sc_hd__decap_12
X_11029_ _03866_ _03905_ VGND VGND VPWR VPWR _03907_ sky130_fd_sc_hd__xnor2_1
XFILLER_92_531 VGND VGND VPWR VPWR sky130_fd_sc_hd__fill_1
XFILLER_65_756 VPWR VGND VPWR VGND sky130_ef_sc_hd__decap_12
XFILLER_92_586 VGND VGND VPWR VPWR sky130_fd_sc_hd__fill_2
XTAP_TAPCELL_ROW_48_965 VGND VPWR sky130_fd_sc_hd__tapvpwrvgnd_1
XFILLER_80_737 VGND VGND VPWR VPWR sky130_fd_sc_hd__fill_2
XFILLER_64_299 VGND VGND VPWR VPWR sky130_fd_sc_hd__fill_1
XPHY_EDGE_ROW_111_Left_248 VGND VGND VPWR VPWR sky130_fd_sc_hd__decap_3
XFILLER_32_141 VPWR VGND VPWR VGND sky130_ef_sc_hd__decap_12
X_08240_ net410 _00184_ _00187_ _00871_ VGND VGND VPWR VPWR _00975_ sky130_fd_sc_hd__o22a_1
X_08171_ net249 _00905_ VGND VGND VPWR VPWR _00907_ sky130_fd_sc_hd__xnor2_1
XANTENNA_26 net491 VGND VGND VPWR VPWR sky130_fd_sc_hd__diode_2
XANTENNA_15 net17 VGND VGND VPWR VPWR sky130_fd_sc_hd__diode_2
X_07122_ _05396_ _05418_ _05407_ VGND VGND VPWR VPWR _06414_ sky130_fd_sc_hd__o21bai_1
XFILLER_21_19 VGND VGND VPWR VPWR sky130_fd_sc_hd__decap_8
XFILLER_118_246 VGND VGND VPWR VPWR sky130_fd_sc_hd__fill_1
XTAP_TAPCELL_ROW_95_1628 VGND VPWR sky130_fd_sc_hd__tapvpwrvgnd_1
XFILLER_106_419 VGND VGND VPWR VPWR sky130_fd_sc_hd__fill_1
X_07053_ _05779_ _05790_ _06074_ _06085_ VGND VGND VPWR VPWR _06106_ sky130_fd_sc_hd__o22a_1
XPHY_EDGE_ROW_120_Left_257 VGND VGND VPWR VPWR sky130_fd_sc_hd__decap_3
Xoutput177 net177 VGND VGND VPWR VPWR out0[9] sky130_fd_sc_hd__buf_2
Xoutput166 net166 VGND VGND VPWR VPWR out0[13] sky130_fd_sc_hd__buf_2
XFILLER_114_452 VGND VGND VPWR VPWR sky130_fd_sc_hd__decap_8
XFILLER_87_303 VPWR VGND VPWR VGND sky130_ef_sc_hd__decap_12
XFILLER_102_636 VGND VGND VPWR VPWR sky130_fd_sc_hd__decap_8
XFILLER_101_102 VGND VGND VPWR VPWR sky130_fd_sc_hd__fill_1
Xoutput188 net188 VGND VGND VPWR VPWR out1[4] sky130_fd_sc_hd__buf_2
Xoutput199 net199 VGND VGND VPWR VPWR out2[14] sky130_fd_sc_hd__buf_2
X_07955_ _00615_ _00691_ VGND VGND VPWR VPWR _00693_ sky130_fd_sc_hd__xnor2_2
XFILLER_101_146 VGND VGND VPWR VPWR sky130_fd_sc_hd__decap_6
XFILLER_87_358 VGND VGND VPWR VPWR sky130_fd_sc_hd__decap_3
X_06906_ _04472_ _04483_ _04494_ VGND VGND VPWR VPWR _04505_ sky130_fd_sc_hd__nand3_1
XFILLER_56_701 VPWR VGND VPWR VGND sky130_ef_sc_hd__decap_12
XFILLER_28_403 VPWR VGND VPWR VGND sky130_ef_sc_hd__decap_12
XFILLER_95_391 VGND VGND VPWR VPWR sky130_fd_sc_hd__fill_1
X_07886_ _00621_ _00622_ VGND VGND VPWR VPWR _00624_ sky130_fd_sc_hd__xnor2_1
X_09625_ _02165_ _02378_ VGND VGND VPWR VPWR _02379_ sky130_fd_sc_hd__xor2_1
X_06837_ _03729_ _03740_ VGND VGND VPWR VPWR _03751_ sky130_fd_sc_hd__nor2_1
XFILLER_43_417 VPWR VGND VPWR VGND sky130_ef_sc_hd__decap_12
X_06768_ _02965_ _02976_ VGND VGND VPWR VPWR _02998_ sky130_fd_sc_hd__nand2_1
X_09556_ _02198_ _02204_ _02202_ VGND VGND VPWR VPWR _02305_ sky130_fd_sc_hd__a21oi_1
X_09487_ _02228_ _02229_ VGND VGND VPWR VPWR _02231_ sky130_fd_sc_hd__xor2_1
XTAP_TAPCELL_ROW_104_1757 VGND VPWR sky130_fd_sc_hd__tapvpwrvgnd_1
XTAP_TAPCELL_ROW_104_1746 VGND VPWR sky130_fd_sc_hd__tapvpwrvgnd_1
X_08507_ _01234_ _01235_ VGND VGND VPWR VPWR _01236_ sky130_fd_sc_hd__and2b_1
XFILLER_62_15 VGND VGND VPWR VPWR sky130_fd_sc_hd__decap_3
X_06699_ net153 VGND VGND VPWR VPWR _02251_ sky130_fd_sc_hd__inv_2
XFILLER_24_664 VPWR VGND VPWR VGND sky130_ef_sc_hd__decap_12
XTAP_TAPCELL_ROW_26_659 VGND VPWR sky130_fd_sc_hd__tapvpwrvgnd_1
X_08438_ net535 net530 net632 net630 VGND VGND VPWR VPWR _01167_ sky130_fd_sc_hd__and4_1
XFILLER_62_48 VGND VGND VPWR VPWR sky130_fd_sc_hd__decap_4
X_08369_ _01098_ _01099_ VGND VGND VPWR VPWR _01100_ sky130_fd_sc_hd__nor2_1
XFILLER_7_329 VGND VGND VPWR VPWR sky130_fd_sc_hd__decap_6
X_10400_ _03215_ _03218_ VGND VGND VPWR VPWR _03220_ sky130_fd_sc_hd__and2b_1
X_11380_ _03687_ _03855_ _03857_ _04016_ _04159_ VGND VGND VPWR VPWR _04291_ sky130_fd_sc_hd__o2111ai_1
X_10331_ net751 _03143_ _03144_ VGND VGND VPWR VPWR _03145_ sky130_fd_sc_hd__nand3_1
X_10262_ net591 net282 net280 net616 VGND VGND VPWR VPWR _03069_ sky130_fd_sc_hd__a22o_1
X_13050_ _06097_ _06109_ VGND VGND VPWR VPWR _06110_ sky130_fd_sc_hd__xor2_1
X_12001_ _04912_ _04963_ _04962_ VGND VGND VPWR VPWR _04965_ sky130_fd_sc_hd__or3_4
XFILLER_2_3 VPWR VGND VPWR VGND sky130_ef_sc_hd__decap_12
XFILLER_133_783 VGND VGND VPWR VPWR sky130_fd_sc_hd__fill_1
XFILLER_105_474 VGND VGND VPWR VPWR sky130_fd_sc_hd__decap_4
X_10193_ _02984_ _02985_ _02992_ VGND VGND VPWR VPWR _02994_ sky130_fd_sc_hd__a21o_1
Xfanout382 net39 VGND VGND VPWR VPWR net382 sky130_fd_sc_hd__dlymetal6s2s_1
Xfanout371 net42 VGND VGND VPWR VPWR net371 sky130_fd_sc_hd__buf_6
Xfanout360 net49 VGND VGND VPWR VPWR net360 sky130_fd_sc_hd__buf_2
XTAP_TAPCELL_ROW_6_384 VGND VPWR sky130_fd_sc_hd__tapvpwrvgnd_1
XTAP_TAPCELL_ROW_6_373 VGND VPWR sky130_fd_sc_hd__tapvpwrvgnd_1
Xfanout393 net395 VGND VGND VPWR VPWR net393 sky130_fd_sc_hd__buf_2
XFILLER_46_222 VGND VGND VPWR VPWR sky130_fd_sc_hd__fill_1
X_12903_ _05820_ _05949_ VGND VGND VPWR VPWR _05950_ sky130_fd_sc_hd__xnor2_1
XTAP_TAPCELL_ROW_66_1218 VGND VPWR sky130_fd_sc_hd__tapvpwrvgnd_1
XFILLER_62_726 VGND VGND VPWR VPWR sky130_fd_sc_hd__decap_3
XTAP_TAPCELL_ROW_45_924 VGND VPWR sky130_fd_sc_hd__tapvpwrvgnd_1
X_12834_ net334 net362 _05749_ _05748_ net315 VGND VGND VPWR VPWR _05874_ sky130_fd_sc_hd__a32o_1
XFILLER_27_480 VPWR VGND VPWR VGND sky130_ef_sc_hd__decap_12
X_12765_ _05639_ _05641_ _05797_ VGND VGND VPWR VPWR _05799_ sky130_fd_sc_hd__and3_1
X_11716_ _04651_ _04652_ VGND VGND VPWR VPWR _04653_ sky130_fd_sc_hd__nor2_1
XFILLER_14_141 VGND VGND VPWR VPWR sky130_fd_sc_hd__decap_6
XFILLER_30_601 VPWR VGND VPWR VGND sky130_ef_sc_hd__decap_12
XFILLER_42_450 VGND VGND VPWR VPWR sky130_fd_sc_hd__decap_4
X_12696_ _05719_ _05720_ _05722_ VGND VGND VPWR VPWR _05723_ sky130_fd_sc_hd__or3_1
XFILLER_30_645 VPWR VGND VPWR VGND sky130_ef_sc_hd__decap_12
Xinput13 in1[4] VGND VGND VPWR VPWR net13 sky130_fd_sc_hd__buf_1
X_11647_ net269 net301 VGND VGND VPWR VPWR _04580_ sky130_fd_sc_hd__nand2_1
Xinput24 in2[7] VGND VGND VPWR VPWR net24 sky130_fd_sc_hd__clkbuf_1
Xinput35 w00[1] VGND VGND VPWR VPWR net35 sky130_fd_sc_hd__buf_1
Xinput46 w01[4] VGND VGND VPWR VPWR net46 sky130_fd_sc_hd__buf_1
X_11578_ _04240_ _04375_ _04373_ VGND VGND VPWR VPWR _04507_ sky130_fd_sc_hd__a21oi_1
Xinput68 w10[2] VGND VGND VPWR VPWR net68 sky130_fd_sc_hd__buf_1
X_10529_ _03195_ _03198_ _03358_ VGND VGND VPWR VPWR _03360_ sky130_fd_sc_hd__nand3_1
X_13317_ net396 VGND VGND VPWR VPWR _00091_ sky130_fd_sc_hd__inv_2
Xinput79 w11[5] VGND VGND VPWR VPWR net79 sky130_fd_sc_hd__buf_1
Xinput57 w02[7] VGND VGND VPWR VPWR net57 sky130_fd_sc_hd__buf_1
XTAP_TAPCELL_ROW_77_1369 VGND VPWR sky130_fd_sc_hd__tapvpwrvgnd_1
XFILLER_131_709 VPWR VGND VPWR VGND sky130_ef_sc_hd__decap_12
X_13248_ _06220_ _06228_ _06225_ VGND VGND VPWR VPWR _06325_ sky130_fd_sc_hd__a21bo_1
XTAP_TAPCELL_ROW_90_1558 VGND VPWR sky130_fd_sc_hd__tapvpwrvgnd_1
X_13179_ net404 _05386_ _06250_ VGND VGND VPWR VPWR _06251_ sky130_fd_sc_hd__o21a_1
XFILLER_123_293 VPWR VGND VPWR VGND sky130_ef_sc_hd__decap_12
XFILLER_111_466 VGND VGND VPWR VPWR sky130_fd_sc_hd__decap_4
X_07740_ net490 net679 net678 net497 VGND VGND VPWR VPWR _00479_ sky130_fd_sc_hd__a22oi_1
XFILLER_65_542 VPWR VGND VPWR VGND sky130_ef_sc_hd__decap_12
XFILLER_92_361 VGND VGND VPWR VPWR sky130_fd_sc_hd__decap_3
X_07671_ _00408_ _00409_ _00377_ VGND VGND VPWR VPWR _00411_ sky130_fd_sc_hd__a21oi_1
XFILLER_80_501 VPWR VGND VPWR VGND sky130_ef_sc_hd__decap_12
X_09410_ _02135_ _02145_ VGND VGND VPWR VPWR _02146_ sky130_fd_sc_hd__xnor2_1
XFILLER_53_748 VGND VGND VPWR VPWR sky130_fd_sc_hd__decap_4
XFILLER_25_428 VGND VGND VPWR VPWR sky130_fd_sc_hd__fill_1
X_09341_ _02068_ _02069_ _01904_ _01906_ VGND VGND VPWR VPWR _02071_ sky130_fd_sc_hd__a211o_1
XFILLER_52_247 VGND VGND VPWR VPWR sky130_fd_sc_hd__decap_4
XFILLER_21_601 VGND VGND VPWR VPWR sky130_fd_sc_hd__fill_1
XTAP_TAPCELL_ROW_23_618 VGND VPWR sky130_fd_sc_hd__tapvpwrvgnd_1
X_09272_ _01983_ _01995_ VGND VGND VPWR VPWR _01996_ sky130_fd_sc_hd__xnor2_1
XFILLER_60_280 VGND VGND VPWR VPWR sky130_fd_sc_hd__decap_8
XFILLER_21_623 VPWR VGND VPWR VGND sky130_ef_sc_hd__decap_12
XFILLER_21_656 VGND VGND VPWR VPWR sky130_fd_sc_hd__decap_4
XFILLER_32_29 VPWR VGND VPWR VGND sky130_ef_sc_hd__decap_12
X_08223_ _00952_ _00957_ VGND VGND VPWR VPWR _00958_ sky130_fd_sc_hd__nand2b_1
XFILLER_20_166 VGND VGND VPWR VPWR sky130_fd_sc_hd__decap_4
X_08154_ _00886_ _00887_ VGND VGND VPWR VPWR _00890_ sky130_fd_sc_hd__xnor2_1
X_08085_ _00820_ _00821_ VGND VGND VPWR VPWR _00822_ sky130_fd_sc_hd__nand2_1
X_07105_ _06393_ _06395_ VGND VGND VPWR VPWR _06397_ sky130_fd_sc_hd__and2b_1
XFILLER_134_525 VGND VGND VPWR VPWR sky130_fd_sc_hd__decap_6
XTAP_TAPCELL_ROW_132_2142 VGND VPWR sky130_fd_sc_hd__tapvpwrvgnd_1
X_07036_ _05888_ _05899_ _05910_ VGND VGND VPWR VPWR _05921_ sky130_fd_sc_hd__or3_4
XFILLER_134_569 VPWR VGND VPWR VGND sky130_ef_sc_hd__decap_12
XFILLER_106_249 VGND VGND VPWR VPWR sky130_fd_sc_hd__decap_3
XFILLER_88_601 VPWR VGND VPWR VGND sky130_ef_sc_hd__decap_12
XFILLER_114_260 VPWR VGND VPWR VGND sky130_ef_sc_hd__decap_12
XFILLER_0_505 VGND VGND VPWR VPWR sky130_fd_sc_hd__fill_2
XFILLER_0_527 VGND VGND VPWR VPWR sky130_fd_sc_hd__fill_1
XFILLER_0_538 VGND VGND VPWR VPWR sky130_fd_sc_hd__decap_4
XFILLER_102_433 VGND VGND VPWR VPWR sky130_fd_sc_hd__fill_2
XFILLER_88_656 VGND VGND VPWR VPWR sky130_fd_sc_hd__fill_1
X_08987_ net624 _01712_ VGND VGND VPWR VPWR _01713_ sky130_fd_sc_hd__xnor2_1
X_07938_ _06561_ _00675_ VGND VGND VPWR VPWR _00676_ sky130_fd_sc_hd__xnor2_1
XFILLER_87_199 VGND VGND VPWR VPWR sky130_fd_sc_hd__decap_6
XFILLER_87_188 VGND VGND VPWR VPWR sky130_fd_sc_hd__decap_4
XFILLER_56_531 VGND VGND VPWR VPWR sky130_fd_sc_hd__fill_1
XTAP_TAPCELL_ROW_3_343 VGND VPWR sky130_fd_sc_hd__tapvpwrvgnd_1
XTAP_TAPCELL_ROW_3_332 VGND VPWR sky130_fd_sc_hd__tapvpwrvgnd_1
X_07869_ _00456_ _00465_ _00464_ VGND VGND VPWR VPWR _00607_ sky130_fd_sc_hd__a21oi_1
XFILLER_90_309 VGND VGND VPWR VPWR sky130_fd_sc_hd__decap_8
XFILLER_56_542 VGND VGND VPWR VPWR sky130_fd_sc_hd__fill_1
XFILLER_28_233 VGND VGND VPWR VPWR sky130_fd_sc_hd__decap_3
X_09608_ _02359_ _02361_ VGND VGND VPWR VPWR _02362_ sky130_fd_sc_hd__nor2_1
XFILLER_113_76 VGND VGND VPWR VPWR sky130_fd_sc_hd__decap_4
XFILLER_56_597 VGND VGND VPWR VPWR sky130_fd_sc_hd__fill_1
XFILLER_43_225 VPWR VGND VPWR VGND sky130_ef_sc_hd__decap_12
XFILLER_43_214 VGND VGND VPWR VPWR sky130_fd_sc_hd__fill_1
X_10880_ _03621_ _03623_ VGND VGND VPWR VPWR _03744_ sky130_fd_sc_hd__nor2_1
X_09539_ _02165_ _02170_ net248 VGND VGND VPWR VPWR _02287_ sky130_fd_sc_hd__a21oi_1
XFILLER_71_545 VPWR VGND VPWR VGND sky130_ef_sc_hd__decap_12
XFILLER_24_450 VGND VGND VPWR VPWR sky130_fd_sc_hd__fill_1
XTAP_TAPCELL_ROW_61_1148 VGND VPWR sky130_fd_sc_hd__tapvpwrvgnd_1
XFILLER_11_100 VPWR VGND VPWR VGND sky130_ef_sc_hd__decap_12
XFILLER_12_645 VGND VGND VPWR VPWR sky130_fd_sc_hd__decap_4
X_12550_ net454 net582 _05405_ _05404_ VGND VGND VPWR VPWR _05564_ sky130_fd_sc_hd__a31o_1
X_12481_ _05486_ _05487_ VGND VGND VPWR VPWR _05489_ sky130_fd_sc_hd__nand2_2
X_11501_ _03426_ _04420_ _04302_ VGND VGND VPWR VPWR _04422_ sky130_fd_sc_hd__o21a_1
XTAP_TAPCELL_ROW_50_993 VGND VPWR sky130_fd_sc_hd__tapvpwrvgnd_1
XFILLER_11_177 VPWR VGND VPWR VGND sky130_ef_sc_hd__decap_12
XFILLER_11_166 VGND VGND VPWR VPWR sky130_fd_sc_hd__fill_2
XFILLER_7_126 VPWR VGND VPWR VGND sky130_ef_sc_hd__decap_12
X_11432_ _04342_ _04345_ VGND VGND VPWR VPWR _04347_ sky130_fd_sc_hd__xnor2_1
XTAP_TAPCELL_ROW_117_1937 VGND VPWR sky130_fd_sc_hd__tapvpwrvgnd_1
XTAP_TAPCELL_ROW_117_1926 VGND VPWR sky130_fd_sc_hd__tapvpwrvgnd_1
X_13102_ net567 net541 net284 net81 VGND VGND VPWR VPWR _06167_ sky130_fd_sc_hd__and4b_1
X_11363_ _04238_ _04271_ VGND VGND VPWR VPWR _04272_ sky130_fd_sc_hd__and2b_1
X_10314_ _03115_ _03125_ VGND VGND VPWR VPWR _03126_ sky130_fd_sc_hd__xnor2_1
X_11294_ _04093_ _04195_ VGND VGND VPWR VPWR _04196_ sky130_fd_sc_hd__xnor2_1
XFILLER_106_772 VGND VGND VPWR VPWR sky130_fd_sc_hd__decap_8
XFILLER_98_99 VPWR VGND VPWR VGND sky130_ef_sc_hd__decap_12
X_10245_ net226 _03047_ _02852_ _02863_ VGND VGND VPWR VPWR _03051_ sky130_fd_sc_hd__o211ai_1
X_13033_ _05955_ _05956_ _05810_ _05811_ VGND VGND VPWR VPWR _06092_ sky130_fd_sc_hd__a211o_1
XFILLER_121_753 VPWR VGND VPWR VGND sky130_ef_sc_hd__decap_12
XFILLER_105_293 VGND VGND VPWR VPWR sky130_fd_sc_hd__decap_6
X_10176_ net746 _02973_ _02971_ VGND VGND VPWR VPWR _02975_ sky130_fd_sc_hd__o21ai_1
XFILLER_121_797 VGND VGND VPWR VPWR sky130_fd_sc_hd__decap_6
XFILLER_94_615 VGND VGND VPWR VPWR sky130_fd_sc_hd__decap_4
XTAP_TAPCELL_ROW_72_1299 VGND VPWR sky130_fd_sc_hd__tapvpwrvgnd_1
XFILLER_66_306 VGND VGND VPWR VPWR sky130_fd_sc_hd__fill_2
XFILLER_93_125 VGND VGND VPWR VPWR sky130_fd_sc_hd__decap_4
XFILLER_78_188 VGND VGND VPWR VPWR sky130_fd_sc_hd__decap_8
XFILLER_47_531 VGND VGND VPWR VPWR sky130_fd_sc_hd__decap_6
XFILLER_93_158 VGND VGND VPWR VPWR sky130_fd_sc_hd__fill_1
XFILLER_35_726 VGND VGND VPWR VPWR sky130_fd_sc_hd__fill_2
X_12817_ _05852_ _05853_ VGND VGND VPWR VPWR _05856_ sky130_fd_sc_hd__or2_1
XFILLER_50_718 VGND VGND VPWR VPWR sky130_fd_sc_hd__decap_4
XFILLER_43_781 VGND VGND VPWR VPWR sky130_fd_sc_hd__decap_3
XFILLER_15_461 VPWR VGND VPWR VGND sky130_ef_sc_hd__decap_12
XFILLER_63_91 VPWR VGND VPWR VGND sky130_ef_sc_hd__decap_12
X_12748_ net405 net587 VGND VGND VPWR VPWR _05781_ sky130_fd_sc_hd__and2_1
XFILLER_42_291 VPWR VGND VPWR VGND sky130_ef_sc_hd__decap_12
XFILLER_30_453 VGND VGND VPWR VPWR sky130_fd_sc_hd__fill_1
XFILLER_30_464 VPWR VGND VPWR VGND sky130_ef_sc_hd__decap_12
X_12679_ _05703_ _05704_ VGND VGND VPWR VPWR _05705_ sky130_fd_sc_hd__and2_1
XFILLER_8_53 VPWR VGND VPWR VGND sky130_ef_sc_hd__decap_12
XFILLER_7_671 VGND VGND VPWR VPWR sky130_fd_sc_hd__fill_1
XFILLER_131_517 VPWR VGND VPWR VGND sky130_ef_sc_hd__decap_12
X_08910_ _01594_ _01634_ VGND VGND VPWR VPWR _01636_ sky130_fd_sc_hd__xnor2_1
X_09890_ _02532_ _02536_ _02667_ VGND VGND VPWR VPWR _02668_ sky130_fd_sc_hd__a21oi_1
XFILLER_69_100 VPWR VGND VPWR VGND sky130_ef_sc_hd__decap_12
XFILLER_112_753 VGND VGND VPWR VPWR sky130_fd_sc_hd__decap_3
XFILLER_97_420 VGND VGND VPWR VPWR sky130_fd_sc_hd__decap_3
X_08841_ _01539_ _01566_ _01567_ VGND VGND VPWR VPWR _01568_ sky130_fd_sc_hd__nand3_1
XFILLER_69_144 VGND VGND VPWR VPWR sky130_fd_sc_hd__fill_1
XFILLER_57_317 VGND VGND VPWR VPWR sky130_fd_sc_hd__fill_2
XFILLER_111_296 VPWR VGND VPWR VGND sky130_ef_sc_hd__decap_12
X_08772_ _01495_ _01497_ _01498_ VGND VGND VPWR VPWR _01499_ sky130_fd_sc_hd__nand3b_1
XFILLER_85_659 VPWR VGND VPWR VGND sky130_ef_sc_hd__decap_12
XFILLER_84_114 VGND VGND VPWR VPWR sky130_fd_sc_hd__fill_2
XFILLER_38_531 VGND VGND VPWR VPWR sky130_fd_sc_hd__fill_1
X_07723_ _00310_ _00460_ VGND VGND VPWR VPWR _00462_ sky130_fd_sc_hd__xor2_1
XFILLER_38_553 VGND VGND VPWR VPWR sky130_fd_sc_hd__decap_8
XFILLER_81_810 VGND VGND VPWR VPWR sky130_fd_sc_hd__fill_1
X_07654_ _00390_ _00391_ _00392_ VGND VGND VPWR VPWR _00394_ sky130_fd_sc_hd__o21bai_1
XFILLER_65_361 VGND VGND VPWR VPWR sky130_fd_sc_hd__decap_8
XFILLER_53_501 VGND VGND VPWR VPWR sky130_fd_sc_hd__decap_3
X_07585_ _00286_ _00323_ VGND VGND VPWR VPWR _00325_ sky130_fd_sc_hd__xnor2_1
XTAP_TAPCELL_ROW_101_1705 VGND VPWR sky130_fd_sc_hd__tapvpwrvgnd_1
XFILLER_53_578 VPWR VGND VPWR VGND sky130_ef_sc_hd__decap_12
X_09324_ _01883_ _01885_ _02050_ _02051_ VGND VGND VPWR VPWR _02052_ sky130_fd_sc_hd__o211ai_2
XFILLER_21_420 VGND VGND VPWR VPWR sky130_fd_sc_hd__fill_2
XTAP_TAPCELL_ROW_36_798 VGND VPWR sky130_fd_sc_hd__tapvpwrvgnd_1
X_09255_ net501 net628 _01811_ _01810_ VGND VGND VPWR VPWR _01979_ sky130_fd_sc_hd__a31o_1
X_08206_ _06587_ _00836_ _00835_ VGND VGND VPWR VPWR _00941_ sky130_fd_sc_hd__a21oi_1
XFILLER_21_486 VGND VGND VPWR VPWR sky130_fd_sc_hd__fill_1
XFILLER_21_497 VGND VGND VPWR VPWR sky130_fd_sc_hd__decap_6
X_09186_ _01591_ _01908_ _01909_ VGND VGND VPWR VPWR _01911_ sky130_fd_sc_hd__or3_4
XFILLER_107_503 VGND VGND VPWR VPWR sky130_fd_sc_hd__fill_1
XFILLER_107_547 VGND VGND VPWR VPWR sky130_fd_sc_hd__decap_6
X_08137_ _00186_ _00872_ VGND VGND VPWR VPWR _00873_ sky130_fd_sc_hd__xnor2_1
XFILLER_134_333 VPWR VGND VPWR VGND sky130_ef_sc_hd__decap_12
X_08068_ _00803_ _00804_ VGND VGND VPWR VPWR _00805_ sky130_fd_sc_hd__nand2b_1
XTAP_TAPCELL_ROW_8_402 VGND VPWR sky130_fd_sc_hd__tapvpwrvgnd_1
XFILLER_134_377 VGND VGND VPWR VPWR sky130_fd_sc_hd__fill_1
X_07019_ _05702_ _05713_ _05724_ VGND VGND VPWR VPWR _05735_ sky130_fd_sc_hd__and3_1
XTAP_TAPCELL_ROW_8_413 VGND VPWR sky130_fd_sc_hd__tapvpwrvgnd_1
XTAP_TAPCELL_ROW_112_1867 VGND VPWR sky130_fd_sc_hd__tapvpwrvgnd_1
XTAP_TAPCELL_ROW_112_1856 VGND VPWR sky130_fd_sc_hd__tapvpwrvgnd_1
XFILLER_108_98 VGND VGND VPWR VPWR sky130_fd_sc_hd__fill_2
X_10030_ _02811_ _02815_ VGND VGND VPWR VPWR _02817_ sky130_fd_sc_hd__nand2_1
XFILLER_76_626 VGND VGND VPWR VPWR sky130_fd_sc_hd__decap_4
XFILLER_48_306 VGND VGND VPWR VPWR sky130_fd_sc_hd__fill_2
XFILLER_124_53 VPWR VGND VPWR VGND sky130_ef_sc_hd__decap_12
XFILLER_102_285 VGND VGND VPWR VPWR sky130_fd_sc_hd__decap_3
XFILLER_76_659 VGND VGND VPWR VPWR sky130_fd_sc_hd__decap_8
XFILLER_76_648 VGND VGND VPWR VPWR sky130_fd_sc_hd__fill_1
XFILLER_124_97 VGND VGND VPWR VPWR sky130_fd_sc_hd__fill_2
X_11981_ _04940_ _04941_ _04939_ VGND VGND VPWR VPWR _04943_ sky130_fd_sc_hd__o21ai_1
XFILLER_44_501 VGND VGND VPWR VPWR sky130_fd_sc_hd__decap_8
XFILLER_17_40 VPWR VGND VPWR VGND sky130_ef_sc_hd__decap_12
XFILLER_17_726 VGND VGND VPWR VPWR sky130_fd_sc_hd__fill_2
X_10932_ net331 net308 net348 net346 VGND VGND VPWR VPWR _03801_ sky130_fd_sc_hd__and4_1
XFILLER_90_139 VGND VGND VPWR VPWR sky130_fd_sc_hd__fill_1
XFILLER_71_342 VGND VGND VPWR VPWR sky130_fd_sc_hd__decap_8
XFILLER_71_364 VGND VGND VPWR VPWR sky130_fd_sc_hd__fill_1
XFILLER_44_589 VGND VGND VPWR VPWR sky130_fd_sc_hd__fill_1
X_10863_ _03546_ _03724_ VGND VGND VPWR VPWR _03725_ sky130_fd_sc_hd__and2b_1
XFILLER_25_781 VGND VGND VPWR VPWR sky130_fd_sc_hd__decap_3
X_12602_ net515 _02284_ _05231_ _05428_ VGND VGND VPWR VPWR _05621_ sky130_fd_sc_hd__o31ai_2
X_10794_ _03641_ _03643_ _03648_ VGND VGND VPWR VPWR _03650_ sky130_fd_sc_hd__nand3_1
XFILLER_129_105 VGND VGND VPWR VPWR sky130_fd_sc_hd__decap_6
XFILLER_8_413 VGND VGND VPWR VPWR sky130_fd_sc_hd__decap_6
X_12533_ net499 net507 net660 net658 VGND VGND VPWR VPWR _05545_ sky130_fd_sc_hd__and4_1
XFILLER_129_149 VPWR VGND VPWR VGND sky130_ef_sc_hd__decap_12
XFILLER_8_435 VPWR VGND VPWR VGND sky130_ef_sc_hd__decap_12
X_12464_ _05466_ _05467_ _05283_ _05285_ VGND VGND VPWR VPWR _05470_ sky130_fd_sc_hd__o211ai_2
XFILLER_125_311 VGND VGND VPWR VPWR sky130_fd_sc_hd__fill_1
X_12395_ _05208_ _05211_ VGND VGND VPWR VPWR _05394_ sky130_fd_sc_hd__and2_1
X_11415_ _04187_ _04201_ _04186_ VGND VGND VPWR VPWR _04328_ sky130_fd_sc_hd__a21bo_1
XTAP_TAPCELL_ROW_74_1328 VGND VPWR sky130_fd_sc_hd__tapvpwrvgnd_1
X_11346_ _04037_ _04252_ VGND VGND VPWR VPWR _04253_ sky130_fd_sc_hd__xnor2_1
XFILLER_99_729 VGND VGND VPWR VPWR sky130_fd_sc_hd__decap_3
XFILLER_98_239 VPWR VGND VPWR VGND sky130_ef_sc_hd__decap_12
X_11277_ _03426_ _04176_ VGND VGND VPWR VPWR _04178_ sky130_fd_sc_hd__xnor2_1
X_13016_ _06039_ _06072_ VGND VGND VPWR VPWR _06073_ sky130_fd_sc_hd__and2b_1
X_10228_ _03022_ _03023_ _03026_ _03029_ VGND VGND VPWR VPWR _03033_ sky130_fd_sc_hd__a211o_1
XFILLER_67_637 VPWR VGND VPWR VGND sky130_ef_sc_hd__decap_12
XFILLER_66_125 VGND VGND VPWR VPWR sky130_fd_sc_hd__decap_4
X_10159_ net468 net564 _02956_ VGND VGND VPWR VPWR _02957_ sky130_fd_sc_hd__and3_1
XFILLER_82_618 VPWR VGND VPWR VGND sky130_ef_sc_hd__decap_12
XFILLER_54_309 VGND VGND VPWR VPWR sky130_fd_sc_hd__fill_2
XFILLER_94_489 VPWR VGND VPWR VGND sky130_ef_sc_hd__decap_12
XFILLER_62_320 VGND VGND VPWR VPWR sky130_fd_sc_hd__decap_6
XTAP_TAPCELL_ROW_85_1479 VGND VPWR sky130_fd_sc_hd__tapvpwrvgnd_1
XFILLER_22_206 VPWR VGND VPWR VGND sky130_ef_sc_hd__decap_12
XFILLER_23_729 VPWR VGND VPWR VGND sky130_ef_sc_hd__decap_12
X_07370_ _06659_ _06660_ VGND VGND VPWR VPWR _00048_ sky130_fd_sc_hd__xor2_1
XFILLER_16_781 VPWR VGND VPWR VGND sky130_ef_sc_hd__decap_12
XTAP_TAPCELL_ROW_33_757 VGND VPWR sky130_fd_sc_hd__tapvpwrvgnd_1
X_09040_ _01763_ _01764_ VGND VGND VPWR VPWR _01765_ sky130_fd_sc_hd__and2b_1
XTAP_TAPCELL_ROW_13_470 VGND VPWR sky130_fd_sc_hd__tapvpwrvgnd_1
XFILLER_136_609 VGND VGND VPWR VPWR sky130_fd_sc_hd__decap_6
XTAP_TAPCELL_ROW_13_481 VGND VPWR sky130_fd_sc_hd__tapvpwrvgnd_1
X_09942_ _02375_ _02623_ _02622_ VGND VGND VPWR VPWR _02724_ sky130_fd_sc_hd__a21oi_1
XFILLER_104_506 VGND VGND VPWR VPWR sky130_fd_sc_hd__fill_2
XFILLER_112_550 VGND VGND VPWR VPWR sky130_fd_sc_hd__decap_3
XFILLER_100_701 VGND VGND VPWR VPWR sky130_fd_sc_hd__decap_8
X_09873_ _02647_ _02648_ VGND VGND VPWR VPWR _02649_ sky130_fd_sc_hd__nor2_1
XFILLER_58_615 VGND VGND VPWR VPWR sky130_fd_sc_hd__decap_8
X_08824_ net358 net60 VGND VGND VPWR VPWR _01551_ sky130_fd_sc_hd__nand2_1
X_08755_ _01216_ _01357_ _01190_ VGND VGND VPWR VPWR _01482_ sky130_fd_sc_hd__o21a_1
XFILLER_85_445 VGND VGND VPWR VPWR sky130_fd_sc_hd__decap_3
XFILLER_57_169 VPWR VGND VPWR VGND sky130_ef_sc_hd__decap_12
XFILLER_57_136 VGND VGND VPWR VPWR sky130_fd_sc_hd__fill_1
XTAP_TAPCELL_ROW_127_2074 VGND VPWR sky130_fd_sc_hd__tapvpwrvgnd_1
X_07706_ _00443_ _00444_ VGND VGND VPWR VPWR _00445_ sky130_fd_sc_hd__or2_1
XFILLER_85_489 VGND VGND VPWR VPWR sky130_fd_sc_hd__fill_1
XFILLER_72_117 VGND VGND VPWR VPWR sky130_fd_sc_hd__fill_1
XFILLER_72_106 VGND VGND VPWR VPWR sky130_fd_sc_hd__decap_4
XFILLER_38_372 VGND VGND VPWR VPWR sky130_fd_sc_hd__fill_1
XFILLER_72_139 VGND VGND VPWR VPWR sky130_fd_sc_hd__fill_1
X_08686_ net335 net358 net340 net338 VGND VGND VPWR VPWR _01414_ sky130_fd_sc_hd__and4_1
XFILLER_26_545 VGND VGND VPWR VPWR sky130_fd_sc_hd__fill_2
X_07637_ _00360_ _00376_ VGND VGND VPWR VPWR _00377_ sky130_fd_sc_hd__xor2_1
XFILLER_81_684 VGND VGND VPWR VPWR sky130_fd_sc_hd__decap_8
XFILLER_81_673 VGND VGND VPWR VPWR sky130_fd_sc_hd__decap_6
XFILLER_81_662 VGND VGND VPWR VPWR sky130_fd_sc_hd__decap_8
XFILLER_26_589 VGND VGND VPWR VPWR sky130_fd_sc_hd__decap_8
X_07568_ _00168_ _00170_ _00167_ VGND VGND VPWR VPWR _00308_ sky130_fd_sc_hd__a21oi_1
XFILLER_41_548 VGND VGND VPWR VPWR sky130_fd_sc_hd__fill_1
XFILLER_110_66 VGND VGND VPWR VPWR sky130_fd_sc_hd__fill_2
X_09307_ _02025_ _02031_ _02032_ VGND VGND VPWR VPWR _02034_ sky130_fd_sc_hd__nand3_1
XFILLER_70_15 VGND VGND VPWR VPWR sky130_fd_sc_hd__fill_2
X_07499_ net768 net382 VGND VGND VPWR VPWR _00240_ sky130_fd_sc_hd__nand2_1
XFILLER_70_37 VGND VGND VPWR VPWR sky130_fd_sc_hd__fill_2
XFILLER_21_261 VPWR VGND VPWR VGND sky130_ef_sc_hd__decap_12
X_09238_ _01924_ _01961_ VGND VGND VPWR VPWR _01962_ sky130_fd_sc_hd__nand2_1
X_09169_ _01890_ _01891_ _01724_ _01726_ VGND VGND VPWR VPWR _01894_ sky130_fd_sc_hd__o211ai_1
XFILLER_5_405 VPWR VGND VPWR VGND sky130_ef_sc_hd__decap_12
XFILLER_135_653 VPWR VGND VPWR VGND sky130_ef_sc_hd__decap_12
XFILLER_134_141 VPWR VGND VPWR VGND sky130_ef_sc_hd__decap_12
XFILLER_79_13 VGND VGND VPWR VPWR sky130_fd_sc_hd__fill_1
X_12180_ _04994_ _04997_ _05157_ VGND VGND VPWR VPWR _05159_ sky130_fd_sc_hd__nand3_1
XFILLER_5_449 VPWR VGND VPWR VGND sky130_ef_sc_hd__decap_12
X_11200_ _03789_ _03982_ _03985_ VGND VGND VPWR VPWR _04094_ sky130_fd_sc_hd__a21o_1
XFILLER_135_697 VPWR VGND VPWR VGND sky130_ef_sc_hd__decap_12
X_11131_ _03690_ _04017_ _04018_ _03856_ VGND VGND VPWR VPWR _04019_ sky130_fd_sc_hd__o22a_1
XFILLER_103_561 VPWR VGND VPWR VGND sky130_ef_sc_hd__decap_12
XFILLER_49_615 VGND VGND VPWR VPWR sky130_fd_sc_hd__fill_1
X_11062_ _03636_ _03808_ VGND VGND VPWR VPWR _03943_ sky130_fd_sc_hd__nor2_1
XFILLER_95_45 VGND VGND VPWR VPWR sky130_fd_sc_hd__decap_6
X_10013_ net467 net577 VGND VGND VPWR VPWR _02798_ sky130_fd_sc_hd__nand2_1
XFILLER_0_165 VGND VGND VPWR VPWR sky130_fd_sc_hd__decap_3
XFILLER_64_618 VPWR VGND VPWR VGND sky130_ef_sc_hd__decap_12
XFILLER_36_309 VGND VGND VPWR VPWR sky130_fd_sc_hd__fill_2
XFILLER_91_437 VGND VGND VPWR VPWR sky130_fd_sc_hd__decap_4
XFILLER_91_415 VGND VGND VPWR VPWR sky130_fd_sc_hd__decap_3
XFILLER_76_489 VGND VGND VPWR VPWR sky130_fd_sc_hd__fill_1
XFILLER_57_670 VGND VGND VPWR VPWR sky130_fd_sc_hd__fill_2
XFILLER_17_512 VPWR VGND VPWR VGND sky130_ef_sc_hd__decap_12
XFILLER_28_83 VGND VGND VPWR VPWR sky130_fd_sc_hd__fill_1
X_11964_ _04920_ _04921_ _04922_ VGND VGND VPWR VPWR _04924_ sky130_fd_sc_hd__a21oi_1
XFILLER_44_320 VPWR VGND VPWR VGND sky130_ef_sc_hd__decap_12
XFILLER_17_556 VGND VGND VPWR VPWR sky130_fd_sc_hd__decap_4
X_11895_ _04661_ _04846_ _04848_ VGND VGND VPWR VPWR _04849_ sky130_fd_sc_hd__and3_1
X_10915_ net433 net416 net563 net561 VGND VGND VPWR VPWR _03782_ sky130_fd_sc_hd__and4_1
XFILLER_44_386 VPWR VGND VPWR VGND sky130_ef_sc_hd__decap_12
XFILLER_44_71 VGND VGND VPWR VPWR sky130_fd_sc_hd__fill_2
X_10846_ _03703_ _03704_ VGND VGND VPWR VPWR _03706_ sky130_fd_sc_hd__xor2_1
XFILLER_8_221 VPWR VGND VPWR VGND sky130_ef_sc_hd__decap_12
XTAP_TAPCELL_ROW_30_716 VGND VPWR sky130_fd_sc_hd__tapvpwrvgnd_1
X_10777_ _03626_ _03630_ VGND VGND VPWR VPWR _03632_ sky130_fd_sc_hd__and2_1
XFILLER_9_777 VGND VGND VPWR VPWR sky130_fd_sc_hd__decap_6
X_12516_ _05521_ _05525_ VGND VGND VPWR VPWR _05526_ sky130_fd_sc_hd__xnor2_1
XFILLER_60_92 VPWR VGND VPWR VGND sky130_ef_sc_hd__decap_12
XTAP_TAPCELL_ROW_10_440 VGND VPWR sky130_fd_sc_hd__tapvpwrvgnd_1
XFILLER_8_265 VGND VGND VPWR VPWR sky130_fd_sc_hd__decap_8
X_12447_ _05448_ _05449_ _05450_ VGND VGND VPWR VPWR _05452_ sky130_fd_sc_hd__nand3_1
X_12378_ net499 net662 VGND VGND VPWR VPWR _05376_ sky130_fd_sc_hd__nand2_1
XFILLER_125_196 VGND VGND VPWR VPWR sky130_fd_sc_hd__fill_2
X_11329_ _04105_ _04106_ _04142_ VGND VGND VPWR VPWR _04235_ sky130_fd_sc_hd__o21a_1
XFILLER_113_369 VPWR VGND VPWR VGND sky130_ef_sc_hd__decap_12
X_06870_ _04068_ _04101_ VGND VGND VPWR VPWR _04112_ sky130_fd_sc_hd__and2_1
XFILLER_79_272 VGND VGND VPWR VPWR sky130_fd_sc_hd__fill_2
XFILLER_79_261 VGND VGND VPWR VPWR sky130_fd_sc_hd__decap_4
XFILLER_95_776 VGND VGND VPWR VPWR sky130_fd_sc_hd__decap_8
XTAP_TAPCELL_ROW_87_1508 VGND VPWR sky130_fd_sc_hd__tapvpwrvgnd_1
XTAP_TAPCELL_ROW_87_1519 VGND VPWR sky130_fd_sc_hd__tapvpwrvgnd_1
XTAP_TAPCELL_ROW_38_827 VGND VPWR sky130_fd_sc_hd__tapvpwrvgnd_1
X_08540_ _01256_ _01267_ _01268_ VGND VGND VPWR VPWR _01269_ sky130_fd_sc_hd__nand3_1
XFILLER_47_180 VGND VGND VPWR VPWR sky130_fd_sc_hd__fill_1
X_08471_ _01118_ _01156_ _01199_ VGND VGND VPWR VPWR _01200_ sky130_fd_sc_hd__and3_1
XFILLER_63_673 VPWR VGND VPWR VGND sky130_ef_sc_hd__decap_12
XTAP_TAPCELL_ROW_18_540 VGND VPWR sky130_fd_sc_hd__tapvpwrvgnd_1
XTAP_TAPCELL_ROW_18_551 VGND VPWR sky130_fd_sc_hd__tapvpwrvgnd_1
XFILLER_35_353 VPWR VGND VPWR VGND sky130_ef_sc_hd__decap_12
X_07422_ _06666_ _00161_ VGND VGND VPWR VPWR _00163_ sky130_fd_sc_hd__xnor2_1
X_07353_ _06431_ _06484_ _06483_ VGND VGND VPWR VPWR _06644_ sky130_fd_sc_hd__a21bo_1
XFILLER_136_406 VGND VGND VPWR VPWR sky130_fd_sc_hd__decap_3
X_07284_ _06572_ _06573_ _06420_ VGND VGND VPWR VPWR _06575_ sky130_fd_sc_hd__a21bo_1
XFILLER_108_119 VGND VGND VPWR VPWR sky130_fd_sc_hd__decap_4
X_09023_ _01589_ _01586_ _01585_ VGND VGND VPWR VPWR _01749_ sky130_fd_sc_hd__a21o_1
XFILLER_132_601 VPWR VGND VPWR VGND sky130_ef_sc_hd__decap_12
XFILLER_117_697 VGND VGND VPWR VPWR sky130_fd_sc_hd__decap_4
XFILLER_117_664 VGND VGND VPWR VPWR sky130_fd_sc_hd__decap_8
XFILLER_116_141 VPWR VGND VPWR VGND sky130_ef_sc_hd__decap_12
XFILLER_2_419 VGND VGND VPWR VPWR sky130_fd_sc_hd__fill_1
XFILLER_132_645 VPWR VGND VPWR VGND sky130_ef_sc_hd__decap_12
XFILLER_131_111 VGND VGND VPWR VPWR sky130_fd_sc_hd__fill_1
XFILLER_104_336 VGND VGND VPWR VPWR sky130_fd_sc_hd__fill_1
XTAP_TAPCELL_ROW_129_2103 VGND VPWR sky130_fd_sc_hd__tapvpwrvgnd_1
X_09925_ _02676_ _02705_ VGND VGND VPWR VPWR _02706_ sky130_fd_sc_hd__and2b_1
X_09856_ _01676_ _02516_ _02515_ VGND VGND VPWR VPWR _02630_ sky130_fd_sc_hd__a21oi_1
XFILLER_100_553 VPWR VGND VPWR VGND sky130_ef_sc_hd__decap_12
XFILLER_86_754 VGND VGND VPWR VPWR sky130_fd_sc_hd__fill_2
X_08807_ _01524_ _01532_ _01533_ VGND VGND VPWR VPWR _01534_ sky130_fd_sc_hd__nand3_1
X_06999_ net252 net99 net498 net490 VGND VGND VPWR VPWR _05516_ sky130_fd_sc_hd__and4_1
X_09787_ net415 _01822_ _02554_ VGND VGND VPWR VPWR _02556_ sky130_fd_sc_hd__o21ba_1
XFILLER_73_415 VGND VGND VPWR VPWR sky130_fd_sc_hd__decap_4
XFILLER_45_117 VGND VGND VPWR VPWR sky130_fd_sc_hd__decap_8
XFILLER_18_309 VPWR VGND VPWR VGND sky130_ef_sc_hd__decap_12
X_08738_ _01463_ _01464_ VGND VGND VPWR VPWR _01465_ sky130_fd_sc_hd__nand2_1
XFILLER_38_191 VGND VGND VPWR VPWR sky130_fd_sc_hd__decap_4
X_08669_ _01394_ _01395_ _01393_ VGND VGND VPWR VPWR _01397_ sky130_fd_sc_hd__o21ai_1
XFILLER_54_662 VGND VGND VPWR VPWR sky130_fd_sc_hd__fill_2
XFILLER_26_342 VPWR VGND VPWR VGND sky130_ef_sc_hd__decap_12
XTAP_TAPCELL_ROW_107_1799 VGND VPWR sky130_fd_sc_hd__tapvpwrvgnd_1
XTAP_TAPCELL_ROW_107_1788 VGND VPWR sky130_fd_sc_hd__tapvpwrvgnd_1
XFILLER_81_36 VGND VGND VPWR VPWR sky130_fd_sc_hd__decap_8
XFILLER_54_684 VGND VGND VPWR VPWR sky130_fd_sc_hd__decap_4
X_10700_ net566 _03546_ _03545_ VGND VGND VPWR VPWR _03547_ sky130_fd_sc_hd__a21bo_1
X_11680_ _04613_ _04614_ VGND VGND VPWR VPWR _00004_ sky130_fd_sc_hd__nor2_1
XFILLER_53_194 VGND VGND VPWR VPWR sky130_fd_sc_hd__decap_6
XTAP_TAPCELL_ROW_120_1977 VGND VPWR sky130_fd_sc_hd__tapvpwrvgnd_1
X_10631_ _03289_ _03298_ _03297_ VGND VGND VPWR VPWR _03472_ sky130_fd_sc_hd__a21boi_2
X_13350_ net399 VGND VGND VPWR VPWR _00124_ sky130_fd_sc_hd__inv_2
XFILLER_14_74 VGND VGND VPWR VPWR sky130_fd_sc_hd__decap_8
XFILLER_14_85 VPWR VGND VPWR VGND sky130_ef_sc_hd__decap_12
X_10562_ net475 net655 VGND VGND VPWR VPWR _03396_ sky130_fd_sc_hd__nand2_4
X_12301_ _05183_ _05290_ VGND VGND VPWR VPWR _05292_ sky130_fd_sc_hd__xnor2_1
X_13281_ _06306_ _06360_ VGND VGND VPWR VPWR _06361_ sky130_fd_sc_hd__xnor2_1
XFILLER_6_725 VPWR VGND VPWR VGND sky130_ef_sc_hd__decap_12
XFILLER_107_130 VPWR VGND VPWR VGND sky130_ef_sc_hd__decap_12
X_10493_ _03319_ _03318_ _03167_ _03169_ VGND VGND VPWR VPWR _03321_ sky130_fd_sc_hd__a211o_1
XTAP_TAPCELL_ROW_58_1109 VGND VPWR sky130_fd_sc_hd__tapvpwrvgnd_1
X_12232_ _05211_ _05212_ _05214_ VGND VGND VPWR VPWR _05216_ sky130_fd_sc_hd__a21o_1
XFILLER_6_769 VPWR VGND VPWR VGND sky130_ef_sc_hd__decap_12
XFILLER_135_461 VPWR VGND VPWR VGND sky130_ef_sc_hd__decap_12
XFILLER_108_675 VGND VGND VPWR VPWR sky130_fd_sc_hd__decap_3
XFILLER_108_664 VGND VGND VPWR VPWR sky130_fd_sc_hd__decap_4
XFILLER_107_152 VGND VGND VPWR VPWR sky130_fd_sc_hd__decap_4
XFILLER_5_279 VGND VGND VPWR VPWR sky130_fd_sc_hd__fill_1
XPHY_EDGE_ROW_15_Left_152 VGND VGND VPWR VPWR sky130_fd_sc_hd__decap_3
X_12163_ net269 _02273_ VGND VGND VPWR VPWR _05140_ sky130_fd_sc_hd__nor2_1
XFILLER_96_529 VGND VGND VPWR VPWR sky130_fd_sc_hd__decap_3
XFILLER_68_209 VGND VGND VPWR VPWR sky130_fd_sc_hd__fill_2
X_12094_ _05062_ _05064_ _05065_ VGND VGND VPWR VPWR _05066_ sky130_fd_sc_hd__or3_1
XFILLER_1_441 VGND VGND VPWR VPWR sky130_fd_sc_hd__decap_6
X_11114_ _03998_ _03999_ VGND VGND VPWR VPWR _04000_ sky130_fd_sc_hd__nand2b_1
XFILLER_1_485 VPWR VGND VPWR VGND sky130_ef_sc_hd__decap_12
X_11045_ _03921_ _03922_ VGND VGND VPWR VPWR _03924_ sky130_fd_sc_hd__xnor2_1
XFILLER_39_60 VGND VGND VPWR VPWR sky130_fd_sc_hd__decap_8
XFILLER_103_391 VGND VGND VPWR VPWR sky130_fd_sc_hd__fill_1
XFILLER_39_82 VGND VGND VPWR VPWR sky130_fd_sc_hd__fill_1
XFILLER_76_253 VGND VGND VPWR VPWR sky130_fd_sc_hd__fill_1
XFILLER_92_757 VGND VGND VPWR VPWR sky130_fd_sc_hd__decap_4
XPHY_EDGE_ROW_24_Left_161 VGND VGND VPWR VPWR sky130_fd_sc_hd__decap_3
X_12996_ _05829_ _05836_ _06050_ VGND VGND VPWR VPWR _06051_ sky130_fd_sc_hd__a21o_1
XFILLER_36_139 VGND VGND VPWR VPWR sky130_fd_sc_hd__fill_1
X_11947_ _04670_ _04904_ VGND VGND VPWR VPWR _04906_ sky130_fd_sc_hd__and2_1
XFILLER_45_673 VGND VGND VPWR VPWR sky130_fd_sc_hd__decap_4
XFILLER_44_150 VGND VGND VPWR VPWR sky130_fd_sc_hd__decap_8
XTAP_TAPCELL_ROW_82_1438 VGND VPWR sky130_fd_sc_hd__tapvpwrvgnd_1
XFILLER_72_492 VGND VGND VPWR VPWR sky130_fd_sc_hd__decap_3
XFILLER_45_684 VPWR VGND VPWR VGND sky130_ef_sc_hd__decap_12
XTAP_TAPCELL_ROW_15_510 VGND VPWR sky130_fd_sc_hd__tapvpwrvgnd_1
XFILLER_32_301 VGND VGND VPWR VPWR sky130_fd_sc_hd__decap_6
XFILLER_32_323 VPWR VGND VPWR VGND sky130_ef_sc_hd__decap_12
XTAP_TAPCELL_ROW_82_1449 VGND VPWR sky130_fd_sc_hd__tapvpwrvgnd_1
X_11878_ _04826_ _04827_ _04713_ VGND VGND VPWR VPWR _04831_ sky130_fd_sc_hd__a21oi_2
XFILLER_60_654 VGND VGND VPWR VPWR sky130_fd_sc_hd__decap_8
X_10829_ _03687_ _03688_ VGND VGND VPWR VPWR _03689_ sky130_fd_sc_hd__or2_4
XTAP_TAPCELL_ROW_43_896 VGND VPWR sky130_fd_sc_hd__tapvpwrvgnd_1
XFILLER_9_541 VGND VGND VPWR VPWR sky130_fd_sc_hd__fill_1
XFILLER_9_530 VGND VGND VPWR VPWR sky130_fd_sc_hd__decap_3
XPHY_EDGE_ROW_33_Left_170 VGND VGND VPWR VPWR sky130_fd_sc_hd__decap_3
XFILLER_114_601 VGND VGND VPWR VPWR sky130_fd_sc_hd__decap_6
XFILLER_114_645 VGND VGND VPWR VPWR sky130_fd_sc_hd__fill_1
X_07971_ _00612_ _00614_ _00707_ VGND VGND VPWR VPWR _00708_ sky130_fd_sc_hd__o21ba_1
XFILLER_99_378 VPWR VGND VPWR VGND sky130_ef_sc_hd__decap_12
X_09710_ _02466_ _02471_ VGND VGND VPWR VPWR _02472_ sky130_fd_sc_hd__nand2b_1
X_06922_ _04559_ _04579_ _04611_ _04654_ VGND VGND VPWR VPWR _04675_ sky130_fd_sc_hd__o211a_4
XFILLER_95_551 VGND VGND VPWR VPWR sky130_fd_sc_hd__decap_3
XFILLER_68_754 VGND VGND VPWR VPWR sky130_fd_sc_hd__fill_2
X_06853_ net469 net606 VGND VGND VPWR VPWR _03926_ sky130_fd_sc_hd__nand2_1
XFILLER_83_702 VGND VGND VPWR VPWR sky130_fd_sc_hd__fill_1
X_09641_ _02289_ _02300_ _02288_ VGND VGND VPWR VPWR _02397_ sky130_fd_sc_hd__o21a_1
X_06784_ _02349_ _02631_ _02642_ _02675_ VGND VGND VPWR VPWR _03173_ sky130_fd_sc_hd__o2bb2ai_1
XTAP_TAPCELL_ROW_124_2033 VGND VPWR sky130_fd_sc_hd__tapvpwrvgnd_1
X_09572_ _02146_ _02158_ _02157_ VGND VGND VPWR VPWR _02322_ sky130_fd_sc_hd__o21ai_1
X_08523_ _01249_ _01251_ VGND VGND VPWR VPWR _01252_ sky130_fd_sc_hd__or2_1
XFILLER_82_256 VGND VGND VPWR VPWR sky130_fd_sc_hd__fill_2
XFILLER_36_684 VPWR VGND VPWR VGND sky130_ef_sc_hd__decap_12
X_08454_ net669 net261 _01180_ _01181_ VGND VGND VPWR VPWR _01183_ sky130_fd_sc_hd__o2bb2a_1
XFILLER_23_334 VGND VGND VPWR VPWR sky130_fd_sc_hd__fill_2
XFILLER_23_356 VPWR VGND VPWR VGND sky130_ef_sc_hd__decap_12
X_07405_ net318 net571 _00144_ _00145_ VGND VGND VPWR VPWR _00146_ sky130_fd_sc_hd__a22oi_1
X_08385_ _01090_ _01115_ VGND VGND VPWR VPWR _01116_ sky130_fd_sc_hd__xnor2_1
X_07336_ _06624_ _06625_ VGND VGND VPWR VPWR _06627_ sky130_fd_sc_hd__xnor2_1
XFILLER_50_197 VPWR VGND VPWR VGND sky130_ef_sc_hd__decap_12
XFILLER_136_203 VGND VGND VPWR VPWR sky130_fd_sc_hd__decap_3
XFILLER_109_439 VGND VGND VPWR VPWR sky130_fd_sc_hd__decap_8
XFILLER_109_417 VPWR VGND VPWR VGND sky130_ef_sc_hd__decap_12
XFILLER_136_225 VPWR VGND VPWR VGND sky130_ef_sc_hd__decap_12
X_07267_ net470 net137 VGND VGND VPWR VPWR _06558_ sky130_fd_sc_hd__and2b_1
X_09006_ net884 _01674_ VGND VGND VPWR VPWR _01732_ sky130_fd_sc_hd__xnor2_2
XTAP_TAPCELL_ROW_135_2184 VGND VPWR sky130_fd_sc_hd__tapvpwrvgnd_1
X_07198_ _06487_ _06488_ _06402_ VGND VGND VPWR VPWR _06490_ sky130_fd_sc_hd__a21o_1
XFILLER_132_453 VPWR VGND VPWR VGND sky130_ef_sc_hd__decap_12
XFILLER_104_166 VGND VGND VPWR VPWR sky130_fd_sc_hd__fill_1
XFILLER_76_14 VPWR VGND VPWR VGND sky130_ef_sc_hd__decap_12
XTAP_TAPCELL_ROW_53_1039 VGND VPWR sky130_fd_sc_hd__tapvpwrvgnd_1
Xfanout520 net522 VGND VGND VPWR VPWR net520 sky130_fd_sc_hd__buf_2
Xfanout542 net547 VGND VGND VPWR VPWR net542 sky130_fd_sc_hd__buf_1
Xfanout531 net533 VGND VGND VPWR VPWR net531 sky130_fd_sc_hd__buf_2
X_09908_ _01950_ _02592_ _02594_ VGND VGND VPWR VPWR _02688_ sky130_fd_sc_hd__o21ai_1
Xfanout553 net156 VGND VGND VPWR VPWR net553 sky130_fd_sc_hd__buf_2
Xfanout575 net148 VGND VGND VPWR VPWR net575 sky130_fd_sc_hd__buf_2
Xfanout564 net150 VGND VGND VPWR VPWR net564 sky130_fd_sc_hd__clkbuf_2
Xfanout597 net14 VGND VGND VPWR VPWR net597 sky130_fd_sc_hd__dlymetal6s2s_1
X_09839_ _02447_ _02484_ _02611_ VGND VGND VPWR VPWR _02613_ sky130_fd_sc_hd__nand3_1
XTAP_TAPCELL_ROW_109_1817 VGND VPWR sky130_fd_sc_hd__tapvpwrvgnd_1
XFILLER_100_361 VGND VGND VPWR VPWR sky130_fd_sc_hd__decap_3
XFILLER_74_713 VGND VGND VPWR VPWR sky130_fd_sc_hd__decap_8
XFILLER_58_253 VGND VGND VPWR VPWR sky130_fd_sc_hd__fill_1
Xfanout586 net142 VGND VGND VPWR VPWR net586 sky130_fd_sc_hd__clkbuf_2
XFILLER_132_53 VPWR VGND VPWR VGND sky130_ef_sc_hd__decap_12
XFILLER_100_394 VGND VGND VPWR VPWR sky130_fd_sc_hd__decap_4
XFILLER_74_757 VPWR VGND VPWR VGND sky130_ef_sc_hd__decap_12
XFILLER_74_746 VGND VGND VPWR VPWR sky130_fd_sc_hd__decap_8
X_12850_ _05590_ _05782_ _05785_ VGND VGND VPWR VPWR _05892_ sky130_fd_sc_hd__a21o_1
XFILLER_18_128 VGND VGND VPWR VPWR sky130_fd_sc_hd__fill_1
X_11801_ _04744_ _04745_ net472 net587 VGND VGND VPWR VPWR _04746_ sky130_fd_sc_hd__and4bb_1
XFILLER_27_640 VGND VGND VPWR VPWR sky130_fd_sc_hd__decap_3
XFILLER_132_97 VPWR VGND VPWR VGND sky130_ef_sc_hd__decap_12
XFILLER_61_429 VPWR VGND VPWR VGND sky130_ef_sc_hd__decap_12
X_12781_ _05813_ _05815_ VGND VGND VPWR VPWR _00026_ sky130_fd_sc_hd__xnor2_2
Xrebuffer80 _04946_ VGND VGND VPWR VPWR net780 sky130_fd_sc_hd__dlygate4sd1_1
XFILLER_26_161 VPWR VGND VPWR VGND sky130_ef_sc_hd__decap_12
XFILLER_27_673 VGND VGND VPWR VPWR sky130_fd_sc_hd__decap_8
X_11732_ net507 net676 _04635_ VGND VGND VPWR VPWR _04670_ sky130_fd_sc_hd__and3_1
XFILLER_14_345 VGND VGND VPWR VPWR sky130_fd_sc_hd__decap_6
X_11663_ net530 net676 VGND VGND VPWR VPWR _04596_ sky130_fd_sc_hd__and2_1
XFILLER_41_153 VPWR VGND VPWR VGND sky130_ef_sc_hd__decap_12
X_13402_ clknet_3_4__leaf_clk _00009_ _00112_ VGND VGND VPWR VPWR net210 sky130_fd_sc_hd__dfrtp_1
X_10614_ net375 net347 _03450_ _03451_ VGND VGND VPWR VPWR _03453_ sky130_fd_sc_hd__nand4_1
XFILLER_41_186 VGND VGND VPWR VPWR sky130_fd_sc_hd__decap_3
XFILLER_128_737 VPWR VGND VPWR VGND sky130_ef_sc_hd__decap_12
X_13333_ net393 VGND VGND VPWR VPWR _00107_ sky130_fd_sc_hd__inv_2
X_11594_ _04506_ _04510_ _04504_ VGND VGND VPWR VPWR _04523_ sky130_fd_sc_hd__a21oi_1
XTAP_TAPCELL_ROW_40_855 VGND VPWR sky130_fd_sc_hd__tapvpwrvgnd_1
XFILLER_127_247 VGND VGND VPWR VPWR sky130_fd_sc_hd__decap_6
XFILLER_127_236 VGND VGND VPWR VPWR sky130_fd_sc_hd__fill_1
XFILLER_127_225 VGND VGND VPWR VPWR sky130_fd_sc_hd__decap_4
X_10545_ _03374_ _03375_ VGND VGND VPWR VPWR _03377_ sky130_fd_sc_hd__nor2_1
XFILLER_6_533 VPWR VGND VPWR VGND sky130_ef_sc_hd__decap_12
X_10476_ _03299_ _03300_ _03301_ VGND VGND VPWR VPWR _03302_ sky130_fd_sc_hd__nand3_1
X_13264_ _06322_ _06341_ VGND VGND VPWR VPWR _06342_ sky130_fd_sc_hd__xnor2_1
XFILLER_136_781 VGND VGND VPWR VPWR sky130_fd_sc_hd__decap_3
X_12215_ _05032_ _05034_ VGND VGND VPWR VPWR _05197_ sky130_fd_sc_hd__nand2_1
X_13195_ _06129_ _06158_ _06266_ VGND VGND VPWR VPWR _06268_ sky130_fd_sc_hd__or3_1
XFILLER_123_464 VPWR VGND VPWR VGND sky130_ef_sc_hd__decap_12
X_12146_ _05120_ _05119_ _04881_ _04885_ VGND VGND VPWR VPWR _05122_ sky130_fd_sc_hd__a211o_4
XFILLER_111_615 VGND VGND VPWR VPWR sky130_fd_sc_hd__fill_1
XFILLER_37_7 VGND VGND VPWR VPWR sky130_fd_sc_hd__fill_1
XFILLER_110_125 VGND VGND VPWR VPWR sky130_fd_sc_hd__fill_1
X_12077_ _05045_ _05046_ VGND VGND VPWR VPWR _05048_ sky130_fd_sc_hd__xnor2_1
XFILLER_1_293 VPWR VGND VPWR VGND sky130_ef_sc_hd__decap_12
XFILLER_77_573 VPWR VGND VPWR VGND sky130_ef_sc_hd__decap_12
XFILLER_65_724 VGND VGND VPWR VPWR sky130_fd_sc_hd__decap_4
XFILLER_2_77 VGND VGND VPWR VPWR sky130_fd_sc_hd__decap_6
X_11028_ _03866_ _03905_ VGND VGND VPWR VPWR _03906_ sky130_fd_sc_hd__nand2b_1
XFILLER_37_426 VGND VGND VPWR VPWR sky130_fd_sc_hd__decap_3
XFILLER_65_768 VGND VGND VPWR VPWR sky130_fd_sc_hd__decap_4
XTAP_TAPCELL_ROW_48_966 VGND VPWR sky130_fd_sc_hd__tapvpwrvgnd_1
XFILLER_18_651 VPWR VGND VPWR VGND sky130_ef_sc_hd__decap_12
XFILLER_80_749 VGND VGND VPWR VPWR sky130_fd_sc_hd__decap_6
XFILLER_45_481 VGND VGND VPWR VPWR sky130_fd_sc_hd__fill_2
X_12979_ _06006_ _06031_ VGND VGND VPWR VPWR _06033_ sky130_fd_sc_hd__and2b_1
XTAP_TAPCELL_ROW_28_690 VGND VPWR sky130_fd_sc_hd__tapvpwrvgnd_1
XFILLER_20_304 VGND VGND VPWR VPWR sky130_fd_sc_hd__decap_4
XFILLER_32_153 VGND VGND VPWR VPWR sky130_fd_sc_hd__decap_6
XPHY_EDGE_ROW_120_Right_120 VGND VGND VPWR VPWR sky130_fd_sc_hd__decap_3
X_08170_ _00905_ net249 VGND VGND VPWR VPWR _00906_ sky130_fd_sc_hd__nand2b_1
XANTENNA_27 net511 VGND VGND VPWR VPWR sky130_fd_sc_hd__diode_2
XFILLER_60_495 VGND VGND VPWR VPWR sky130_fd_sc_hd__fill_1
XANTENNA_16 net26 VGND VGND VPWR VPWR sky130_fd_sc_hd__diode_2
XFILLER_32_197 VGND VGND VPWR VPWR sky130_fd_sc_hd__fill_1
X_07121_ _06410_ _06411_ _06408_ VGND VGND VPWR VPWR _06413_ sky130_fd_sc_hd__a21bo_1
XTAP_TAPCELL_ROW_95_1618 VGND VPWR sky130_fd_sc_hd__tapvpwrvgnd_1
XFILLER_9_393 VPWR VGND VPWR VGND sky130_ef_sc_hd__decap_12
XTAP_TAPCELL_ROW_95_1629 VGND VPWR sky130_fd_sc_hd__tapvpwrvgnd_1
X_07052_ _06085_ _05790_ _06074_ _05779_ VGND VGND VPWR VPWR _06095_ sky130_fd_sc_hd__nor4_4
Xoutput167 net167 VGND VGND VPWR VPWR out0[14] sky130_fd_sc_hd__buf_2
XFILLER_114_486 VPWR VGND VPWR VGND sky130_ef_sc_hd__decap_12
XFILLER_87_326 VGND VGND VPWR VPWR sky130_fd_sc_hd__fill_1
XFILLER_87_315 VGND VGND VPWR VPWR sky130_fd_sc_hd__decap_6
Xoutput189 net189 VGND VGND VPWR VPWR out1[5] sky130_fd_sc_hd__buf_2
Xoutput178 net178 VGND VGND VPWR VPWR out1[0] sky130_fd_sc_hd__buf_2
X_07954_ _00615_ _00691_ VGND VGND VPWR VPWR _00692_ sky130_fd_sc_hd__or2_1
XFILLER_87_337 VGND VGND VPWR VPWR sky130_fd_sc_hd__decap_4
X_06905_ _04461_ _04396_ _02781_ VGND VGND VPWR VPWR _04494_ sky130_fd_sc_hd__a21o_1
X_07885_ _00622_ _00621_ VGND VGND VPWR VPWR _00623_ sky130_fd_sc_hd__and2b_1
XFILLER_56_713 VPWR VGND VPWR VGND sky130_ef_sc_hd__decap_12
XFILLER_28_415 VGND VGND VPWR VPWR sky130_fd_sc_hd__decap_4
X_06836_ net522 net685 net683 net527 VGND VGND VPWR VPWR _03740_ sky130_fd_sc_hd__a22oi_1
XFILLER_83_521 VPWR VGND VPWR VGND sky130_ef_sc_hd__decap_12
X_09624_ _02283_ _02377_ VGND VGND VPWR VPWR _02378_ sky130_fd_sc_hd__nor2_1
XFILLER_56_757 VPWR VGND VPWR VGND sky130_ef_sc_hd__decap_12
XFILLER_55_201 VGND VGND VPWR VPWR sky130_fd_sc_hd__fill_2
XFILLER_83_576 VPWR VGND VPWR VGND sky130_ef_sc_hd__decap_12
X_06767_ _02965_ _02976_ VGND VGND VPWR VPWR _02987_ sky130_fd_sc_hd__or2_1
X_09555_ _02301_ _02302_ VGND VGND VPWR VPWR _02304_ sky130_fd_sc_hd__xor2_2
XFILLER_43_429 VGND VGND VPWR VPWR sky130_fd_sc_hd__decap_4
X_09486_ _01751_ _02071_ _02070_ VGND VGND VPWR VPWR _02229_ sky130_fd_sc_hd__a21boi_2
XTAP_TAPCELL_ROW_104_1747 VGND VPWR sky130_fd_sc_hd__tapvpwrvgnd_1
XFILLER_102_67 VGND VGND VPWR VPWR sky130_fd_sc_hd__decap_6
X_08506_ net447 net556 net554 net455 VGND VGND VPWR VPWR _01235_ sky130_fd_sc_hd__a22o_1
XFILLER_70_259 VGND VGND VPWR VPWR sky130_fd_sc_hd__fill_1
X_06698_ net342 VGND VGND VPWR VPWR _02240_ sky130_fd_sc_hd__inv_2
XFILLER_102_89 VGND VGND VPWR VPWR sky130_fd_sc_hd__decap_4
X_08437_ net530 net632 net629 net535 VGND VGND VPWR VPWR _01166_ sky130_fd_sc_hd__a22oi_1
XFILLER_12_805 VGND VGND VPWR VPWR sky130_fd_sc_hd__fill_2
XFILLER_23_142 VPWR VGND VPWR VGND sky130_ef_sc_hd__decap_12
XFILLER_24_676 VGND VGND VPWR VPWR sky130_fd_sc_hd__decap_3
XFILLER_11_337 VPWR VGND VPWR VGND sky130_ef_sc_hd__decap_12
XFILLER_11_315 VGND VGND VPWR VPWR sky130_fd_sc_hd__fill_1
XFILLER_109_214 VGND VGND VPWR VPWR sky130_fd_sc_hd__decap_8
X_08368_ net465 net558 _01095_ _01097_ VGND VGND VPWR VPWR _01099_ sky130_fd_sc_hd__a22oi_1
X_08299_ _00824_ _00938_ VGND VGND VPWR VPWR _01034_ sky130_fd_sc_hd__nand2_1
X_07319_ net816 net386 net820 net387 VGND VGND VPWR VPWR _06610_ sky130_fd_sc_hd__a22o_1
XFILLER_125_729 VPWR VGND VPWR VGND sky130_ef_sc_hd__decap_12
X_10330_ _02971_ _02973_ _02972_ VGND VGND VPWR VPWR _03144_ sky130_fd_sc_hd__o21bai_1
XFILLER_3_503 VGND VGND VPWR VPWR sky130_fd_sc_hd__fill_1
XFILLER_118_781 VPWR VGND VPWR VGND sky130_ef_sc_hd__decap_12
XFILLER_105_420 VGND VGND VPWR VPWR sky130_fd_sc_hd__decap_8
X_10261_ net616 net590 net282 net280 VGND VGND VPWR VPWR _03068_ sky130_fd_sc_hd__and4_1
X_12000_ _04912_ _04963_ _04962_ VGND VGND VPWR VPWR _04964_ sky130_fd_sc_hd__nor3_4
XTAP_TAPCELL_ROW_115_1898 VGND VPWR sky130_fd_sc_hd__tapvpwrvgnd_1
XFILLER_87_57 VPWR VGND VPWR VGND sky130_ef_sc_hd__decap_12
X_10192_ _02984_ _02985_ _02992_ VGND VGND VPWR VPWR _02993_ sky130_fd_sc_hd__nand3_2
XFILLER_78_348 VPWR VGND VPWR VGND sky130_ef_sc_hd__decap_12
Xfanout350 net51 VGND VGND VPWR VPWR net350 sky130_fd_sc_hd__buf_2
Xfanout383 net38 VGND VGND VPWR VPWR net383 sky130_fd_sc_hd__buf_2
Xfanout361 net48 VGND VGND VPWR VPWR net361 sky130_fd_sc_hd__buf_2
XTAP_TAPCELL_ROW_6_385 VGND VPWR sky130_fd_sc_hd__tapvpwrvgnd_1
XTAP_TAPCELL_ROW_6_374 VGND VPWR sky130_fd_sc_hd__tapvpwrvgnd_1
Xfanout394 net395 VGND VGND VPWR VPWR net394 sky130_fd_sc_hd__buf_4
XFILLER_19_437 VGND VGND VPWR VPWR sky130_fd_sc_hd__fill_2
X_12902_ _05946_ _05947_ VGND VGND VPWR VPWR _05949_ sky130_fd_sc_hd__xor2_1
XFILLER_74_587 VGND VGND VPWR VPWR sky130_fd_sc_hd__fill_1
XTAP_TAPCELL_ROW_66_1219 VGND VPWR sky130_fd_sc_hd__tapvpwrvgnd_1
XTAP_TAPCELL_ROW_45_925 VGND VPWR sky130_fd_sc_hd__tapvpwrvgnd_1
X_12833_ net791 _02284_ _05759_ _05762_ VGND VGND VPWR VPWR _05873_ sky130_fd_sc_hd__o31ai_2
XFILLER_34_429 VGND VGND VPWR VPWR sky130_fd_sc_hd__fill_2
XFILLER_27_492 VPWR VGND VPWR VGND sky130_ef_sc_hd__decap_12
X_12764_ _05639_ _05641_ _05797_ VGND VGND VPWR VPWR _05798_ sky130_fd_sc_hd__a21oi_1
X_11715_ net269 net76 _04649_ _04650_ VGND VGND VPWR VPWR _04652_ sky130_fd_sc_hd__o2bb2a_1
XFILLER_30_613 VPWR VGND VPWR VGND sky130_ef_sc_hd__decap_12
X_12695_ _05554_ _05556_ VGND VGND VPWR VPWR _05722_ sky130_fd_sc_hd__and2_1
XFILLER_128_501 VPWR VGND VPWR VGND sky130_ef_sc_hd__decap_12
X_11646_ _04574_ _04575_ _04576_ VGND VGND VPWR VPWR _04578_ sky130_fd_sc_hd__o21a_1
XFILLER_30_657 VPWR VGND VPWR VGND sky130_ef_sc_hd__decap_12
Xinput14 in1[5] VGND VGND VPWR VPWR net14 sky130_fd_sc_hd__clkbuf_4
Xinput36 w00[2] VGND VGND VPWR VPWR net36 sky130_fd_sc_hd__clkbuf_2
X_11577_ _04502_ _04503_ VGND VGND VPWR VPWR _04506_ sky130_fd_sc_hd__xnor2_1
Xinput25 in3[0] VGND VGND VPWR VPWR net25 sky130_fd_sc_hd__buf_2
Xinput69 w10[3] VGND VGND VPWR VPWR net69 sky130_fd_sc_hd__buf_1
XFILLER_128_589 VPWR VGND VPWR VGND sky130_ef_sc_hd__decap_12
XFILLER_128_567 VGND VGND VPWR VPWR sky130_fd_sc_hd__fill_1
Xinput58 w03[0] VGND VGND VPWR VPWR net58 sky130_fd_sc_hd__buf_1
X_10528_ _03195_ _03198_ _03358_ VGND VGND VPWR VPWR _03359_ sky130_fd_sc_hd__a21o_1
X_13316_ net396 VGND VGND VPWR VPWR _00090_ sky130_fd_sc_hd__inv_2
Xinput47 w01[5] VGND VGND VPWR VPWR net47 sky130_fd_sc_hd__buf_1
XFILLER_115_239 VPWR VGND VPWR VGND sky130_ef_sc_hd__decap_12
X_13247_ _06260_ _06258_ _06249_ VGND VGND VPWR VPWR _06324_ sky130_fd_sc_hd__mux2_1
XFILLER_6_363 VGND VGND VPWR VPWR sky130_fd_sc_hd__fill_1
XFILLER_108_291 VPWR VGND VPWR VGND sky130_ef_sc_hd__decap_12
X_10459_ _03278_ _03282_ VGND VGND VPWR VPWR _03284_ sky130_fd_sc_hd__xnor2_1
XFILLER_123_272 VGND VGND VPWR VPWR sky130_fd_sc_hd__decap_8
XFILLER_97_613 VGND VGND VPWR VPWR sky130_fd_sc_hd__decap_3
XTAP_TAPCELL_ROW_90_1548 VGND VPWR sky130_fd_sc_hd__tapvpwrvgnd_1
X_13178_ net404 _02295_ _05195_ VGND VGND VPWR VPWR _06250_ sky130_fd_sc_hd__o21ai_1
XFILLER_111_434 VPWR VGND VPWR VGND sky130_ef_sc_hd__decap_12
XTAP_TAPCELL_ROW_90_1559 VGND VPWR sky130_fd_sc_hd__tapvpwrvgnd_1
XFILLER_69_337 VPWR VGND VPWR VGND sky130_ef_sc_hd__decap_12
X_12129_ _05083_ _05103_ _05102_ VGND VGND VPWR VPWR _05104_ sky130_fd_sc_hd__and3_1
XFILLER_111_478 VPWR VGND VPWR VGND sky130_ef_sc_hd__decap_12
XFILLER_28_3 VGND VGND VPWR VPWR sky130_fd_sc_hd__fill_1
XFILLER_37_212 VPWR VGND VPWR VGND sky130_ef_sc_hd__decap_12
XFILLER_38_757 VPWR VGND VPWR VGND sky130_ef_sc_hd__decap_12
X_07670_ _00377_ _00408_ _00409_ VGND VGND VPWR VPWR _00410_ sky130_fd_sc_hd__and3_1
XFILLER_65_554 VGND VGND VPWR VPWR sky130_fd_sc_hd__decap_6
XFILLER_53_705 VGND VGND VPWR VPWR sky130_fd_sc_hd__fill_1
XFILLER_80_513 VGND VGND VPWR VPWR sky130_fd_sc_hd__decap_4
X_09340_ _01904_ _01906_ _02068_ _02069_ VGND VGND VPWR VPWR _02070_ sky130_fd_sc_hd__o211ai_1
XFILLER_52_237 VGND VGND VPWR VPWR sky130_fd_sc_hd__decap_3
X_09271_ _01991_ _01992_ VGND VGND VPWR VPWR _01995_ sky130_fd_sc_hd__xnor2_1
XTAP_TAPCELL_ROW_23_619 VGND VPWR sky130_fd_sc_hd__tapvpwrvgnd_1
X_08222_ _00953_ _00956_ VGND VGND VPWR VPWR _00957_ sky130_fd_sc_hd__xor2_1
XFILLER_60_270 VGND VGND VPWR VPWR sky130_fd_sc_hd__decap_3
XFILLER_20_112 VPWR VGND VPWR VGND sky130_ef_sc_hd__decap_12
XFILLER_21_635 VPWR VGND VPWR VGND sky130_ef_sc_hd__decap_12
X_08153_ _00886_ _00887_ VGND VGND VPWR VPWR _00889_ sky130_fd_sc_hd__nand2_1
XFILLER_20_178 VGND VGND VPWR VPWR sky130_fd_sc_hd__decap_4
X_08084_ _00576_ _00819_ VGND VGND VPWR VPWR _00821_ sky130_fd_sc_hd__or2_1
X_07104_ _06395_ _06393_ VGND VGND VPWR VPWR _06396_ sky130_fd_sc_hd__and2b_1
XTAP_TAPCELL_ROW_132_2143 VGND VPWR sky130_fd_sc_hd__tapvpwrvgnd_1
X_07035_ net388 net752 net821 net390 VGND VGND VPWR VPWR _05910_ sky130_fd_sc_hd__a22oi_2
XFILLER_114_272 VGND VGND VPWR VPWR sky130_fd_sc_hd__decap_4
XFILLER_88_613 VGND VGND VPWR VPWR sky130_fd_sc_hd__decap_4
XFILLER_87_145 VPWR VGND VPWR VGND sky130_ef_sc_hd__decap_12
X_08986_ net97 net324 VGND VGND VPWR VPWR _01712_ sky130_fd_sc_hd__xor2_1
X_07937_ net435 net137 VGND VGND VPWR VPWR _00675_ sky130_fd_sc_hd__and2b_1
XFILLER_75_307 VGND VGND VPWR VPWR sky130_fd_sc_hd__decap_8
XFILLER_29_702 VGND VGND VPWR VPWR sky130_fd_sc_hd__fill_1
XFILLER_56_510 VGND VGND VPWR VPWR sky130_fd_sc_hd__fill_1
XTAP_TAPCELL_ROW_3_333 VGND VPWR sky130_fd_sc_hd__tapvpwrvgnd_1
XFILLER_113_55 VGND VGND VPWR VPWR sky130_fd_sc_hd__fill_1
X_07868_ _00598_ _00605_ VGND VGND VPWR VPWR _00606_ sky130_fd_sc_hd__xnor2_1
XFILLER_29_768 VGND VGND VPWR VPWR sky130_fd_sc_hd__fill_2
X_09607_ _02127_ _02218_ _02217_ VGND VGND VPWR VPWR _02361_ sky130_fd_sc_hd__a21boi_2
X_06819_ _03510_ _03532_ VGND VGND VPWR VPWR _03554_ sky130_fd_sc_hd__nor2_1
X_07799_ _00536_ _00537_ VGND VGND VPWR VPWR _00538_ sky130_fd_sc_hd__nor2_1
XFILLER_83_362 VPWR VGND VPWR VGND sky130_ef_sc_hd__decap_12
XFILLER_44_749 VGND VGND VPWR VPWR sky130_fd_sc_hd__fill_1
X_09538_ _02165_ _02285_ VGND VGND VPWR VPWR _02286_ sky130_fd_sc_hd__xor2_1
XFILLER_71_557 VGND VGND VPWR VPWR sky130_fd_sc_hd__decap_3
X_09469_ _02019_ _02053_ _02052_ VGND VGND VPWR VPWR _02211_ sky130_fd_sc_hd__a21bo_1
XFILLER_51_281 VPWR VGND VPWR VGND sky130_ef_sc_hd__decap_12
X_11500_ _03426_ _04420_ VGND VGND VPWR VPWR _04421_ sky130_fd_sc_hd__nand2_1
XFILLER_132_3 VPWR VGND VPWR VGND sky130_ef_sc_hd__decap_12
XTAP_TAPCELL_ROW_61_1149 VGND VPWR sky130_fd_sc_hd__tapvpwrvgnd_1
X_12480_ _05487_ _05486_ VGND VGND VPWR VPWR _05488_ sky130_fd_sc_hd__or2_4
XFILLER_12_668 VGND VGND VPWR VPWR sky130_fd_sc_hd__fill_1
XTAP_TAPCELL_ROW_50_994 VGND VPWR sky130_fd_sc_hd__tapvpwrvgnd_1
XFILLER_11_189 VPWR VGND VPWR VGND sky130_ef_sc_hd__decap_12
XFILLER_7_138 VPWR VGND VPWR VGND sky130_ef_sc_hd__decap_12
X_11431_ _04345_ _04342_ VGND VGND VPWR VPWR _04346_ sky130_fd_sc_hd__nand2b_1
XTAP_TAPCELL_ROW_117_1938 VGND VPWR sky130_fd_sc_hd__tapvpwrvgnd_1
XTAP_TAPCELL_ROW_117_1927 VGND VPWR sky130_fd_sc_hd__tapvpwrvgnd_1
XFILLER_20_690 VGND VGND VPWR VPWR sky130_fd_sc_hd__decap_8
XFILLER_22_85 VPWR VGND VPWR VGND sky130_ef_sc_hd__decap_12
X_11362_ _04239_ _04269_ VGND VGND VPWR VPWR _04271_ sky130_fd_sc_hd__xnor2_1
X_10313_ _03123_ _03124_ VGND VGND VPWR VPWR _03125_ sky130_fd_sc_hd__nor2_1
X_13101_ _05824_ _06045_ _06047_ VGND VGND VPWR VPWR _06166_ sky130_fd_sc_hd__a21boi_2
XFILLER_125_559 VGND VGND VPWR VPWR sky130_fd_sc_hd__fill_1
X_11293_ net408 _04194_ _04193_ VGND VGND VPWR VPWR _04195_ sky130_fd_sc_hd__a21bo_1
X_10244_ _03046_ _03048_ VGND VGND VPWR VPWR _03050_ sky130_fd_sc_hd__xnor2_2
X_13032_ _05813_ _05958_ VGND VGND VPWR VPWR _06091_ sky130_fd_sc_hd__nand2_1
XFILLER_78_134 VGND VGND VPWR VPWR sky130_fd_sc_hd__decap_6
XFILLER_78_112 VPWR VGND VPWR VGND sky130_ef_sc_hd__decap_12
X_10175_ _02971_ _02972_ _02973_ VGND VGND VPWR VPWR _02974_ sky130_fd_sc_hd__or3_4
XFILLER_121_765 VPWR VGND VPWR VGND sky130_ef_sc_hd__decap_12
XFILLER_120_253 VPWR VGND VPWR VGND sky130_ef_sc_hd__decap_12
XFILLER_19_234 VGND VGND VPWR VPWR sky130_fd_sc_hd__decap_3
XFILLER_19_245 VGND VGND VPWR VPWR sky130_fd_sc_hd__decap_6
XFILLER_35_705 VGND VGND VPWR VPWR sky130_fd_sc_hd__decap_3
XFILLER_74_362 VGND VGND VPWR VPWR sky130_fd_sc_hd__fill_2
XFILLER_19_289 VGND VGND VPWR VPWR sky130_fd_sc_hd__fill_1
XFILLER_34_215 VGND VGND VPWR VPWR sky130_fd_sc_hd__decap_8
X_12816_ _05852_ _05853_ VGND VGND VPWR VPWR _05854_ sky130_fd_sc_hd__nor2_1
XFILLER_34_248 VGND VGND VPWR VPWR sky130_fd_sc_hd__decap_4
XFILLER_63_81 VGND VGND VPWR VPWR sky130_fd_sc_hd__fill_2
XFILLER_15_473 VGND VGND VPWR VPWR sky130_fd_sc_hd__decap_3
X_12747_ _05590_ _05592_ _05589_ VGND VGND VPWR VPWR _05780_ sky130_fd_sc_hd__o21ba_1
XFILLER_30_421 VGND VGND VPWR VPWR sky130_fd_sc_hd__fill_1
X_12678_ _05577_ _05579_ _05701_ VGND VGND VPWR VPWR _05704_ sky130_fd_sc_hd__or3_1
X_11629_ _04560_ _04561_ VGND VGND VPWR VPWR _04562_ sky130_fd_sc_hd__xnor2_1
XFILLER_8_65 VGND VGND VPWR VPWR sky130_fd_sc_hd__fill_2
XPHY_EDGE_ROW_7_Left_144 VGND VGND VPWR VPWR sky130_fd_sc_hd__decap_3
XFILLER_11_690 VPWR VGND VPWR VGND sky130_ef_sc_hd__decap_12
XFILLER_131_529 VPWR VGND VPWR VGND sky130_ef_sc_hd__decap_12
XFILLER_112_710 VGND VGND VPWR VPWR sky130_fd_sc_hd__decap_6
XFILLER_124_592 VGND VGND VPWR VPWR sky130_fd_sc_hd__fill_1
XFILLER_97_443 VGND VGND VPWR VPWR sky130_fd_sc_hd__decap_4
X_08840_ _01564_ _01565_ _01425_ _01428_ VGND VGND VPWR VPWR _01567_ sky130_fd_sc_hd__o211ai_2
X_08771_ net501 net632 net630 net510 VGND VGND VPWR VPWR _01498_ sky130_fd_sc_hd__a22o_1
XFILLER_57_329 VGND VGND VPWR VPWR sky130_fd_sc_hd__fill_1
X_07722_ _00460_ _00310_ VGND VGND VPWR VPWR _00461_ sky130_fd_sc_hd__nand2b_1
XFILLER_81_800 VGND VGND VPWR VPWR sky130_fd_sc_hd__fill_1
XFILLER_93_671 VGND VGND VPWR VPWR sky130_fd_sc_hd__fill_1
XFILLER_93_682 VGND VGND VPWR VPWR sky130_fd_sc_hd__fill_2
XFILLER_93_660 VGND VGND VPWR VPWR sky130_fd_sc_hd__fill_1
X_07653_ _00391_ _00390_ _00392_ VGND VGND VPWR VPWR _00393_ sky130_fd_sc_hd__or3b_4
X_07584_ _00323_ _00286_ VGND VGND VPWR VPWR _00324_ sky130_fd_sc_hd__nand2b_1
XTAP_TAPCELL_ROW_101_1706 VGND VPWR sky130_fd_sc_hd__tapvpwrvgnd_1
XFILLER_80_365 VGND VGND VPWR VPWR sky130_fd_sc_hd__fill_1
X_09323_ _02037_ _02038_ _02049_ VGND VGND VPWR VPWR _02051_ sky130_fd_sc_hd__nand3_1
XFILLER_34_771 VGND VGND VPWR VPWR sky130_fd_sc_hd__decap_3
XTAP_TAPCELL_ROW_36_799 VGND VPWR sky130_fd_sc_hd__tapvpwrvgnd_1
X_09254_ _02087_ _01975_ net628 _01973_ VGND VGND VPWR VPWR _01978_ sky130_fd_sc_hd__or4bb_1
X_08205_ _00939_ _00940_ VGND VGND VPWR VPWR _00042_ sky130_fd_sc_hd__xnor2_1
X_09185_ _01591_ _01908_ _01909_ VGND VGND VPWR VPWR _01910_ sky130_fd_sc_hd__nor3_1
XFILLER_119_342 VGND VGND VPWR VPWR sky130_fd_sc_hd__decap_3
X_08136_ net410 _00184_ _00871_ VGND VGND VPWR VPWR _00872_ sky130_fd_sc_hd__o21ba_1
XFILLER_5_609 VGND VGND VPWR VPWR sky130_fd_sc_hd__decap_6
XFILLER_134_301 VGND VGND VPWR VPWR sky130_fd_sc_hd__decap_6
XFILLER_134_345 VPWR VGND VPWR VGND sky130_ef_sc_hd__decap_12
X_08067_ _00598_ _00605_ _00604_ VGND VGND VPWR VPWR _00804_ sky130_fd_sc_hd__a21bo_1
XFILLER_107_559 VGND VGND VPWR VPWR sky130_fd_sc_hd__fill_1
XTAP_TAPCELL_ROW_8_403 VGND VPWR sky130_fd_sc_hd__tapvpwrvgnd_1
XFILLER_108_55 VGND VGND VPWR VPWR sky130_fd_sc_hd__decap_4
X_07018_ net460 net608 _03959_ _03948_ VGND VGND VPWR VPWR _05724_ sky130_fd_sc_hd__a31o_1
XFILLER_68_15 VPWR VGND VPWR VGND sky130_ef_sc_hd__decap_12
XTAP_TAPCELL_ROW_112_1868 VGND VPWR sky130_fd_sc_hd__tapvpwrvgnd_1
XTAP_TAPCELL_ROW_112_1857 VGND VPWR sky130_fd_sc_hd__tapvpwrvgnd_1
XFILLER_88_421 VPWR VGND VPWR VGND sky130_ef_sc_hd__decap_12
XFILLER_102_253 VPWR VGND VPWR VGND sky130_ef_sc_hd__decap_12
XFILLER_124_65 VPWR VGND VPWR VGND sky130_ef_sc_hd__decap_12
X_08969_ _01544_ _01693_ VGND VGND VPWR VPWR _01695_ sky130_fd_sc_hd__xor2_1
XFILLER_75_148 VGND VGND VPWR VPWR sky130_fd_sc_hd__fill_1
X_11980_ _04939_ _04940_ _04941_ VGND VGND VPWR VPWR _04942_ sky130_fd_sc_hd__or3_4
XFILLER_29_532 VGND VGND VPWR VPWR sky130_fd_sc_hd__decap_3
XFILLER_72_800 VGND VGND VPWR VPWR sky130_fd_sc_hd__decap_6
XFILLER_29_576 VPWR VGND VPWR VGND sky130_ef_sc_hd__decap_12
X_10931_ _03780_ _03799_ VGND VGND VPWR VPWR _03800_ sky130_fd_sc_hd__xor2_1
XFILLER_83_181 VGND VGND VPWR VPWR sky130_fd_sc_hd__decap_6
XFILLER_16_248 VGND VGND VPWR VPWR sky130_fd_sc_hd__decap_4
XFILLER_17_52 VGND VGND VPWR VPWR sky130_fd_sc_hd__decap_4
X_10862_ net539 _03542_ _03544_ _03723_ VGND VGND VPWR VPWR _03724_ sky130_fd_sc_hd__a31o_1
X_12601_ _05616_ _05617_ _05618_ VGND VGND VPWR VPWR _05620_ sky130_fd_sc_hd__a21o_1
X_10793_ _03641_ _03643_ _03648_ VGND VGND VPWR VPWR _03649_ sky130_fd_sc_hd__a21o_1
XFILLER_12_443 VGND VGND VPWR VPWR sky130_fd_sc_hd__decap_8
X_12532_ _05420_ _05422_ VGND VGND VPWR VPWR _05544_ sky130_fd_sc_hd__nor2_1
X_12463_ _05468_ VGND VGND VPWR VPWR _05469_ sky130_fd_sc_hd__inv_2
XFILLER_40_785 VGND VGND VPWR VPWR sky130_fd_sc_hd__fill_1
X_11414_ _04314_ _04326_ VGND VGND VPWR VPWR _04327_ sky130_fd_sc_hd__xnor2_1
XFILLER_8_447 VGND VGND VPWR VPWR sky130_fd_sc_hd__decap_8
X_12394_ _05382_ _05392_ VGND VGND VPWR VPWR _05393_ sky130_fd_sc_hd__xor2_1
XTAP_TAPCELL_ROW_74_1329 VGND VPWR sky130_fd_sc_hd__tapvpwrvgnd_1
X_11345_ _04250_ _04251_ VGND VGND VPWR VPWR _04252_ sky130_fd_sc_hd__nand2_1
X_11276_ _04174_ _04175_ VGND VGND VPWR VPWR _04176_ sky130_fd_sc_hd__nor2_1
X_10227_ _03026_ net230 _03022_ _03023_ VGND VGND VPWR VPWR _03032_ sky130_fd_sc_hd__o211ai_4
X_13015_ _06040_ _06070_ VGND VGND VPWR VPWR _06072_ sky130_fd_sc_hd__xnor2_1
XFILLER_79_487 VGND VGND VPWR VPWR sky130_fd_sc_hd__fill_1
XFILLER_67_649 VGND VGND VPWR VPWR sky130_fd_sc_hd__decap_8
X_10158_ _02949_ _02953_ VGND VGND VPWR VPWR _02956_ sky130_fd_sc_hd__xnor2_1
XFILLER_66_137 VGND VGND VPWR VPWR sky130_fd_sc_hd__decap_3
X_10089_ _02844_ _02876_ _02878_ _02879_ VGND VGND VPWR VPWR _02880_ sky130_fd_sc_hd__o211ai_2
XFILLER_74_170 VPWR VGND VPWR VGND sky130_ef_sc_hd__decap_12
XFILLER_62_365 VPWR VGND VPWR VGND sky130_ef_sc_hd__decap_12
XFILLER_95_3 VPWR VGND VPWR VGND sky130_ef_sc_hd__decap_12
XFILLER_16_793 VPWR VGND VPWR VGND sky130_ef_sc_hd__decap_12
XFILLER_22_218 VGND VGND VPWR VPWR sky130_fd_sc_hd__decap_4
XFILLER_22_229 VPWR VGND VPWR VGND sky130_ef_sc_hd__decap_12
XTAP_TAPCELL_ROW_33_758 VGND VPWR sky130_fd_sc_hd__tapvpwrvgnd_1
XFILLER_30_251 VGND VGND VPWR VPWR sky130_fd_sc_hd__fill_1
XFILLER_31_785 VPWR VGND VPWR VGND sky130_ef_sc_hd__decap_12
XTAP_TAPCELL_ROW_13_471 VGND VPWR sky130_fd_sc_hd__tapvpwrvgnd_1
XTAP_TAPCELL_ROW_13_482 VGND VPWR sky130_fd_sc_hd__tapvpwrvgnd_1
XFILLER_129_673 VPWR VGND VPWR VGND sky130_ef_sc_hd__decap_12
XFILLER_132_805 VGND VGND VPWR VPWR sky130_fd_sc_hd__decap_6
XFILLER_131_315 VGND VGND VPWR VPWR sky130_fd_sc_hd__fill_1
X_09941_ _02616_ _02721_ VGND VGND VPWR VPWR _02723_ sky130_fd_sc_hd__xor2_1
XFILLER_98_785 VGND VGND VPWR VPWR sky130_fd_sc_hd__decap_6
XFILLER_97_251 VPWR VGND VPWR VGND sky130_ef_sc_hd__decap_12
X_09872_ _02645_ _02646_ VGND VGND VPWR VPWR _02648_ sky130_fd_sc_hd__and2_1
X_08823_ _01546_ _01549_ VGND VGND VPWR VPWR _01550_ sky130_fd_sc_hd__xnor2_1
XFILLER_38_29 VGND VGND VPWR VPWR sky130_fd_sc_hd__decap_3
X_08754_ _01355_ _01480_ VGND VGND VPWR VPWR _01481_ sky130_fd_sc_hd__xnor2_1
XFILLER_100_757 VGND VGND VPWR VPWR sky130_fd_sc_hd__decap_8
X_07705_ net594 net305 _00442_ VGND VGND VPWR VPWR _00444_ sky130_fd_sc_hd__a21oi_1
XTAP_TAPCELL_ROW_127_2075 VGND VPWR sky130_fd_sc_hd__tapvpwrvgnd_1
XFILLER_93_490 VPWR VGND VPWR VGND sky130_ef_sc_hd__decap_12
X_08685_ net737 net60 VGND VGND VPWR VPWR _01413_ sky130_fd_sc_hd__nand2_1
XFILLER_38_395 VPWR VGND VPWR VGND sky130_ef_sc_hd__decap_12
X_07636_ _00361_ _00374_ VGND VGND VPWR VPWR _00376_ sky130_fd_sc_hd__xnor2_1
XFILLER_14_708 VPWR VGND VPWR VGND sky130_ef_sc_hd__decap_12
XFILLER_41_505 VGND VGND VPWR VPWR sky130_fd_sc_hd__fill_1
X_07567_ net318 net571 _00145_ _00143_ VGND VGND VPWR VPWR _00307_ sky130_fd_sc_hd__a31o_1
XFILLER_80_162 VGND VGND VPWR VPWR sky130_fd_sc_hd__decap_8
X_09306_ _02028_ _02029_ _02026_ VGND VGND VPWR VPWR _02032_ sky130_fd_sc_hd__o21ai_1
XFILLER_22_741 VPWR VGND VPWR VGND sky130_ef_sc_hd__decap_12
XFILLER_110_78 VGND VGND VPWR VPWR sky130_fd_sc_hd__decap_6
X_09237_ _01942_ _01960_ VGND VGND VPWR VPWR _01961_ sky130_fd_sc_hd__xnor2_1
X_07498_ _00237_ _00238_ VGND VGND VPWR VPWR _00239_ sky130_fd_sc_hd__and2b_1
XFILLER_70_27 VGND VGND VPWR VPWR sky130_fd_sc_hd__fill_1
XFILLER_21_273 VGND VGND VPWR VPWR sky130_fd_sc_hd__decap_6
XFILLER_126_109 VGND VGND VPWR VPWR sky130_fd_sc_hd__decap_8
X_09168_ _01892_ VGND VGND VPWR VPWR _01893_ sky130_fd_sc_hd__inv_2
XFILLER_5_417 VPWR VGND VPWR VGND sky130_ef_sc_hd__decap_12
XFILLER_123_805 VGND VGND VPWR VPWR sky130_fd_sc_hd__fill_2
XFILLER_119_183 VGND VGND VPWR VPWR sky130_fd_sc_hd__fill_1
X_09099_ net479 net633 VGND VGND VPWR VPWR _01824_ sky130_fd_sc_hd__and2_1
X_08119_ _00853_ _00854_ VGND VGND VPWR VPWR _00855_ sky130_fd_sc_hd__and2_1
XFILLER_79_36 VPWR VGND VPWR VGND sky130_ef_sc_hd__decap_12
XFILLER_135_665 VGND VGND VPWR VPWR sky130_fd_sc_hd__decap_6
XFILLER_134_153 VPWR VGND VPWR VGND sky130_ef_sc_hd__decap_12
XFILLER_122_315 VGND VGND VPWR VPWR sky130_fd_sc_hd__fill_1
X_11130_ _03687_ _03855_ VGND VGND VPWR VPWR _04018_ sky130_fd_sc_hd__nor2_1
XFILLER_134_197 VPWR VGND VPWR VGND sky130_ef_sc_hd__decap_12
XPHY_EDGE_ROW_79_Left_216 VGND VGND VPWR VPWR sky130_fd_sc_hd__decap_3
X_11061_ _03908_ _03941_ VGND VGND VPWR VPWR _03942_ sky130_fd_sc_hd__xor2_1
XFILLER_103_573 VGND VGND VPWR VPWR sky130_fd_sc_hd__decap_8
XFILLER_89_785 VGND VGND VPWR VPWR sky130_fd_sc_hd__decap_6
X_10012_ _02782_ _02795_ VGND VGND VPWR VPWR _02797_ sky130_fd_sc_hd__xnor2_1
XFILLER_49_638 VGND VGND VPWR VPWR sky130_fd_sc_hd__fill_1
XFILLER_48_137 VGND VGND VPWR VPWR sky130_fd_sc_hd__decap_3
XFILLER_91_449 VGND VGND VPWR VPWR sky130_fd_sc_hd__fill_1
XFILLER_72_630 VGND VGND VPWR VPWR sky130_fd_sc_hd__decap_4
X_11963_ _04920_ _04921_ _04922_ VGND VGND VPWR VPWR _04923_ sky130_fd_sc_hd__and3_1
XFILLER_44_332 VPWR VGND VPWR VGND sky130_ef_sc_hd__decap_12
XFILLER_17_524 VGND VGND VPWR VPWR sky130_fd_sc_hd__decap_4
XPHY_EDGE_ROW_88_Left_225 VGND VGND VPWR VPWR sky130_fd_sc_hd__decap_3
XFILLER_71_151 VGND VGND VPWR VPWR sky130_fd_sc_hd__fill_2
X_11894_ _04838_ _04844_ _04647_ _04658_ VGND VGND VPWR VPWR _04848_ sky130_fd_sc_hd__o211ai_1
XFILLER_44_365 VGND VGND VPWR VPWR sky130_fd_sc_hd__decap_6
X_10914_ _03625_ _03633_ _03632_ VGND VGND VPWR VPWR _03781_ sky130_fd_sc_hd__a21o_1
XFILLER_72_696 VGND VGND VPWR VPWR sky130_fd_sc_hd__decap_4
XFILLER_71_173 VGND VGND VPWR VPWR sky130_fd_sc_hd__fill_1
XFILLER_44_398 VPWR VGND VPWR VGND sky130_ef_sc_hd__decap_12
X_10845_ _03703_ _03704_ VGND VGND VPWR VPWR _03705_ sky130_fd_sc_hd__nand2_1
XFILLER_12_240 VPWR VGND VPWR VGND sky130_ef_sc_hd__decap_12
XFILLER_13_785 VPWR VGND VPWR VGND sky130_ef_sc_hd__decap_12
XTAP_TAPCELL_ROW_30_717 VGND VPWR sky130_fd_sc_hd__tapvpwrvgnd_1
X_10776_ _03426_ _03628_ VGND VGND VPWR VPWR _03630_ sky130_fd_sc_hd__xnor2_1
XFILLER_40_571 VPWR VGND VPWR VGND sky130_ef_sc_hd__decap_12
XFILLER_8_233 VPWR VGND VPWR VGND sky130_ef_sc_hd__decap_12
X_12515_ _05345_ _05523_ VGND VGND VPWR VPWR _05525_ sky130_fd_sc_hd__nand2b_2
XFILLER_67_7 VPWR VGND VPWR VGND sky130_ef_sc_hd__decap_12
XTAP_TAPCELL_ROW_10_441 VGND VPWR sky130_fd_sc_hd__tapvpwrvgnd_1
XTAP_TAPCELL_ROW_10_430 VGND VPWR sky130_fd_sc_hd__tapvpwrvgnd_1
X_12446_ _05262_ _05269_ _05268_ VGND VGND VPWR VPWR _05450_ sky130_fd_sc_hd__a21o_1
XFILLER_126_643 VGND VGND VPWR VPWR sky130_fd_sc_hd__fill_1
X_12377_ _05372_ _05373_ VGND VGND VPWR VPWR _05375_ sky130_fd_sc_hd__and2b_1
XFILLER_114_805 VGND VGND VPWR VPWR sky130_fd_sc_hd__decap_6
XPHY_EDGE_ROW_97_Left_234 VGND VGND VPWR VPWR sky130_fd_sc_hd__decap_3
XFILLER_5_55 VGND VGND VPWR VPWR sky130_fd_sc_hd__fill_1
X_11328_ _04205_ _04233_ VGND VGND VPWR VPWR _04234_ sky130_fd_sc_hd__xor2_1
XFILLER_113_337 VGND VGND VPWR VPWR sky130_fd_sc_hd__decap_6
X_11259_ _04157_ _04158_ VGND VGND VPWR VPWR _04159_ sky130_fd_sc_hd__xor2_2
XTAP_TAPCELL_ROW_87_1509 VGND VPWR sky130_fd_sc_hd__tapvpwrvgnd_1
XFILLER_79_295 VGND VGND VPWR VPWR sky130_fd_sc_hd__fill_2
XFILLER_10_3 VPWR VGND VPWR VGND sky130_ef_sc_hd__decap_12
XTAP_TAPCELL_ROW_38_828 VGND VPWR sky130_fd_sc_hd__tapvpwrvgnd_1
XFILLER_85_90 VGND VGND VPWR VPWR sky130_fd_sc_hd__decap_3
XFILLER_54_129 VGND VGND VPWR VPWR sky130_fd_sc_hd__decap_8
X_08470_ _01198_ VGND VGND VPWR VPWR _01199_ sky130_fd_sc_hd__inv_2
XFILLER_90_460 VPWR VGND VPWR VGND sky130_ef_sc_hd__decap_12
XFILLER_47_192 VGND VGND VPWR VPWR sky130_fd_sc_hd__decap_8
XTAP_TAPCELL_ROW_18_541 VGND VPWR sky130_fd_sc_hd__tapvpwrvgnd_1
XTAP_TAPCELL_ROW_18_552 VGND VPWR sky130_fd_sc_hd__tapvpwrvgnd_1
XFILLER_35_365 VPWR VGND VPWR VGND sky130_ef_sc_hd__decap_12
X_07421_ _06666_ _00161_ VGND VGND VPWR VPWR _00162_ sky130_fd_sc_hd__and2b_1
X_07352_ _06585_ net727 VGND VGND VPWR VPWR _06643_ sky130_fd_sc_hd__xnor2_2
XFILLER_50_335 VGND VGND VPWR VPWR sky130_fd_sc_hd__fill_1
X_07283_ _06420_ _06572_ _06573_ VGND VGND VPWR VPWR _06574_ sky130_fd_sc_hd__nand3b_1
XFILLER_31_593 VGND VGND VPWR VPWR sky130_fd_sc_hd__decap_4
X_09022_ _01583_ _01746_ VGND VGND VPWR VPWR _01748_ sky130_fd_sc_hd__xor2_2
XFILLER_132_613 VPWR VGND VPWR VGND sky130_ef_sc_hd__decap_12
XFILLER_116_153 VGND VGND VPWR VPWR sky130_fd_sc_hd__fill_1
XFILLER_105_805 VGND VGND VPWR VPWR sky130_fd_sc_hd__decap_3
XFILLER_116_197 VPWR VGND VPWR VGND sky130_ef_sc_hd__decap_12
XFILLER_116_186 VGND VGND VPWR VPWR sky130_fd_sc_hd__decap_8
XFILLER_132_657 VPWR VGND VPWR VGND sky130_ef_sc_hd__decap_12
XTAP_TAPCELL_ROW_129_2104 VGND VPWR sky130_fd_sc_hd__tapvpwrvgnd_1
X_09924_ _02677_ _02704_ VGND VGND VPWR VPWR _02705_ sky130_fd_sc_hd__xor2_1
XTAP_TAPCELL_ROW_55_1070 VGND VPWR sky130_fd_sc_hd__tapvpwrvgnd_1
XFILLER_131_167 VGND VGND VPWR VPWR sky130_fd_sc_hd__fill_1
XFILLER_98_571 VGND VGND VPWR VPWR sky130_fd_sc_hd__decap_4
X_09855_ _02509_ _02520_ _02508_ VGND VGND VPWR VPWR _02629_ sky130_fd_sc_hd__a21bo_1
X_08806_ _01529_ _01530_ _01531_ VGND VGND VPWR VPWR _01533_ sky130_fd_sc_hd__a21o_1
XFILLER_105_89 VGND VGND VPWR VPWR sky130_fd_sc_hd__fill_1
XFILLER_100_587 VGND VGND VPWR VPWR sky130_fd_sc_hd__fill_1
XFILLER_100_565 VGND VGND VPWR VPWR sky130_fd_sc_hd__fill_2
X_06998_ net98 net490 VGND VGND VPWR VPWR _05505_ sky130_fd_sc_hd__nand2_1
X_09786_ net415 _02219_ _01649_ VGND VGND VPWR VPWR _02554_ sky130_fd_sc_hd__o21a_1
XFILLER_85_265 VGND VGND VPWR VPWR sky130_fd_sc_hd__decap_4
XPHY_EDGE_ROW_134_Right_134 VGND VGND VPWR VPWR sky130_fd_sc_hd__decap_3
X_08737_ net271 net254 _01462_ VGND VGND VPWR VPWR _01464_ sky130_fd_sc_hd__nand3_1
X_08668_ _01393_ _01394_ _01395_ VGND VGND VPWR VPWR _01396_ sky130_fd_sc_hd__or3_1
XFILLER_53_140 VGND VGND VPWR VPWR sky130_fd_sc_hd__decap_4
XFILLER_26_354 VGND VGND VPWR VPWR sky130_fd_sc_hd__decap_8
XFILLER_26_365 VGND VGND VPWR VPWR sky130_fd_sc_hd__decap_8
XFILLER_121_55 VGND VGND VPWR VPWR sky130_fd_sc_hd__fill_1
XTAP_TAPCELL_ROW_107_1789 VGND VPWR sky130_fd_sc_hd__tapvpwrvgnd_1
X_07619_ _00326_ _00358_ VGND VGND VPWR VPWR _00359_ sky130_fd_sc_hd__xor2_1
XFILLER_81_460 VGND VGND VPWR VPWR sky130_fd_sc_hd__fill_2
XFILLER_81_15 VPWR VGND VPWR VGND sky130_ef_sc_hd__decap_12
XFILLER_41_313 VGND VGND VPWR VPWR sky130_fd_sc_hd__fill_1
X_08599_ _01320_ _01323_ _01322_ VGND VGND VPWR VPWR _01328_ sky130_fd_sc_hd__a21o_1
X_10630_ _03463_ _03470_ VGND VGND VPWR VPWR _03471_ sky130_fd_sc_hd__xnor2_1
XTAP_TAPCELL_ROW_120_1978 VGND VPWR sky130_fd_sc_hd__tapvpwrvgnd_1
XFILLER_14_53 VGND VGND VPWR VPWR sky130_fd_sc_hd__decap_4
X_10561_ _03392_ _03393_ VGND VGND VPWR VPWR _03395_ sky130_fd_sc_hd__xnor2_1
X_10492_ _03169_ _03167_ _03318_ _03319_ VGND VGND VPWR VPWR _03320_ sky130_fd_sc_hd__o211ai_2
X_12300_ _05183_ _05290_ VGND VGND VPWR VPWR _05291_ sky130_fd_sc_hd__nor2_1
XFILLER_10_755 VGND VGND VPWR VPWR sky130_fd_sc_hd__fill_1
X_13280_ _06355_ _06359_ VGND VGND VPWR VPWR _06360_ sky130_fd_sc_hd__xnor2_1
XFILLER_14_97 VGND VGND VPWR VPWR sky130_fd_sc_hd__fill_1
X_12231_ _05211_ _05212_ _05214_ VGND VGND VPWR VPWR _05215_ sky130_fd_sc_hd__nand3_1
XFILLER_6_737 VPWR VGND VPWR VGND sky130_ef_sc_hd__decap_12
XFILLER_5_225 VPWR VGND VPWR VGND sky130_ef_sc_hd__decap_12
XFILLER_135_473 VPWR VGND VPWR VGND sky130_ef_sc_hd__decap_12
XFILLER_107_164 VGND VGND VPWR VPWR sky130_fd_sc_hd__decap_4
XFILLER_107_142 VGND VGND VPWR VPWR sky130_fd_sc_hd__decap_6
XFILLER_30_63 VGND VGND VPWR VPWR sky130_fd_sc_hd__fill_1
X_12162_ _05137_ _05138_ VGND VGND VPWR VPWR _05139_ sky130_fd_sc_hd__nand2b_1
XFILLER_30_85 VGND VGND VPWR VPWR sky130_fd_sc_hd__decap_3
XFILLER_122_156 VGND VGND VPWR VPWR sky130_fd_sc_hd__decap_4
X_12093_ net421 net598 net589 net437 VGND VGND VPWR VPWR _05065_ sky130_fd_sc_hd__a22oi_2
X_11113_ _03779_ _03838_ _03837_ VGND VGND VPWR VPWR _03999_ sky130_fd_sc_hd__a21bo_1
XFILLER_110_307 VGND VGND VPWR VPWR sky130_fd_sc_hd__fill_1
X_11044_ _03919_ _03920_ _03922_ VGND VGND VPWR VPWR _03923_ sky130_fd_sc_hd__or3_1
XFILLER_76_221 VGND VGND VPWR VPWR sky130_fd_sc_hd__decap_8
XFILLER_1_497 VGND VGND VPWR VPWR sky130_fd_sc_hd__decap_6
XFILLER_36_107 VPWR VGND VPWR VGND sky130_ef_sc_hd__decap_12
XPHY_EDGE_ROW_101_Right_101 VGND VGND VPWR VPWR sky130_fd_sc_hd__decap_3
XFILLER_45_630 VGND VGND VPWR VPWR sky130_fd_sc_hd__decap_3
X_12995_ _06044_ _06049_ VGND VGND VPWR VPWR _06050_ sky130_fd_sc_hd__xnor2_1
X_11946_ _04727_ _04902_ VGND VGND VPWR VPWR _04904_ sky130_fd_sc_hd__nor2_1
XFILLER_17_332 VGND VGND VPWR VPWR sky130_fd_sc_hd__decap_4
XFILLER_17_343 VGND VGND VPWR VPWR sky130_fd_sc_hd__decap_8
XTAP_TAPCELL_ROW_82_1439 VGND VPWR sky130_fd_sc_hd__tapvpwrvgnd_1
XFILLER_72_460 VGND VGND VPWR VPWR sky130_fd_sc_hd__decap_3
XFILLER_60_611 VGND VGND VPWR VPWR sky130_fd_sc_hd__fill_2
XFILLER_55_82 VGND VGND VPWR VPWR sky130_fd_sc_hd__fill_1
XFILLER_45_696 VGND VGND VPWR VPWR sky130_fd_sc_hd__decap_6
XTAP_TAPCELL_ROW_15_500 VGND VPWR sky130_fd_sc_hd__tapvpwrvgnd_1
XTAP_TAPCELL_ROW_15_511 VGND VPWR sky130_fd_sc_hd__tapvpwrvgnd_1
X_11877_ _04713_ _04826_ _04827_ VGND VGND VPWR VPWR _04830_ sky130_fd_sc_hd__nand3_2
XFILLER_44_195 VGND VGND VPWR VPWR sky130_fd_sc_hd__fill_1
XFILLER_32_335 VGND VGND VPWR VPWR sky130_fd_sc_hd__decap_8
XFILLER_60_699 VGND VGND VPWR VPWR sky130_fd_sc_hd__fill_1
X_10828_ net764 _03685_ _03502_ VGND VGND VPWR VPWR _03688_ sky130_fd_sc_hd__a21oi_2
XTAP_TAPCELL_ROW_43_897 VGND VPWR sky130_fd_sc_hd__tapvpwrvgnd_1
X_10759_ net401 net577 net575 net409 VGND VGND VPWR VPWR _03612_ sky130_fd_sc_hd__a22o_1
X_12429_ _05425_ _05430_ VGND VGND VPWR VPWR _05432_ sky130_fd_sc_hd__xor2_1
XFILLER_99_335 VGND VGND VPWR VPWR sky130_fd_sc_hd__fill_1
X_07970_ _00448_ _00596_ _00595_ VGND VGND VPWR VPWR _00707_ sky130_fd_sc_hd__a21oi_1
XFILLER_113_167 VGND VGND VPWR VPWR sky130_fd_sc_hd__fill_1
XFILLER_101_307 VGND VGND VPWR VPWR sky130_fd_sc_hd__decap_4
X_06921_ _04654_ _04611_ net243 _04579_ VGND VGND VPWR VPWR _04665_ sky130_fd_sc_hd__a211oi_4
X_06852_ _03882_ _03893_ VGND VGND VPWR VPWR _03915_ sky130_fd_sc_hd__xor2_1
X_09640_ _02383_ _02394_ VGND VGND VPWR VPWR _02396_ sky130_fd_sc_hd__xor2_1
XFILLER_55_405 VPWR VGND VPWR VGND sky130_ef_sc_hd__decap_12
XTAP_TAPCELL_ROW_124_2034 VGND VPWR sky130_fd_sc_hd__tapvpwrvgnd_1
X_06783_ _03140_ _03151_ VGND VGND VPWR VPWR _03162_ sky130_fd_sc_hd__or2_1
X_09571_ _02319_ _02320_ VGND VGND VPWR VPWR _02321_ sky130_fd_sc_hd__xnor2_1
X_08522_ _01245_ _01248_ VGND VGND VPWR VPWR _01251_ sky130_fd_sc_hd__nor2_1
X_08453_ _01180_ _01181_ net669 net261 VGND VGND VPWR VPWR _01182_ sky130_fd_sc_hd__and4bb_1
XFILLER_51_600 VPWR VGND VPWR VGND sky130_ef_sc_hd__decap_12
XFILLER_23_313 VGND VGND VPWR VPWR sky130_fd_sc_hd__decap_3
XFILLER_36_696 VGND VGND VPWR VPWR sky130_fd_sc_hd__decap_4
X_07404_ net322 net320 net543 VGND VGND VPWR VPWR _00145_ sky130_fd_sc_hd__o21a_1
XFILLER_50_110 VPWR VGND VPWR VGND sky130_ef_sc_hd__decap_12
X_08384_ _01113_ _01114_ VGND VGND VPWR VPWR _01115_ sky130_fd_sc_hd__nand2_1
XFILLER_51_688 VGND VGND VPWR VPWR sky130_fd_sc_hd__decap_8
XFILLER_23_368 VPWR VGND VPWR VGND sky130_ef_sc_hd__decap_12
X_07335_ _06624_ _06625_ VGND VGND VPWR VPWR _06626_ sky130_fd_sc_hd__and2b_1
XFILLER_109_429 VGND VGND VPWR VPWR sky130_fd_sc_hd__decap_3
X_07266_ net461 net602 VGND VGND VPWR VPWR _06557_ sky130_fd_sc_hd__nand2_1
XFILLER_136_237 VGND VGND VPWR VPWR sky130_fd_sc_hd__decap_8
X_09005_ _01674_ _01730_ VGND VGND VPWR VPWR _01731_ sky130_fd_sc_hd__or2_4
XTAP_TAPCELL_ROW_135_2185 VGND VPWR sky130_fd_sc_hd__tapvpwrvgnd_1
XFILLER_117_440 VGND VGND VPWR VPWR sky130_fd_sc_hd__decap_8
X_07197_ _06402_ _06487_ _06488_ VGND VGND VPWR VPWR _06489_ sky130_fd_sc_hd__nand3_1
XFILLER_117_495 VGND VGND VPWR VPWR sky130_fd_sc_hd__decap_8
XFILLER_105_646 VPWR VGND VPWR VGND sky130_ef_sc_hd__decap_12
XFILLER_105_624 VPWR VGND VPWR VGND sky130_ef_sc_hd__decap_12
XFILLER_3_729 VPWR VGND VPWR VGND sky130_ef_sc_hd__decap_12
XFILLER_132_465 VGND VGND VPWR VPWR sky130_fd_sc_hd__decap_8
X_09907_ _02579_ _02685_ VGND VGND VPWR VPWR _02687_ sky130_fd_sc_hd__xnor2_1
Xfanout510 net511 VGND VGND VPWR VPWR net510 sky130_fd_sc_hd__clkbuf_2
Xfanout532 net533 VGND VGND VPWR VPWR net532 sky130_fd_sc_hd__buf_2
Xfanout521 net522 VGND VGND VPWR VPWR net521 sky130_fd_sc_hd__clkbuf_4
Xfanout543 net546 VGND VGND VPWR VPWR net543 sky130_fd_sc_hd__buf_2
Xfanout554 net156 VGND VGND VPWR VPWR net554 sky130_fd_sc_hd__dlymetal6s2s_1
XFILLER_76_26 VGND VGND VPWR VPWR sky130_fd_sc_hd__fill_2
XFILLER_59_755 VPWR VGND VPWR VGND sky130_ef_sc_hd__decap_12
Xfanout565 net566 VGND VGND VPWR VPWR net565 sky130_fd_sc_hd__buf_2
X_09838_ _02447_ _02484_ _02611_ VGND VGND VPWR VPWR _02612_ sky130_fd_sc_hd__a21oi_1
XTAP_TAPCELL_ROW_109_1818 VGND VPWR sky130_fd_sc_hd__tapvpwrvgnd_1
XFILLER_100_351 VGND VGND VPWR VPWR sky130_fd_sc_hd__decap_6
XFILLER_86_585 VGND VGND VPWR VPWR sky130_fd_sc_hd__decap_3
Xfanout576 net148 VGND VGND VPWR VPWR net576 sky130_fd_sc_hd__clkbuf_2
Xfanout598 net599 VGND VGND VPWR VPWR net598 sky130_fd_sc_hd__buf_2
Xfanout587 net141 VGND VGND VPWR VPWR net587 sky130_fd_sc_hd__buf_2
X_09769_ _02526_ _02535_ VGND VGND VPWR VPWR _02536_ sky130_fd_sc_hd__nand2b_1
XFILLER_58_298 VGND VGND VPWR VPWR sky130_fd_sc_hd__decap_8
XFILLER_46_449 VGND VGND VPWR VPWR sky130_fd_sc_hd__fill_1
XFILLER_132_65 VPWR VGND VPWR VGND sky130_ef_sc_hd__decap_12
XFILLER_74_769 VPWR VGND VPWR VGND sky130_ef_sc_hd__decap_12
XFILLER_73_246 VGND VGND VPWR VPWR sky130_fd_sc_hd__fill_1
XTAP_TAPCELL_ROW_68_1250 VGND VPWR sky130_fd_sc_hd__tapvpwrvgnd_1
X_11800_ net454 net599 net589 net463 VGND VGND VPWR VPWR _04745_ sky130_fd_sc_hd__a22oi_1
XFILLER_15_803 VGND VGND VPWR VPWR sky130_fd_sc_hd__fill_2
Xrebuffer70 net767 VGND VGND VPWR VPWR net770 sky130_fd_sc_hd__dlygate4sd1_1
Xrebuffer81 _04770_ VGND VGND VPWR VPWR net781 sky130_fd_sc_hd__dlygate4sd1_1
X_12780_ _05815_ _05813_ VGND VGND VPWR VPWR _05816_ sky130_fd_sc_hd__nand2b_1
XFILLER_26_173 VPWR VGND VPWR VGND sky130_ef_sc_hd__decap_12
XFILLER_42_611 VPWR VGND VPWR VGND sky130_ef_sc_hd__decap_12
X_11731_ net507 net106 VGND VGND VPWR VPWR _04669_ sky130_fd_sc_hd__nand2_1
Xrebuffer92 _04766_ VGND VGND VPWR VPWR net792 sky130_fd_sc_hd__dlymetal6s2s_1
XFILLER_42_633 VGND VGND VPWR VPWR sky130_fd_sc_hd__decap_8
X_11662_ net534 net676 VGND VGND VPWR VPWR _04595_ sky130_fd_sc_hd__nand2_1
XFILLER_41_165 VGND VGND VPWR VPWR sky130_fd_sc_hd__decap_3
X_11593_ _04404_ _04514_ _04513_ VGND VGND VPWR VPWR _04522_ sky130_fd_sc_hd__a21bo_1
X_13401_ clknet_3_1__leaf_clk _00018_ _00111_ VGND VGND VPWR VPWR net200 sky130_fd_sc_hd__dfrtp_1
X_10613_ net375 net347 _03450_ _03451_ VGND VGND VPWR VPWR _03452_ sky130_fd_sc_hd__a22o_1
X_10544_ _03374_ _03375_ VGND VGND VPWR VPWR _03376_ sky130_fd_sc_hd__nand2_1
X_13332_ net33 VGND VGND VPWR VPWR _00106_ sky130_fd_sc_hd__inv_2
XFILLER_10_530 VGND VGND VPWR VPWR sky130_fd_sc_hd__fill_2
XTAP_TAPCELL_ROW_40_856 VGND VPWR sky130_fd_sc_hd__tapvpwrvgnd_1
XFILLER_128_749 VGND VGND VPWR VPWR sky130_fd_sc_hd__decap_6
XFILLER_10_596 VPWR VGND VPWR VGND sky130_ef_sc_hd__decap_12
XFILLER_6_545 VPWR VGND VPWR VGND sky130_ef_sc_hd__decap_12
X_10475_ _03137_ net711 _03145_ VGND VGND VPWR VPWR _03301_ sky130_fd_sc_hd__a21bo_1
X_13263_ _06337_ _06340_ VGND VGND VPWR VPWR _06341_ sky130_fd_sc_hd__xnor2_1
XTAP_TAPCELL_ROW_20_580 VGND VPWR sky130_fd_sc_hd__tapvpwrvgnd_1
XFILLER_135_281 VPWR VGND VPWR VGND sky130_ef_sc_hd__decap_12
X_13194_ _06129_ _06158_ _06266_ VGND VGND VPWR VPWR _06267_ sky130_fd_sc_hd__o21a_1
XFILLER_6_589 VPWR VGND VPWR VGND sky130_ef_sc_hd__decap_12
X_12214_ _05194_ _05195_ VGND VGND VPWR VPWR _05196_ sky130_fd_sc_hd__xnor2_1
X_12145_ _04881_ _04885_ _05119_ _05120_ VGND VGND VPWR VPWR _05121_ sky130_fd_sc_hd__o211ai_2
XFILLER_123_476 VGND VGND VPWR VPWR sky130_fd_sc_hd__fill_2
XFILLER_1_261 VPWR VGND VPWR VGND sky130_ef_sc_hd__decap_12
X_12076_ net508 net494 net677 _04725_ VGND VGND VPWR VPWR _05046_ sky130_fd_sc_hd__o211a_1
XFILLER_110_159 VGND VGND VPWR VPWR sky130_fd_sc_hd__fill_2
X_11027_ _03867_ _03902_ VGND VGND VPWR VPWR _03905_ sky130_fd_sc_hd__xnor2_1
XFILLER_92_533 VGND VGND VPWR VPWR sky130_fd_sc_hd__decap_6
XFILLER_77_585 VGND VGND VPWR VPWR sky130_fd_sc_hd__fill_1
XFILLER_64_213 VGND VGND VPWR VPWR sky130_fd_sc_hd__decap_8
XFILLER_37_449 VGND VGND VPWR VPWR sky130_fd_sc_hd__decap_8
XFILLER_80_706 VGND VGND VPWR VPWR sky130_fd_sc_hd__decap_4
XFILLER_64_246 VGND VGND VPWR VPWR sky130_fd_sc_hd__decap_6
XTAP_TAPCELL_ROW_48_967 VGND VPWR sky130_fd_sc_hd__tapvpwrvgnd_1
XFILLER_18_641 VGND VGND VPWR VPWR sky130_fd_sc_hd__decap_3
XFILLER_18_663 VPWR VGND VPWR VGND sky130_ef_sc_hd__decap_12
XFILLER_52_419 VGND VGND VPWR VPWR sky130_fd_sc_hd__fill_1
XFILLER_18_696 VGND VGND VPWR VPWR sky130_fd_sc_hd__decap_4
X_12978_ _06031_ _06006_ VGND VGND VPWR VPWR _06032_ sky130_fd_sc_hd__and2b_1
XFILLER_33_622 VGND VGND VPWR VPWR sky130_fd_sc_hd__fill_1
X_11929_ _04856_ _04884_ VGND VGND VPWR VPWR _04886_ sky130_fd_sc_hd__xor2_1
XTAP_TAPCELL_ROW_28_680 VGND VPWR sky130_fd_sc_hd__tapvpwrvgnd_1
XTAP_TAPCELL_ROW_28_691 VGND VPWR sky130_fd_sc_hd__tapvpwrvgnd_1
XFILLER_32_121 VPWR VGND VPWR VGND sky130_ef_sc_hd__decap_12
XANTENNA_17 net28 VGND VGND VPWR VPWR sky130_fd_sc_hd__diode_2
XFILLER_20_316 VGND VGND VPWR VPWR sky130_fd_sc_hd__decap_8
XFILLER_32_176 VGND VGND VPWR VPWR sky130_fd_sc_hd__decap_8
XANTENNA_28 net569 VGND VGND VPWR VPWR sky130_fd_sc_hd__diode_2
XFILLER_119_727 VGND VGND VPWR VPWR sky130_fd_sc_hd__fill_1
X_07120_ _06408_ _06410_ _06411_ VGND VGND VPWR VPWR _06412_ sky130_fd_sc_hd__nand3b_1
XFILLER_9_361 VPWR VGND VPWR VGND sky130_ef_sc_hd__decap_12
XFILLER_20_349 VPWR VGND VPWR VGND sky130_ef_sc_hd__decap_12
XTAP_TAPCELL_ROW_95_1619 VGND VPWR sky130_fd_sc_hd__tapvpwrvgnd_1
X_07051_ _06063_ _06041_ _04417_ _04439_ VGND VGND VPWR VPWR _06085_ sky130_fd_sc_hd__o211a_1
XFILLER_114_421 VGND VGND VPWR VPWR sky130_fd_sc_hd__fill_1
Xoutput168 net168 VGND VGND VPWR VPWR out0[15] sky130_fd_sc_hd__buf_2
XFILLER_114_443 VGND VGND VPWR VPWR sky130_fd_sc_hd__decap_3
Xoutput179 net179 VGND VGND VPWR VPWR out1[10] sky130_fd_sc_hd__buf_2
XFILLER_114_498 VPWR VGND VPWR VGND sky130_ef_sc_hd__decap_12
X_07953_ _00689_ _00690_ VGND VGND VPWR VPWR _00691_ sky130_fd_sc_hd__xnor2_1
XFILLER_68_530 VGND VGND VPWR VPWR sky130_fd_sc_hd__fill_2
X_06904_ net614 net444 VGND VGND VPWR VPWR _04483_ sky130_fd_sc_hd__and2_1
X_07884_ _00388_ _00513_ VGND VGND VPWR VPWR _00622_ sky130_fd_sc_hd__and2_1
XFILLER_68_574 VGND VGND VPWR VPWR sky130_fd_sc_hd__decap_4
X_06835_ net527 net521 net685 net682 VGND VGND VPWR VPWR _03729_ sky130_fd_sc_hd__and4_1
XFILLER_95_393 VPWR VGND VPWR VGND sky130_ef_sc_hd__decap_12
XFILLER_83_533 VGND VGND VPWR VPWR sky130_fd_sc_hd__fill_2
X_09623_ net292 net326 _02281_ VGND VGND VPWR VPWR _02377_ sky130_fd_sc_hd__a21oi_1
XFILLER_56_725 VPWR VGND VPWR VGND sky130_ef_sc_hd__decap_12
XFILLER_55_213 VGND VGND VPWR VPWR sky130_fd_sc_hd__decap_8
XFILLER_46_29 VGND VGND VPWR VPWR sky130_fd_sc_hd__fill_2
XFILLER_83_555 VGND VGND VPWR VPWR sky130_fd_sc_hd__decap_4
XFILLER_56_769 VGND VGND VPWR VPWR sky130_fd_sc_hd__decap_4
X_06766_ net532 net684 VGND VGND VPWR VPWR _02976_ sky130_fd_sc_hd__nand2_1
XFILLER_83_588 VGND VGND VPWR VPWR sky130_fd_sc_hd__fill_1
X_09554_ _02301_ _02302_ VGND VGND VPWR VPWR _02303_ sky130_fd_sc_hd__nand2_1
X_09485_ _02081_ _02227_ VGND VGND VPWR VPWR _02228_ sky130_fd_sc_hd__xnor2_1
XTAP_TAPCELL_ROW_104_1748 VGND VPWR sky130_fd_sc_hd__tapvpwrvgnd_1
X_08505_ net455 net447 net556 net554 VGND VGND VPWR VPWR _01234_ sky130_fd_sc_hd__and4_1
X_06697_ net89 VGND VGND VPWR VPWR _02230_ sky130_fd_sc_hd__inv_2
X_08436_ _01164_ _01165_ VGND VGND VPWR VPWR _00011_ sky130_fd_sc_hd__nor2_1
XFILLER_23_154 VGND VGND VPWR VPWR sky130_fd_sc_hd__decap_4
XFILLER_23_165 VGND VGND VPWR VPWR sky130_fd_sc_hd__decap_3
X_08367_ net465 net558 _01095_ _01097_ VGND VGND VPWR VPWR _01098_ sky130_fd_sc_hd__and4_1
XTAP_TAPCELL_ROW_63_1180 VGND VPWR sky130_fd_sc_hd__tapvpwrvgnd_1
X_07318_ net387 net817 net386 net921 VGND VGND VPWR VPWR _06609_ sky130_fd_sc_hd__nand4_1
XFILLER_11_349 VGND VGND VPWR VPWR sky130_fd_sc_hd__decap_6
X_08298_ _01030_ _01031_ VGND VGND VPWR VPWR _01033_ sky130_fd_sc_hd__xor2_1
X_07249_ _06538_ _06539_ VGND VGND VPWR VPWR _06540_ sky130_fd_sc_hd__nand2_1
XFILLER_124_218 VGND VGND VPWR VPWR sky130_fd_sc_hd__decap_4
XFILLER_118_793 VPWR VGND VPWR VGND sky130_ef_sc_hd__decap_12
X_10260_ _03065_ _03066_ VGND VGND VPWR VPWR _03067_ sky130_fd_sc_hd__nand2_1
XFILLER_133_741 VPWR VGND VPWR VGND sky130_ef_sc_hd__decap_12
XFILLER_3_559 VGND VGND VPWR VPWR sky130_fd_sc_hd__fill_1
XFILLER_133_785 VPWR VGND VPWR VGND sky130_ef_sc_hd__decap_12
XFILLER_132_273 VGND VGND VPWR VPWR sky130_fd_sc_hd__fill_2
XTAP_TAPCELL_ROW_115_1899 VGND VPWR sky130_fd_sc_hd__tapvpwrvgnd_1
X_10191_ _02967_ _02990_ _02989_ VGND VGND VPWR VPWR _02992_ sky130_fd_sc_hd__o21bai_1
XPHY_EDGE_ROW_52_Left_189 VGND VGND VPWR VPWR sky130_fd_sc_hd__decap_3
XFILLER_120_424 VGND VGND VPWR VPWR sky130_fd_sc_hd__fill_2
XFILLER_87_69 VGND VGND VPWR VPWR sky130_fd_sc_hd__fill_2
Xfanout340 net58 VGND VGND VPWR VPWR net340 sky130_fd_sc_hd__buf_2
XFILLER_59_541 VGND VGND VPWR VPWR sky130_fd_sc_hd__decap_4
XFILLER_93_319 VGND VGND VPWR VPWR sky130_fd_sc_hd__decap_4
Xfanout373 net41 VGND VGND VPWR VPWR net373 sky130_fd_sc_hd__clkbuf_4
Xfanout384 net38 VGND VGND VPWR VPWR net384 sky130_fd_sc_hd__buf_1
Xfanout351 net51 VGND VGND VPWR VPWR net351 sky130_fd_sc_hd__clkbuf_2
XTAP_TAPCELL_ROW_6_375 VGND VPWR sky130_fd_sc_hd__tapvpwrvgnd_1
Xfanout362 net47 VGND VGND VPWR VPWR net362 sky130_fd_sc_hd__buf_2
XFILLER_19_405 VPWR VGND VPWR VGND sky130_ef_sc_hd__decap_12
XFILLER_101_671 VGND VGND VPWR VPWR sky130_fd_sc_hd__fill_1
Xfanout395 net33 VGND VGND VPWR VPWR net395 sky130_fd_sc_hd__buf_4
X_12901_ _05946_ _05947_ VGND VGND VPWR VPWR _05948_ sky130_fd_sc_hd__nor2_1
XTAP_TAPCELL_ROW_45_926 VGND VPWR sky130_fd_sc_hd__tapvpwrvgnd_1
XFILLER_15_611 VGND VGND VPWR VPWR sky130_fd_sc_hd__fill_1
X_12832_ _05869_ _05870_ VGND VGND VPWR VPWR _05872_ sky130_fd_sc_hd__xnor2_1
XFILLER_61_249 VPWR VGND VPWR VGND sky130_ef_sc_hd__decap_12
XPHY_EDGE_ROW_61_Left_198 VGND VGND VPWR VPWR sky130_fd_sc_hd__decap_3
X_12763_ _05742_ _05796_ VGND VGND VPWR VPWR _05797_ sky130_fd_sc_hd__xor2_1
X_11714_ _04649_ _04650_ net269 net298 VGND VGND VPWR VPWR _04651_ sky130_fd_sc_hd__and4bb_1
XFILLER_14_132 VGND VGND VPWR VPWR sky130_fd_sc_hd__fill_1
XFILLER_14_154 VGND VGND VPWR VPWR sky130_fd_sc_hd__decap_8
XFILLER_15_666 VGND VGND VPWR VPWR sky130_fd_sc_hd__decap_6
XTAP_TAPCELL_ROW_25_650 VGND VPWR sky130_fd_sc_hd__tapvpwrvgnd_1
XFILLER_15_699 VGND VGND VPWR VPWR sky130_fd_sc_hd__decap_4
X_12694_ _05719_ _05720_ VGND VGND VPWR VPWR _05721_ sky130_fd_sc_hd__nor2_1
XFILLER_30_625 VPWR VGND VPWR VGND sky130_ef_sc_hd__decap_12
XFILLER_128_513 VGND VGND VPWR VPWR sky130_fd_sc_hd__decap_8
X_11645_ _04574_ _04575_ _04576_ VGND VGND VPWR VPWR _04577_ sky130_fd_sc_hd__nor3_1
XFILLER_52_94 VGND VGND VPWR VPWR sky130_fd_sc_hd__fill_1
XFILLER_30_669 VPWR VGND VPWR VGND sky130_ef_sc_hd__decap_12
Xinput15 in1[6] VGND VGND VPWR VPWR net15 sky130_fd_sc_hd__clkbuf_4
Xinput37 w00[3] VGND VGND VPWR VPWR net37 sky130_fd_sc_hd__buf_1
Xinput26 in3[1] VGND VGND VPWR VPWR net26 sky130_fd_sc_hd__clkbuf_4
X_11576_ _04502_ _04503_ VGND VGND VPWR VPWR _04504_ sky130_fd_sc_hd__and2b_1
Xinput59 w03[1] VGND VGND VPWR VPWR net59 sky130_fd_sc_hd__buf_1
X_13315_ net397 VGND VGND VPWR VPWR _00089_ sky130_fd_sc_hd__inv_2
X_10527_ _03348_ _03356_ VGND VGND VPWR VPWR _03358_ sky130_fd_sc_hd__xnor2_1
Xinput48 w01[6] VGND VGND VPWR VPWR net48 sky130_fd_sc_hd__clkbuf_2
X_13246_ _06244_ _06265_ _06243_ VGND VGND VPWR VPWR _06322_ sky130_fd_sc_hd__o21ai_1
X_10458_ _03278_ _03279_ _03280_ VGND VGND VPWR VPWR _03283_ sky130_fd_sc_hd__or3_1
XFILLER_97_625 VGND VGND VPWR VPWR sky130_fd_sc_hd__decap_4
XTAP_TAPCELL_ROW_90_1549 VGND VPWR sky130_fd_sc_hd__tapvpwrvgnd_1
XFILLER_69_305 VPWR VGND VPWR VGND sky130_ef_sc_hd__decap_12
X_10389_ _03206_ _03207_ VGND VGND VPWR VPWR _03208_ sky130_fd_sc_hd__and2b_1
X_13177_ _06009_ _06247_ VGND VGND VPWR VPWR _06249_ sky130_fd_sc_hd__xnor2_1
XFILLER_111_446 VGND VGND VPWR VPWR sky130_fd_sc_hd__fill_2
XFILLER_69_349 VPWR VGND VPWR VGND sky130_ef_sc_hd__decap_12
X_12128_ _05098_ _05099_ _05100_ VGND VGND VPWR VPWR _05103_ sky130_fd_sc_hd__a21o_1
XFILLER_2_581 VGND VGND VPWR VPWR sky130_fd_sc_hd__decap_6
XFILLER_111_457 VGND VGND VPWR VPWR sky130_fd_sc_hd__fill_2
XFILLER_96_168 VGND VGND VPWR VPWR sky130_fd_sc_hd__fill_1
XFILLER_77_91 VPWR VGND VPWR VGND sky130_ef_sc_hd__decap_12
X_12059_ net529 net661 net659 net534 VGND VGND VPWR VPWR _05028_ sky130_fd_sc_hd__a22oi_1
XFILLER_65_511 VPWR VGND VPWR VGND sky130_ef_sc_hd__decap_12
XFILLER_38_769 VGND VGND VPWR VPWR sky130_fd_sc_hd__decap_6
XFILLER_80_525 VGND VGND VPWR VPWR sky130_fd_sc_hd__fill_1
X_09270_ _01991_ _01992_ VGND VGND VPWR VPWR _01994_ sky130_fd_sc_hd__and2b_1
X_08221_ _00954_ _00955_ VGND VGND VPWR VPWR _00956_ sky130_fd_sc_hd__nor2_1
XFILLER_21_647 VGND VGND VPWR VPWR sky130_fd_sc_hd__fill_2
XFILLER_33_485 VGND VGND VPWR VPWR sky130_fd_sc_hd__fill_1
XFILLER_20_124 VGND VGND VPWR VPWR sky130_fd_sc_hd__decap_4
XFILLER_21_669 VGND VGND VPWR VPWR sky130_fd_sc_hd__decap_3
XFILLER_119_535 VPWR VGND VPWR VGND sky130_ef_sc_hd__decap_12
X_08152_ _00886_ _00887_ VGND VGND VPWR VPWR _00888_ sky130_fd_sc_hd__nor2_1
X_08083_ _00576_ _00819_ VGND VGND VPWR VPWR _00820_ sky130_fd_sc_hd__nand2_1
X_07103_ _03773_ _05265_ _06394_ VGND VGND VPWR VPWR _06395_ sky130_fd_sc_hd__a21oi_1
XFILLER_9_191 VGND VGND VPWR VPWR sky130_fd_sc_hd__decap_3
XTAP_TAPCELL_ROW_132_2144 VGND VPWR sky130_fd_sc_hd__tapvpwrvgnd_1
XFILLER_106_229 VGND VGND VPWR VPWR sky130_fd_sc_hd__fill_1
X_07034_ net390 net388 net816 net818 VGND VGND VPWR VPWR _05899_ sky130_fd_sc_hd__and4_1
XFILLER_115_785 VPWR VGND VPWR VGND sky130_ef_sc_hd__decap_12
XFILLER_130_755 VGND VGND VPWR VPWR sky130_fd_sc_hd__fill_1
XFILLER_114_284 VPWR VGND VPWR VGND sky130_ef_sc_hd__decap_12
X_08985_ net97 net324 VGND VGND VPWR VPWR _01711_ sky130_fd_sc_hd__and2_1
XFILLER_102_457 VPWR VGND VPWR VGND sky130_ef_sc_hd__decap_12
X_07936_ _00537_ _00539_ _00536_ VGND VGND VPWR VPWR _00674_ sky130_fd_sc_hd__o21ba_1
XFILLER_87_157 VGND VGND VPWR VPWR sky130_fd_sc_hd__decap_8
XFILLER_75_319 VPWR VGND VPWR VGND sky130_ef_sc_hd__decap_12
XTAP_TAPCELL_ROW_3_334 VGND VPWR sky130_fd_sc_hd__tapvpwrvgnd_1
X_07867_ _00599_ _00603_ VGND VGND VPWR VPWR _00605_ sky130_fd_sc_hd__xnor2_1
XFILLER_29_758 VGND VGND VPWR VPWR sky130_fd_sc_hd__decap_3
X_09606_ _02279_ _02358_ VGND VGND VPWR VPWR _02359_ sky130_fd_sc_hd__xnor2_2
X_06818_ _03510_ _03532_ VGND VGND VPWR VPWR _03543_ sky130_fd_sc_hd__and2_1
X_07798_ net418 net603 net411 net605 VGND VGND VPWR VPWR _00537_ sky130_fd_sc_hd__a22oi_1
XFILLER_83_374 VPWR VGND VPWR VGND sky130_ef_sc_hd__decap_12
XFILLER_71_525 VGND VGND VPWR VPWR sky130_fd_sc_hd__decap_6
XFILLER_56_577 VGND VGND VPWR VPWR sky130_fd_sc_hd__decap_8
XFILLER_44_739 VGND VGND VPWR VPWR sky130_fd_sc_hd__fill_1
XFILLER_28_279 VPWR VGND VPWR VGND sky130_ef_sc_hd__decap_12
X_06749_ _02435_ _02772_ VGND VGND VPWR VPWR _02791_ sky130_fd_sc_hd__xnor2_1
X_09537_ _02281_ _02282_ VGND VGND VPWR VPWR _02285_ sky130_fd_sc_hd__xor2_1
X_09468_ _02190_ _02209_ VGND VGND VPWR VPWR _02210_ sky130_fd_sc_hd__xnor2_2
XFILLER_11_113 VPWR VGND VPWR VGND sky130_ef_sc_hd__decap_12
XFILLER_12_636 VGND VGND VPWR VPWR sky130_fd_sc_hd__decap_8
XFILLER_24_474 VGND VGND VPWR VPWR sky130_fd_sc_hd__fill_2
X_09399_ net510 net624 VGND VGND VPWR VPWR _02134_ sky130_fd_sc_hd__and2b_1
X_08419_ _01140_ _01148_ VGND VGND VPWR VPWR _01149_ sky130_fd_sc_hd__xor2_1
XFILLER_51_293 VGND VGND VPWR VPWR sky130_fd_sc_hd__decap_8
XTAP_TAPCELL_ROW_50_995 VGND VPWR sky130_fd_sc_hd__tapvpwrvgnd_1
X_11430_ _03589_ _04344_ VGND VGND VPWR VPWR _04345_ sky130_fd_sc_hd__xnor2_1
XFILLER_125_3 VPWR VGND VPWR VGND sky130_ef_sc_hd__decap_12
XTAP_TAPCELL_ROW_117_1939 VGND VPWR sky130_fd_sc_hd__tapvpwrvgnd_1
XTAP_TAPCELL_ROW_117_1928 VGND VPWR sky130_fd_sc_hd__tapvpwrvgnd_1
X_11361_ _04269_ _04239_ VGND VGND VPWR VPWR _04270_ sky130_fd_sc_hd__and2b_1
X_10312_ _03120_ _03121_ _03122_ VGND VGND VPWR VPWR _03124_ sky130_fd_sc_hd__a21oi_1
X_13100_ _06029_ _06032_ VGND VGND VPWR VPWR _06165_ sky130_fd_sc_hd__nor2_1
XFILLER_22_97 VGND VGND VPWR VPWR sky130_fd_sc_hd__decap_8
XFILLER_106_730 VGND VGND VPWR VPWR sky130_fd_sc_hd__fill_2
XTAP_TAPCELL_ROW_76_1360 VGND VPWR sky130_fd_sc_hd__tapvpwrvgnd_1
X_11292_ net559 _04192_ VGND VGND VPWR VPWR _04194_ sky130_fd_sc_hd__and2_1
XFILLER_79_614 VGND VGND VPWR VPWR sky130_fd_sc_hd__fill_2
X_10243_ _03048_ VGND VGND VPWR VPWR _03049_ sky130_fd_sc_hd__inv_2
X_13031_ _06088_ _06089_ VGND VGND VPWR VPWR _06090_ sky130_fd_sc_hd__or2_1
XFILLER_78_124 VGND VGND VPWR VPWR sky130_fd_sc_hd__decap_3
X_10174_ net822 net353 net351 net376 VGND VGND VPWR VPWR _02973_ sky130_fd_sc_hd__a22oi_2
XFILLER_121_777 VGND VGND VPWR VPWR sky130_fd_sc_hd__decap_6
XFILLER_47_555 VGND VGND VPWR VPWR sky130_fd_sc_hd__decap_4
XFILLER_47_72 VGND VGND VPWR VPWR sky130_fd_sc_hd__fill_1
XFILLER_19_279 VGND VGND VPWR VPWR sky130_fd_sc_hd__fill_1
XFILLER_74_385 VGND VGND VPWR VPWR sky130_fd_sc_hd__decap_3
XFILLER_28_780 VPWR VGND VPWR VGND sky130_ef_sc_hd__decap_12
X_12815_ _05686_ _05696_ _05695_ VGND VGND VPWR VPWR _05853_ sky130_fd_sc_hd__a21oi_1
XFILLER_43_761 VPWR VGND VPWR VGND sky130_ef_sc_hd__decap_12
XFILLER_97_7 VPWR VGND VPWR VGND sky130_ef_sc_hd__decap_12
Xclkbuf_3_4__f_clk clknet_0_clk VGND VGND VPWR VPWR clknet_3_4__leaf_clk sky130_fd_sc_hd__clkbuf_16
X_12746_ _05776_ _05777_ VGND VGND VPWR VPWR _05778_ sky130_fd_sc_hd__nor2_1
XFILLER_30_411 VGND VGND VPWR VPWR sky130_fd_sc_hd__decap_3
X_12677_ _05577_ _05579_ _05701_ VGND VGND VPWR VPWR _05703_ sky130_fd_sc_hd__o21ai_1
XFILLER_128_321 VGND VGND VPWR VPWR sky130_fd_sc_hd__decap_8
X_11628_ _04446_ _04458_ _04457_ VGND VGND VPWR VPWR _04561_ sky130_fd_sc_hd__o21ba_1
XFILLER_30_477 VPWR VGND VPWR VGND sky130_ef_sc_hd__decap_12
XFILLER_128_387 VGND VGND VPWR VPWR sky130_fd_sc_hd__decap_4
XFILLER_7_673 VPWR VGND VPWR VGND sky130_ef_sc_hd__decap_12
X_11559_ _04484_ _04485_ VGND VGND VPWR VPWR _04486_ sky130_fd_sc_hd__and2b_1
XFILLER_124_571 VGND VGND VPWR VPWR sky130_fd_sc_hd__decap_4
X_13229_ _06196_ _06198_ _06305_ VGND VGND VPWR VPWR _06306_ sky130_fd_sc_hd__o21ba_1
XFILLER_40_3 VGND VGND VPWR VPWR sky130_fd_sc_hd__fill_2
XFILLER_111_210 VPWR VGND VPWR VGND sky130_ef_sc_hd__decap_12
XFILLER_69_113 VGND VGND VPWR VPWR sky130_fd_sc_hd__decap_6
X_08770_ net501 net509 net632 net630 VGND VGND VPWR VPWR _01497_ sky130_fd_sc_hd__nand4_1
XPHY_EDGE_ROW_108_Left_245 VGND VGND VPWR VPWR sky130_fd_sc_hd__decap_3
X_07721_ _00329_ _00331_ _00328_ VGND VGND VPWR VPWR _00460_ sky130_fd_sc_hd__a21oi_1
XFILLER_84_149 VPWR VGND VPWR VGND sky130_ef_sc_hd__decap_12
X_07652_ _00236_ _00241_ _00235_ VGND VGND VPWR VPWR _00392_ sky130_fd_sc_hd__a21bo_1
XFILLER_25_205 VPWR VGND VPWR VGND sky130_ef_sc_hd__decap_12
XFILLER_38_566 VPWR VGND VPWR VGND sky130_ef_sc_hd__decap_12
X_07583_ _00287_ _00321_ VGND VGND VPWR VPWR _00323_ sky130_fd_sc_hd__xnor2_1
XFILLER_65_396 VGND VGND VPWR VPWR sky130_fd_sc_hd__decap_3
XFILLER_19_780 VGND VGND VPWR VPWR sky130_fd_sc_hd__decap_4
XFILLER_80_355 VGND VGND VPWR VPWR sky130_fd_sc_hd__decap_4
X_09322_ _02037_ _02038_ _02049_ VGND VGND VPWR VPWR _02050_ sky130_fd_sc_hd__a21o_1
XFILLER_34_750 VGND VGND VPWR VPWR sky130_fd_sc_hd__decap_6
XTAP_TAPCELL_ROW_101_1707 VGND VPWR sky130_fd_sc_hd__tapvpwrvgnd_1
XFILLER_80_388 VPWR VGND VPWR VGND sky130_ef_sc_hd__decap_12
X_09253_ net494 net628 _01973_ _01976_ VGND VGND VPWR VPWR _01977_ sky130_fd_sc_hd__a22o_1
X_08204_ _00829_ _00826_ _00824_ VGND VGND VPWR VPWR _00940_ sky130_fd_sc_hd__o21bai_1
XPHY_EDGE_ROW_117_Left_254 VGND VGND VPWR VPWR sky130_fd_sc_hd__decap_3
X_09184_ _01907_ _01906_ _01739_ _01741_ VGND VGND VPWR VPWR _01909_ sky130_fd_sc_hd__o211a_1
XFILLER_119_354 VPWR VGND VPWR VGND sky130_ef_sc_hd__decap_12
X_08135_ net410 _02164_ _06561_ VGND VGND VPWR VPWR _00871_ sky130_fd_sc_hd__o21a_1
XFILLER_4_109 VPWR VGND VPWR VGND sky130_ef_sc_hd__decap_12
XFILLER_134_357 VGND VGND VPWR VPWR sky130_fd_sc_hd__decap_6
X_08066_ _00793_ _00801_ VGND VGND VPWR VPWR _00803_ sky130_fd_sc_hd__xor2_1
X_07017_ _05680_ _05691_ _05669_ VGND VGND VPWR VPWR _05713_ sky130_fd_sc_hd__o21ai_1
XTAP_TAPCELL_ROW_8_404 VGND VPWR sky130_fd_sc_hd__tapvpwrvgnd_1
XTAP_TAPCELL_ROW_112_1869 VGND VPWR sky130_fd_sc_hd__tapvpwrvgnd_1
XTAP_TAPCELL_ROW_112_1858 VGND VPWR sky130_fd_sc_hd__tapvpwrvgnd_1
XFILLER_68_27 VGND VGND VPWR VPWR sky130_fd_sc_hd__fill_1
XFILLER_0_337 VPWR VGND VPWR VGND sky130_ef_sc_hd__decap_12
XPHY_EDGE_ROW_126_Left_263 VGND VGND VPWR VPWR sky130_fd_sc_hd__decap_3
XFILLER_103_799 VPWR VGND VPWR VGND sky130_ef_sc_hd__decap_12
XFILLER_102_265 VGND VGND VPWR VPWR sky130_fd_sc_hd__decap_6
X_08968_ _01544_ _01693_ VGND VGND VPWR VPWR _01694_ sky130_fd_sc_hd__nor2_1
XTAP_TAPCELL_ROW_71_1290 VGND VPWR sky130_fd_sc_hd__tapvpwrvgnd_1
XFILLER_69_680 VPWR VGND VPWR VGND sky130_ef_sc_hd__decap_12
XFILLER_124_77 VGND VGND VPWR VPWR sky130_fd_sc_hd__decap_6
X_08899_ _01619_ _01624_ VGND VGND VPWR VPWR _01625_ sky130_fd_sc_hd__xor2_1
X_07919_ _00654_ _00655_ VGND VGND VPWR VPWR _00657_ sky130_fd_sc_hd__xor2_1
XFILLER_56_363 VGND VGND VPWR VPWR sky130_fd_sc_hd__fill_1
XFILLER_44_514 VPWR VGND VPWR VGND sky130_ef_sc_hd__decap_12
XFILLER_16_205 VGND VGND VPWR VPWR sky130_fd_sc_hd__decap_3
XFILLER_29_588 VGND VGND VPWR VPWR sky130_fd_sc_hd__decap_8
X_10930_ _03781_ _03797_ VGND VGND VPWR VPWR _03799_ sky130_fd_sc_hd__xnor2_1
XFILLER_56_385 VPWR VGND VPWR VGND sky130_ef_sc_hd__decap_12
XFILLER_44_558 VPWR VGND VPWR VGND sky130_ef_sc_hd__decap_12
XFILLER_25_761 VGND VGND VPWR VPWR sky130_fd_sc_hd__decap_6
X_12600_ _05616_ _05617_ _05618_ VGND VGND VPWR VPWR _05619_ sky130_fd_sc_hd__nand3_1
X_10861_ net539 net279 VGND VGND VPWR VPWR _03723_ sky130_fd_sc_hd__and2_1
X_10792_ _03646_ _03647_ VGND VGND VPWR VPWR _03648_ sky130_fd_sc_hd__xnor2_1
XPHY_EDGE_ROW_135_Left_272 VGND VGND VPWR VPWR sky130_fd_sc_hd__decap_3
XFILLER_24_282 VGND VGND VPWR VPWR sky130_fd_sc_hd__fill_2
X_12531_ _05381_ _05397_ _05395_ VGND VGND VPWR VPWR _05543_ sky130_fd_sc_hd__o21ai_1
X_12462_ _05283_ _05285_ _05466_ _05467_ VGND VGND VPWR VPWR _05468_ sky130_fd_sc_hd__a211o_4
X_11413_ _04315_ _04324_ VGND VGND VPWR VPWR _04326_ sky130_fd_sc_hd__xnor2_1
X_12393_ _05383_ _05390_ VGND VGND VPWR VPWR _05392_ sky130_fd_sc_hd__xor2_1
XFILLER_4_643 VGND VGND VPWR VPWR sky130_fd_sc_hd__fill_1
X_11344_ _04032_ _04040_ _04249_ VGND VGND VPWR VPWR _04251_ sky130_fd_sc_hd__nand3_1
XFILLER_113_519 VGND VGND VPWR VPWR sky130_fd_sc_hd__fill_1
X_11275_ net331 net308 net343 net342 VGND VGND VPWR VPWR _04175_ sky130_fd_sc_hd__and4b_1
X_10226_ _03027_ _03026_ _03028_ VGND VGND VPWR VPWR _03030_ sky130_fd_sc_hd__or3_4
X_13014_ _06070_ _06040_ VGND VGND VPWR VPWR _06071_ sky130_fd_sc_hd__and2b_1
XFILLER_121_541 VGND VGND VPWR VPWR sky130_fd_sc_hd__decap_4
XFILLER_67_617 VGND VGND VPWR VPWR sky130_fd_sc_hd__decap_6
X_10157_ _02953_ _02949_ VGND VGND VPWR VPWR _02955_ sky130_fd_sc_hd__and2b_1
XTAP_TAPCELL_ROW_89_1540 VGND VPWR sky130_fd_sc_hd__tapvpwrvgnd_1
X_10088_ _02800_ _02842_ _02875_ VGND VGND VPWR VPWR _02879_ sky130_fd_sc_hd__or3_1
XFILLER_75_683 VGND VGND VPWR VPWR sky130_fd_sc_hd__decap_6
XFILLER_47_374 VGND VGND VPWR VPWR sky130_fd_sc_hd__fill_1
XFILLER_74_182 VGND VGND VPWR VPWR sky130_fd_sc_hd__fill_2
XFILLER_50_506 VPWR VGND VPWR VGND sky130_ef_sc_hd__decap_12
XFILLER_35_558 VGND VGND VPWR VPWR sky130_fd_sc_hd__fill_2
XFILLER_62_377 VPWR VGND VPWR VGND sky130_ef_sc_hd__decap_12
X_12729_ net791 net360 VGND VGND VPWR VPWR _05760_ sky130_fd_sc_hd__and2b_1
XFILLER_31_742 VGND VGND VPWR VPWR sky130_fd_sc_hd__fill_1
XTAP_TAPCELL_ROW_33_759 VGND VPWR sky130_fd_sc_hd__tapvpwrvgnd_1
XFILLER_88_3 VGND VGND VPWR VPWR sky130_fd_sc_hd__fill_2
XFILLER_31_797 VGND VGND VPWR VPWR sky130_fd_sc_hd__decap_4
XFILLER_129_641 VPWR VGND VPWR VGND sky130_ef_sc_hd__decap_12
XTAP_TAPCELL_ROW_13_472 VGND VPWR sky130_fd_sc_hd__tapvpwrvgnd_1
XTAP_TAPCELL_ROW_13_483 VGND VPWR sky130_fd_sc_hd__tapvpwrvgnd_1
XFILLER_129_685 VPWR VGND VPWR VGND sky130_ef_sc_hd__decap_12
X_09940_ _02616_ _02721_ VGND VGND VPWR VPWR _02722_ sky130_fd_sc_hd__and2b_1
XFILLER_116_368 VPWR VGND VPWR VGND sky130_ef_sc_hd__decap_12
XFILLER_104_519 VGND VGND VPWR VPWR sky130_fd_sc_hd__decap_6
XPHY_EDGE_ROW_115_Right_115 VGND VGND VPWR VPWR sky130_fd_sc_hd__decap_3
XFILLER_98_753 VGND VGND VPWR VPWR sky130_fd_sc_hd__decap_3
X_09871_ _02645_ _02646_ VGND VGND VPWR VPWR _02647_ sky130_fd_sc_hd__nor2_1
XFILLER_100_714 VPWR VGND VPWR VGND sky130_ef_sc_hd__decap_12
XFILLER_97_263 VGND VGND VPWR VPWR sky130_fd_sc_hd__decap_3
XFILLER_85_425 VGND VGND VPWR VPWR sky130_fd_sc_hd__decap_3
X_08822_ _01547_ _01548_ VGND VGND VPWR VPWR _01549_ sky130_fd_sc_hd__and2b_1
XFILLER_38_19 VGND VGND VPWR VPWR sky130_fd_sc_hd__decap_8
X_08753_ _01469_ _01479_ VGND VGND VPWR VPWR _01480_ sky130_fd_sc_hd__xor2_1
XTAP_TAPCELL_ROW_127_2076 VGND VPWR sky130_fd_sc_hd__tapvpwrvgnd_1
X_07704_ net594 net305 _00442_ VGND VGND VPWR VPWR _00443_ sky130_fd_sc_hd__and3_1
XFILLER_38_363 VGND VGND VPWR VPWR sky130_fd_sc_hd__fill_1
X_08684_ _01408_ _01411_ VGND VGND VPWR VPWR _01412_ sky130_fd_sc_hd__xnor2_1
X_07635_ _00374_ _00361_ VGND VGND VPWR VPWR _00375_ sky130_fd_sc_hd__and2b_1
XFILLER_80_141 VGND VGND VPWR VPWR sky130_fd_sc_hd__fill_2
XFILLER_65_193 VGND VGND VPWR VPWR sky130_fd_sc_hd__decap_6
X_07566_ _00171_ _00179_ _00178_ VGND VGND VPWR VPWR _00306_ sky130_fd_sc_hd__a21oi_1
XFILLER_41_528 VGND VGND VPWR VPWR sky130_fd_sc_hd__decap_8
X_09305_ _02026_ _02028_ _02029_ VGND VGND VPWR VPWR _02031_ sky130_fd_sc_hd__or3_4
XFILLER_21_230 VGND VGND VPWR VPWR sky130_fd_sc_hd__decap_4
XFILLER_22_753 VGND VGND VPWR VPWR sky130_fd_sc_hd__decap_3
X_09236_ _01956_ _01957_ VGND VGND VPWR VPWR _01960_ sky130_fd_sc_hd__xor2_1
X_07497_ net749 net383 net819 net385 VGND VGND VPWR VPWR _00238_ sky130_fd_sc_hd__a22o_1
XFILLER_21_241 VPWR VGND VPWR VGND sky130_ef_sc_hd__decap_12
XPHY_EDGE_ROW_17_Right_17 VGND VGND VPWR VPWR sky130_fd_sc_hd__decap_3
X_09167_ _01724_ _01726_ _01890_ _01891_ VGND VGND VPWR VPWR _01892_ sky130_fd_sc_hd__a211o_1
XFILLER_5_429 VPWR VGND VPWR VGND sky130_ef_sc_hd__decap_12
XFILLER_134_121 VPWR VGND VPWR VGND sky130_ef_sc_hd__decap_12
XFILLER_119_55 VGND VGND VPWR VPWR sky130_fd_sc_hd__fill_1
XFILLER_107_335 VGND VGND VPWR VPWR sky130_fd_sc_hd__fill_1
X_09098_ _01649_ _01821_ VGND VGND VPWR VPWR _01823_ sky130_fd_sc_hd__xnor2_1
X_08118_ _00723_ _00725_ _00852_ VGND VGND VPWR VPWR _00854_ sky130_fd_sc_hd__or3_1
XFILLER_134_165 VPWR VGND VPWR VGND sky130_ef_sc_hd__decap_12
X_08049_ net305 net570 _00582_ _00784_ _00440_ VGND VGND VPWR VPWR _00786_ sky130_fd_sc_hd__a311o_1
XFILLER_107_357 VPWR VGND VPWR VGND sky130_ef_sc_hd__decap_12
XFILLER_79_48 VGND VGND VPWR VPWR sky130_fd_sc_hd__decap_3
X_11060_ _03909_ _03939_ VGND VGND VPWR VPWR _03941_ sky130_fd_sc_hd__xnor2_1
XFILLER_115_390 VGND VGND VPWR VPWR sky130_fd_sc_hd__fill_2
X_10011_ _02782_ _02795_ VGND VGND VPWR VPWR _02796_ sky130_fd_sc_hd__nand2_1
XFILLER_49_617 VGND VGND VPWR VPWR sky130_fd_sc_hd__fill_2
XPHY_EDGE_ROW_26_Right_26 VGND VGND VPWR VPWR sky130_fd_sc_hd__decap_3
XFILLER_57_683 VPWR VGND VPWR VGND sky130_ef_sc_hd__decap_12
XFILLER_56_171 VGND VGND VPWR VPWR sky130_fd_sc_hd__decap_6
X_11962_ net463 net587 _04740_ _04739_ VGND VGND VPWR VPWR _04922_ sky130_fd_sc_hd__a31o_1
XFILLER_28_85 VPWR VGND VPWR VGND sky130_ef_sc_hd__decap_12
X_11893_ _04843_ _04845_ VGND VGND VPWR VPWR _04847_ sky130_fd_sc_hd__xnor2_2
XFILLER_60_804 VGND VGND VPWR VPWR sky130_fd_sc_hd__decap_3
XFILLER_44_344 VPWR VGND VPWR VGND sky130_ef_sc_hd__decap_12
X_10913_ _03616_ _03618_ VGND VGND VPWR VPWR _03780_ sky130_fd_sc_hd__nand2_1
XTAP_TAPCELL_ROW_84_1470 VGND VPWR sky130_fd_sc_hd__tapvpwrvgnd_1
XFILLER_32_517 VPWR VGND VPWR VGND sky130_ef_sc_hd__decap_12
X_10844_ net638 net87 _03523_ _03522_ VGND VGND VPWR VPWR _03704_ sky130_fd_sc_hd__a31o_1
XFILLER_25_580 VGND VGND VPWR VPWR sky130_fd_sc_hd__decap_4
XTAP_TAPCELL_ROW_30_718 VGND VPWR sky130_fd_sc_hd__tapvpwrvgnd_1
X_10775_ _03427_ _03628_ VGND VGND VPWR VPWR _03629_ sky130_fd_sc_hd__nor2_1
X_12514_ _05345_ _05523_ VGND VGND VPWR VPWR _05524_ sky130_fd_sc_hd__and2b_2
XPHY_EDGE_ROW_35_Right_35 VGND VGND VPWR VPWR sky130_fd_sc_hd__decap_3
XFILLER_40_561 VGND VGND VPWR VPWR sky130_fd_sc_hd__decap_3
XFILLER_8_245 VGND VGND VPWR VPWR sky130_fd_sc_hd__decap_6
XFILLER_13_797 VPWR VGND VPWR VGND sky130_ef_sc_hd__decap_12
XFILLER_40_583 VGND VGND VPWR VPWR sky130_fd_sc_hd__decap_4
XFILLER_60_83 VGND VGND VPWR VPWR sky130_fd_sc_hd__fill_1
XTAP_TAPCELL_ROW_10_431 VGND VPWR sky130_fd_sc_hd__tapvpwrvgnd_1
X_12445_ _05441_ _05442_ _05447_ VGND VGND VPWR VPWR _05449_ sky130_fd_sc_hd__nand3_1
X_12376_ net486 net674 net672 net492 VGND VGND VPWR VPWR _05373_ sky130_fd_sc_hd__a22o_1
XFILLER_125_165 VGND VGND VPWR VPWR sky130_fd_sc_hd__decap_3
X_11327_ _04206_ _04230_ VGND VGND VPWR VPWR _04233_ sky130_fd_sc_hd__xnor2_1
XFILLER_126_699 VGND VGND VPWR VPWR sky130_fd_sc_hd__fill_1
XFILLER_69_81 VGND VGND VPWR VPWR sky130_fd_sc_hd__fill_1
X_11258_ _03861_ _04010_ _04009_ VGND VGND VPWR VPWR _04158_ sky130_fd_sc_hd__a21oi_2
XPHY_EDGE_ROW_44_Right_44 VGND VGND VPWR VPWR sky130_fd_sc_hd__decap_3
XFILLER_121_371 VGND VGND VPWR VPWR sky130_fd_sc_hd__fill_1
XFILLER_79_285 VGND VGND VPWR VPWR sky130_fd_sc_hd__fill_1
X_10209_ _03002_ _02830_ _03011_ VGND VGND VPWR VPWR _03012_ sky130_fd_sc_hd__and3_1
X_11189_ _03426_ _04081_ VGND VGND VPWR VPWR _04082_ sky130_fd_sc_hd__xnor2_1
XFILLER_39_127 VGND VGND VPWR VPWR sky130_fd_sc_hd__decap_8
XTAP_TAPCELL_ROW_38_829 VGND VPWR sky130_fd_sc_hd__tapvpwrvgnd_1
XFILLER_62_141 VPWR VGND VPWR VGND sky130_ef_sc_hd__decap_12
XTAP_TAPCELL_ROW_18_542 VGND VPWR sky130_fd_sc_hd__tapvpwrvgnd_1
XTAP_TAPCELL_ROW_18_553 VGND VPWR sky130_fd_sc_hd__tapvpwrvgnd_1
X_07420_ _00139_ _00159_ VGND VGND VPWR VPWR _00161_ sky130_fd_sc_hd__xnor2_1
XFILLER_90_483 VPWR VGND VPWR VGND sky130_ef_sc_hd__decap_12
XFILLER_90_472 VGND VGND VPWR VPWR sky130_fd_sc_hd__decap_4
XFILLER_35_377 VPWR VGND VPWR VGND sky130_ef_sc_hd__decap_12
XFILLER_35_399 VPWR VGND VPWR VGND sky130_ef_sc_hd__decap_12
X_07351_ _06585_ _06641_ VGND VGND VPWR VPWR _06642_ sky130_fd_sc_hd__or2_4
XPHY_EDGE_ROW_53_Right_53 VGND VGND VPWR VPWR sky130_fd_sc_hd__decap_3
XFILLER_16_580 VGND VGND VPWR VPWR sky130_fd_sc_hd__decap_8
XFILLER_31_561 VGND VGND VPWR VPWR sky130_fd_sc_hd__decap_8
X_07282_ _06570_ _06571_ _06567_ VGND VGND VPWR VPWR _06573_ sky130_fd_sc_hd__a21o_1
X_09021_ _01583_ _01746_ VGND VGND VPWR VPWR _01747_ sky130_fd_sc_hd__nor2_1
XFILLER_132_625 VPWR VGND VPWR VGND sky130_ef_sc_hd__decap_12
XFILLER_131_113 VPWR VGND VPWR VGND sky130_ef_sc_hd__decap_12
XPHY_EDGE_ROW_62_Right_62 VGND VGND VPWR VPWR sky130_fd_sc_hd__decap_3
XFILLER_132_669 VPWR VGND VPWR VGND sky130_ef_sc_hd__decap_12
XTAP_TAPCELL_ROW_129_2105 VGND VPWR sky130_fd_sc_hd__tapvpwrvgnd_1
X_09923_ _02678_ _02702_ VGND VGND VPWR VPWR _02704_ sky130_fd_sc_hd__xor2_1
XTAP_TAPCELL_ROW_55_1060 VGND VPWR sky130_fd_sc_hd__tapvpwrvgnd_1
X_09854_ _02627_ _02628_ VGND VGND VPWR VPWR _00055_ sky130_fd_sc_hd__xnor2_1
XFILLER_112_360 VGND VGND VPWR VPWR sky130_fd_sc_hd__decap_4
XFILLER_86_701 VGND VGND VPWR VPWR sky130_fd_sc_hd__fill_2
XTAP_TAPCELL_ROW_55_1071 VGND VPWR sky130_fd_sc_hd__tapvpwrvgnd_1
XFILLER_85_222 VGND VGND VPWR VPWR sky130_fd_sc_hd__fill_2
XFILLER_85_211 VGND VGND VPWR VPWR sky130_fd_sc_hd__fill_2
X_08805_ _01529_ _01530_ _01531_ VGND VGND VPWR VPWR _01532_ sky130_fd_sc_hd__nand3_1
XFILLER_58_458 VGND VGND VPWR VPWR sky130_fd_sc_hd__fill_2
X_06997_ _05484_ _05385_ VGND VGND VPWR VPWR _05494_ sky130_fd_sc_hd__xnor2_2
X_09785_ net415 net537 _02403_ _02310_ VGND VGND VPWR VPWR _02553_ sky130_fd_sc_hd__a31o_1
XFILLER_85_277 VGND VGND VPWR VPWR sky130_fd_sc_hd__decap_3
X_08736_ net270 net253 _01462_ VGND VGND VPWR VPWR _01463_ sky130_fd_sc_hd__a21o_1
X_08667_ net439 net556 net554 net447 VGND VGND VPWR VPWR _01395_ sky130_fd_sc_hd__a22oi_2
XFILLER_54_653 VGND VGND VPWR VPWR sky130_fd_sc_hd__fill_2
XFILLER_42_804 VGND VGND VPWR VPWR sky130_fd_sc_hd__decap_4
X_07618_ _00327_ _00356_ VGND VGND VPWR VPWR _00358_ sky130_fd_sc_hd__xnor2_1
XFILLER_81_27 VGND VGND VPWR VPWR sky130_fd_sc_hd__fill_2
XPHY_EDGE_ROW_71_Right_71 VGND VGND VPWR VPWR sky130_fd_sc_hd__decap_3
XFILLER_53_174 VGND VGND VPWR VPWR sky130_fd_sc_hd__fill_1
X_08598_ _01325_ _01326_ VGND VGND VPWR VPWR _01327_ sky130_fd_sc_hd__nand2b_4
X_07549_ net306 net594 net570 net316 VGND VGND VPWR VPWR _00289_ sky130_fd_sc_hd__a22oi_1
XTAP_TAPCELL_ROW_120_1979 VGND VPWR sky130_fd_sc_hd__tapvpwrvgnd_1
XTAP_TAPCELL_ROW_120_1968 VGND VPWR sky130_fd_sc_hd__tapvpwrvgnd_1
XFILLER_10_701 VPWR VGND VPWR VGND sky130_ef_sc_hd__decap_12
X_10560_ net458 net559 _03393_ VGND VGND VPWR VPWR _03394_ sky130_fd_sc_hd__and3_1
X_09219_ _01788_ _01790_ _01787_ VGND VGND VPWR VPWR _01943_ sky130_fd_sc_hd__a21o_1
X_10491_ _03317_ _03316_ _03225_ VGND VGND VPWR VPWR _03319_ sky130_fd_sc_hd__a21o_1
X_12230_ _05044_ _05213_ VGND VGND VPWR VPWR _05214_ sky130_fd_sc_hd__or2_1
XFILLER_6_749 VGND VGND VPWR VPWR sky130_fd_sc_hd__decap_6
XFILLER_5_237 VPWR VGND VPWR VGND sky130_ef_sc_hd__decap_12
XFILLER_135_441 VGND VGND VPWR VPWR sky130_fd_sc_hd__decap_6
XFILLER_123_603 VPWR VGND VPWR VGND sky130_ef_sc_hd__decap_12
XPHY_EDGE_ROW_80_Right_80 VGND VGND VPWR VPWR sky130_fd_sc_hd__decap_3
XFILLER_135_485 VPWR VGND VPWR VGND sky130_ef_sc_hd__decap_12
X_12161_ net665 net79 net285 net690 VGND VGND VPWR VPWR _05138_ sky130_fd_sc_hd__a22o_1
XFILLER_123_658 VGND VGND VPWR VPWR sky130_fd_sc_hd__fill_1
XFILLER_111_809 VGND VGND VPWR VPWR sky130_fd_sc_hd__fill_2
X_12092_ net437 net421 net598 net589 VGND VGND VPWR VPWR _05064_ sky130_fd_sc_hd__and4_1
X_11112_ _03942_ _03997_ VGND VGND VPWR VPWR _03998_ sky130_fd_sc_hd__xnor2_1
XFILLER_122_179 VGND VGND VPWR VPWR sky130_fd_sc_hd__fill_1
XFILLER_89_561 VGND VGND VPWR VPWR sky130_fd_sc_hd__decap_8
XFILLER_77_723 VGND VGND VPWR VPWR sky130_fd_sc_hd__decap_4
X_11043_ _03754_ _03756_ VGND VGND VPWR VPWR _03922_ sky130_fd_sc_hd__and2_1
XFILLER_103_393 VPWR VGND VPWR VGND sky130_ef_sc_hd__decap_12
XFILLER_91_225 VGND VGND VPWR VPWR sky130_fd_sc_hd__decap_3
X_12994_ _06047_ _06048_ VGND VGND VPWR VPWR _06049_ sky130_fd_sc_hd__nand2_1
XFILLER_36_119 VPWR VGND VPWR VGND sky130_ef_sc_hd__decap_12
XFILLER_91_247 VPWR VGND VPWR VGND sky130_ef_sc_hd__decap_12
XFILLER_55_50 VGND VGND VPWR VPWR sky130_fd_sc_hd__fill_1
X_11945_ net508 net107 _04635_ _04726_ VGND VGND VPWR VPWR _04903_ sky130_fd_sc_hd__a31o_1
XTAP_TAPCELL_ROW_15_501 VGND VPWR sky130_fd_sc_hd__tapvpwrvgnd_1
X_11876_ _04713_ _04826_ _04827_ VGND VGND VPWR VPWR _04828_ sky130_fd_sc_hd__and3_4
XFILLER_60_634 VGND VGND VPWR VPWR sky130_fd_sc_hd__decap_3
XFILLER_60_645 VGND VGND VPWR VPWR sky130_fd_sc_hd__fill_1
X_10827_ _03502_ _03684_ _03685_ VGND VGND VPWR VPWR _03687_ sky130_fd_sc_hd__and3_4
XFILLER_13_561 VGND VGND VPWR VPWR sky130_fd_sc_hd__decap_6
XTAP_TAPCELL_ROW_43_898 VGND VPWR sky130_fd_sc_hd__tapvpwrvgnd_1
X_10758_ net409 net401 net577 net575 VGND VGND VPWR VPWR _03611_ sky130_fd_sc_hd__nand4_1
XFILLER_72_6 VGND VGND VPWR VPWR sky130_fd_sc_hd__fill_1
XFILLER_40_391 VGND VGND VPWR VPWR sky130_fd_sc_hd__fill_1
XTAP_TAPCELL_ROW_97_1650 VGND VPWR sky130_fd_sc_hd__tapvpwrvgnd_1
X_10689_ _03533_ _03534_ VGND VGND VPWR VPWR _03535_ sky130_fd_sc_hd__nand2b_1
X_12428_ _05425_ _05430_ VGND VGND VPWR VPWR _05431_ sky130_fd_sc_hd__and2_1
XFILLER_99_314 VGND VGND VPWR VPWR sky130_fd_sc_hd__decap_3
X_12359_ _05337_ _05354_ VGND VGND VPWR VPWR _05355_ sky130_fd_sc_hd__xor2_1
X_06920_ _04632_ _04600_ _04643_ VGND VGND VPWR VPWR _04654_ sky130_fd_sc_hd__or3_4
XFILLER_67_200 VGND VGND VPWR VPWR sky130_fd_sc_hd__decap_4
XFILLER_68_734 VPWR VGND VPWR VGND sky130_ef_sc_hd__decap_12
X_06851_ _03882_ _03893_ VGND VGND VPWR VPWR _03904_ sky130_fd_sc_hd__and2b_1
XFILLER_95_575 VPWR VGND VPWR VGND sky130_ef_sc_hd__decap_12
XTAP_TAPCELL_ROW_124_2035 VGND VPWR sky130_fd_sc_hd__tapvpwrvgnd_1
XTAP_TAPCELL_ROW_124_2024 VGND VPWR sky130_fd_sc_hd__tapvpwrvgnd_1
X_06782_ _03031_ _03129_ VGND VGND VPWR VPWR _03151_ sky130_fd_sc_hd__and2_1
XFILLER_82_225 VPWR VGND VPWR VGND sky130_ef_sc_hd__decap_12
X_09570_ _02190_ _02209_ _02189_ VGND VGND VPWR VPWR _02320_ sky130_fd_sc_hd__a21oi_1
XFILLER_55_417 VPWR VGND VPWR VGND sky130_ef_sc_hd__decap_12
X_08521_ _01249_ VGND VGND VPWR VPWR _01250_ sky130_fd_sc_hd__inv_2
XFILLER_82_269 VGND VGND VPWR VPWR sky130_fd_sc_hd__fill_1
X_08452_ net621 net265 net263 net644 VGND VGND VPWR VPWR _01181_ sky130_fd_sc_hd__a22oi_1
XFILLER_63_461 VGND VGND VPWR VPWR sky130_fd_sc_hd__decap_4
XFILLER_51_612 VGND VGND VPWR VPWR sky130_fd_sc_hd__decap_4
XFILLER_35_174 VGND VGND VPWR VPWR sky130_fd_sc_hd__decap_8
X_07403_ net322 net320 net543 VGND VGND VPWR VPWR _00144_ sky130_fd_sc_hd__nand3_1
XFILLER_90_280 VGND VGND VPWR VPWR sky130_fd_sc_hd__fill_2
XFILLER_50_122 VGND VGND VPWR VPWR sky130_fd_sc_hd__fill_1
X_08383_ _01105_ _01112_ VGND VGND VPWR VPWR _01114_ sky130_fd_sc_hd__or2_1
X_07334_ _06464_ _06466_ _06465_ VGND VGND VPWR VPWR _06625_ sky130_fd_sc_hd__o21bai_1
X_07265_ _06409_ _06555_ VGND VGND VPWR VPWR _06556_ sky130_fd_sc_hd__xnor2_1
XFILLER_31_391 VGND VGND VPWR VPWR sky130_fd_sc_hd__fill_1
X_09004_ _01727_ _01728_ VGND VGND VPWR VPWR _01730_ sky130_fd_sc_hd__xor2_2
XTAP_TAPCELL_ROW_135_2186 VGND VPWR sky130_fd_sc_hd__tapvpwrvgnd_1
XFILLER_117_463 VGND VGND VPWR VPWR sky130_fd_sc_hd__fill_1
XFILLER_105_603 VGND VGND VPWR VPWR sky130_fd_sc_hd__fill_1
X_07196_ _06485_ _06486_ _06117_ _06139_ VGND VGND VPWR VPWR _06488_ sky130_fd_sc_hd__a211o_4
XFILLER_105_636 VGND VGND VPWR VPWR sky130_fd_sc_hd__fill_2
XFILLER_105_658 VGND VGND VPWR VPWR sky130_fd_sc_hd__fill_2
XFILLER_132_477 VPWR VGND VPWR VGND sky130_ef_sc_hd__decap_12
X_09906_ _02683_ _02684_ VGND VGND VPWR VPWR _02685_ sky130_fd_sc_hd__nor2_1
XFILLER_120_617 VPWR VGND VPWR VGND sky130_ef_sc_hd__decap_12
Xfanout511 net20 VGND VGND VPWR VPWR net511 sky130_fd_sc_hd__buf_4
Xfanout500 net21 VGND VGND VPWR VPWR net500 sky130_fd_sc_hd__dlymetal6s2s_1
Xfanout522 net525 VGND VGND VPWR VPWR net522 sky130_fd_sc_hd__clkbuf_4
Xfanout533 net17 VGND VGND VPWR VPWR net533 sky130_fd_sc_hd__clkbuf_4
Xfanout544 net545 VGND VGND VPWR VPWR net544 sky130_fd_sc_hd__clkbuf_4
Xfanout555 net155 VGND VGND VPWR VPWR net555 sky130_fd_sc_hd__buf_2
XFILLER_76_49 VGND VGND VPWR VPWR sky130_fd_sc_hd__fill_1
XFILLER_58_233 VGND VGND VPWR VPWR sky130_fd_sc_hd__fill_2
Xfanout566 net569 VGND VGND VPWR VPWR net566 sky130_fd_sc_hd__clkbuf_2
X_09837_ _02574_ _02609_ VGND VGND VPWR VPWR _02611_ sky130_fd_sc_hd__xnor2_1
XTAP_TAPCELL_ROW_109_1819 VGND VPWR sky130_fd_sc_hd__tapvpwrvgnd_1
XFILLER_59_767 VGND VGND VPWR VPWR sky130_fd_sc_hd__decap_8
Xfanout577 net147 VGND VGND VPWR VPWR net577 sky130_fd_sc_hd__clkbuf_4
Xfanout599 net139 VGND VGND VPWR VPWR net599 sky130_fd_sc_hd__clkbuf_4
Xfanout588 net140 VGND VGND VPWR VPWR net588 sky130_fd_sc_hd__clkbuf_4
X_09768_ _02532_ _02534_ VGND VGND VPWR VPWR _02535_ sky130_fd_sc_hd__and2_1
XFILLER_73_214 VGND VGND VPWR VPWR sky130_fd_sc_hd__decap_4
XFILLER_132_77 VGND VGND VPWR VPWR sky130_fd_sc_hd__decap_6
X_08719_ _01445_ _01446_ VGND VGND VPWR VPWR _01447_ sky130_fd_sc_hd__and2_4
XFILLER_92_26 VGND VGND VPWR VPWR sky130_fd_sc_hd__fill_2
XTAP_TAPCELL_ROW_68_1240 VGND VPWR sky130_fd_sc_hd__tapvpwrvgnd_1
X_09699_ _02453_ _02459_ VGND VGND VPWR VPWR _02460_ sky130_fd_sc_hd__xnor2_1
XFILLER_92_59 VGND VGND VPWR VPWR sky130_fd_sc_hd__fill_1
XFILLER_92_37 VGND VGND VPWR VPWR sky130_fd_sc_hd__decap_3
Xrebuffer71 net767 VGND VGND VPWR VPWR net771 sky130_fd_sc_hd__buf_1
XTAP_TAPCELL_ROW_68_1251 VGND VPWR sky130_fd_sc_hd__tapvpwrvgnd_1
Xrebuffer82 _04794_ VGND VGND VPWR VPWR net782 sky130_fd_sc_hd__buf_1
X_11730_ _04666_ _04667_ VGND VGND VPWR VPWR _04668_ sky130_fd_sc_hd__or2_1
XFILLER_26_141 VGND VGND VPWR VPWR sky130_fd_sc_hd__decap_6
XFILLER_27_686 VPWR VGND VPWR VGND sky130_ef_sc_hd__decap_12
Xrebuffer93 net358 VGND VGND VPWR VPWR net793 sky130_fd_sc_hd__dlymetal6s4s_1
XFILLER_25_53 VGND VGND VPWR VPWR sky130_fd_sc_hd__decap_3
XFILLER_26_185 VGND VGND VPWR VPWR sky130_fd_sc_hd__decap_4
XFILLER_41_111 VGND VGND VPWR VPWR sky130_fd_sc_hd__fill_1
XFILLER_42_623 VGND VGND VPWR VPWR sky130_fd_sc_hd__decap_4
XFILLER_42_645 VPWR VGND VPWR VGND sky130_ef_sc_hd__decap_12
X_11661_ net529 net677 VGND VGND VPWR VPWR _04594_ sky130_fd_sc_hd__nand2_1
XFILLER_14_369 VGND VGND VPWR VPWR sky130_fd_sc_hd__fill_1
XFILLER_25_64 VGND VGND VPWR VPWR sky130_fd_sc_hd__fill_1
XFILLER_30_807 VGND VGND VPWR VPWR sky130_fd_sc_hd__fill_1
X_11592_ _04519_ _04520_ _04518_ VGND VGND VPWR VPWR _04521_ sky130_fd_sc_hd__o21ai_2
XFILLER_10_520 VGND VGND VPWR VPWR sky130_fd_sc_hd__fill_1
X_13400_ clknet_3_1__leaf_clk _00017_ _00110_ VGND VGND VPWR VPWR net199 sky130_fd_sc_hd__dfrtp_1
X_10612_ net337 net52 net349 net356 VGND VGND VPWR VPWR _03451_ sky130_fd_sc_hd__a22o_1
X_10543_ _03072_ _03075_ _03214_ _03213_ _03203_ VGND VGND VPWR VPWR _03375_ sky130_fd_sc_hd__a32o_1
X_13331_ net392 VGND VGND VPWR VPWR _00105_ sky130_fd_sc_hd__inv_2
XTAP_TAPCELL_ROW_40_857 VGND VPWR sky130_fd_sc_hd__tapvpwrvgnd_1
XFILLER_10_586 VGND VGND VPWR VPWR sky130_fd_sc_hd__fill_2
XFILLER_6_513 VPWR VGND VPWR VGND sky130_ef_sc_hd__decap_12
Xrebuffer183 _01902_ VGND VGND VPWR VPWR net883 sky130_fd_sc_hd__buf_1
X_10474_ _03297_ _03298_ _03289_ VGND VGND VPWR VPWR _03300_ sky130_fd_sc_hd__a21o_1
XFILLER_6_557 VPWR VGND VPWR VGND sky130_ef_sc_hd__decap_12
X_13262_ _06338_ _06339_ VGND VGND VPWR VPWR _06340_ sky130_fd_sc_hd__xnor2_1
XTAP_TAPCELL_ROW_20_570 VGND VPWR sky130_fd_sc_hd__tapvpwrvgnd_1
XTAP_TAPCELL_ROW_20_581 VGND VPWR sky130_fd_sc_hd__tapvpwrvgnd_1
XFILLER_108_485 VPWR VGND VPWR VGND sky130_ef_sc_hd__decap_12
X_13193_ _06244_ _06265_ VGND VGND VPWR VPWR _06266_ sky130_fd_sc_hd__xor2_1
X_12213_ net480 net677 VGND VGND VPWR VPWR _05195_ sky130_fd_sc_hd__nand2_4
XFILLER_135_293 VPWR VGND VPWR VGND sky130_ef_sc_hd__decap_12
XFILLER_97_807 VGND VGND VPWR VPWR sky130_fd_sc_hd__fill_1
X_12144_ _05118_ _05117_ _04967_ _04969_ VGND VGND VPWR VPWR _05120_ sky130_fd_sc_hd__a211o_1
XFILLER_123_488 VPWR VGND VPWR VGND sky130_ef_sc_hd__decap_12
XFILLER_111_617 VGND VGND VPWR VPWR sky130_fd_sc_hd__decap_4
XFILLER_96_317 VGND VGND VPWR VPWR sky130_fd_sc_hd__fill_2
XTAP_TAPCELL_ROW_92_1580 VGND VPWR sky130_fd_sc_hd__tapvpwrvgnd_1
XFILLER_110_138 VGND VGND VPWR VPWR sky130_fd_sc_hd__fill_2
X_12075_ _05043_ _05044_ VGND VGND VPWR VPWR _05045_ sky130_fd_sc_hd__or2_1
XFILLER_49_233 VPWR VGND VPWR VGND sky130_ef_sc_hd__decap_12
XFILLER_1_273 VGND VGND VPWR VPWR sky130_fd_sc_hd__decap_6
X_11026_ _03867_ _03902_ VGND VGND VPWR VPWR _03903_ sky130_fd_sc_hd__nand2b_1
XFILLER_66_82 VGND VGND VPWR VPWR sky130_fd_sc_hd__fill_2
XTAP_TAPCELL_ROW_48_968 VGND VPWR sky130_fd_sc_hd__tapvpwrvgnd_1
XFILLER_92_578 VGND VGND VPWR VPWR sky130_fd_sc_hd__decap_8
XFILLER_18_675 VPWR VGND VPWR VGND sky130_ef_sc_hd__decap_12
X_12977_ _06007_ _06028_ VGND VGND VPWR VPWR _06031_ sky130_fd_sc_hd__xor2_1
X_11928_ _04884_ _04856_ VGND VGND VPWR VPWR _04885_ sky130_fd_sc_hd__and2b_1
XFILLER_17_185 VGND VGND VPWR VPWR sky130_fd_sc_hd__fill_1
XTAP_TAPCELL_ROW_28_681 VGND VPWR sky130_fd_sc_hd__tapvpwrvgnd_1
XTAP_TAPCELL_ROW_28_692 VGND VPWR sky130_fd_sc_hd__tapvpwrvgnd_1
XFILLER_82_81 VGND VGND VPWR VPWR sky130_fd_sc_hd__decap_3
X_11859_ _04795_ _04804_ _04624_ VGND VGND VPWR VPWR _04810_ sky130_fd_sc_hd__a21oi_1
XFILLER_32_133 VGND VGND VPWR VPWR sky130_fd_sc_hd__decap_6
XANTENNA_29 clknet_3_6__leaf_clk VGND VGND VPWR VPWR sky130_fd_sc_hd__diode_2
XFILLER_20_339 VGND VGND VPWR VPWR sky130_fd_sc_hd__decap_3
XANTENNA_18 net32 VGND VGND VPWR VPWR sky130_fd_sc_hd__diode_2
XFILLER_118_205 VGND VGND VPWR VPWR sky130_fd_sc_hd__fill_2
X_07050_ _04439_ _04417_ _06041_ net938 VGND VGND VPWR VPWR _06074_ sky130_fd_sc_hd__a211oi_4
XFILLER_9_373 VPWR VGND VPWR VGND sky130_ef_sc_hd__decap_12
XFILLER_127_783 VGND VGND VPWR VPWR sky130_fd_sc_hd__fill_1
XFILLER_99_111 VGND VGND VPWR VPWR sky130_fd_sc_hd__fill_1
Xoutput169 net169 VGND VGND VPWR VPWR out0[1] sky130_fd_sc_hd__buf_2
XFILLER_102_606 VPWR VGND VPWR VGND sky130_ef_sc_hd__decap_12
X_07952_ _00507_ _00555_ _00554_ VGND VGND VPWR VPWR _00690_ sky130_fd_sc_hd__a21oi_1
X_06903_ _02781_ _04396_ _04461_ VGND VGND VPWR VPWR _04472_ sky130_fd_sc_hd__nand3_1
X_07883_ _00508_ _00620_ VGND VGND VPWR VPWR _00621_ sky130_fd_sc_hd__xor2_1
X_09622_ _02373_ _02374_ VGND VGND VPWR VPWR _02376_ sky130_fd_sc_hd__xnor2_1
X_06834_ net533 net681 VGND VGND VPWR VPWR _03718_ sky130_fd_sc_hd__nand2_1
XFILLER_83_501 VGND VGND VPWR VPWR sky130_fd_sc_hd__decap_3
XFILLER_56_737 VPWR VGND VPWR VGND sky130_ef_sc_hd__decap_12
X_09553_ _02174_ _02185_ _02173_ VGND VGND VPWR VPWR _02302_ sky130_fd_sc_hd__o21ai_2
XFILLER_71_707 VGND VGND VPWR VPWR sky130_fd_sc_hd__fill_1
X_06765_ _02566_ _02943_ VGND VGND VPWR VPWR _02965_ sky130_fd_sc_hd__xnor2_1
X_08504_ net464 net552 VGND VGND VPWR VPWR _01233_ sky130_fd_sc_hd__nand2_1
XFILLER_71_729 VGND VGND VPWR VPWR sky130_fd_sc_hd__fill_1
XFILLER_24_612 VGND VGND VPWR VPWR sky130_fd_sc_hd__decap_8
X_09484_ _02224_ _02225_ VGND VGND VPWR VPWR _02227_ sky130_fd_sc_hd__xor2_1
XTAP_TAPCELL_ROW_104_1749 VGND VPWR sky130_fd_sc_hd__tapvpwrvgnd_1
XFILLER_102_58 VGND VGND VPWR VPWR sky130_fd_sc_hd__fill_2
X_06696_ net161 VGND VGND VPWR VPWR _02219_ sky130_fd_sc_hd__inv_2
X_08435_ _01162_ _01163_ _01121_ VGND VGND VPWR VPWR _01165_ sky130_fd_sc_hd__a21oi_1
XFILLER_62_29 VPWR VGND VPWR VGND sky130_ef_sc_hd__decap_12
XFILLER_23_133 VGND VGND VPWR VPWR sky130_fd_sc_hd__decap_3
X_08366_ _01096_ VGND VGND VPWR VPWR _01097_ sky130_fd_sc_hd__inv_2
XTAP_TAPCELL_ROW_63_1170 VGND VPWR sky130_fd_sc_hd__tapvpwrvgnd_1
X_07317_ net514 net382 _06461_ _06460_ VGND VGND VPWR VPWR _06608_ sky130_fd_sc_hd__a31o_1
XTAP_TAPCELL_ROW_63_1181 VGND VPWR sky130_fd_sc_hd__tapvpwrvgnd_1
X_08297_ _01030_ _01031_ VGND VGND VPWR VPWR _01032_ sky130_fd_sc_hd__nand2b_1
XFILLER_109_238 VGND VGND VPWR VPWR sky130_fd_sc_hd__decap_6
XFILLER_125_709 VPWR VGND VPWR VGND sky130_ef_sc_hd__decap_12
X_07248_ _06530_ _06537_ VGND VGND VPWR VPWR _06539_ sky130_fd_sc_hd__or2_1
X_07179_ _06467_ _06468_ _06469_ VGND VGND VPWR VPWR _06471_ sky130_fd_sc_hd__a21o_1
XFILLER_3_505 VPWR VGND VPWR VGND sky130_ef_sc_hd__decap_12
XFILLER_133_753 VPWR VGND VPWR VGND sky130_ef_sc_hd__decap_12
XFILLER_127_55 VGND VGND VPWR VPWR sky130_fd_sc_hd__fill_1
XFILLER_87_15 VPWR VGND VPWR VGND sky130_ef_sc_hd__decap_12
X_10190_ _02967_ _02989_ _02990_ VGND VGND VPWR VPWR _02991_ sky130_fd_sc_hd__or3_4
XFILLER_133_797 VPWR VGND VPWR VGND sky130_ef_sc_hd__decap_12
XFILLER_78_306 VGND VGND VPWR VPWR sky130_fd_sc_hd__fill_2
XFILLER_105_499 VGND VGND VPWR VPWR sky130_fd_sc_hd__decap_4
Xfanout341 net58 VGND VGND VPWR VPWR net341 sky130_fd_sc_hd__clkbuf_2
Xfanout330 net61 VGND VGND VPWR VPWR net330 sky130_fd_sc_hd__dlymetal6s2s_1
XFILLER_59_520 VGND VGND VPWR VPWR sky130_fd_sc_hd__decap_3
XFILLER_120_469 VGND VGND VPWR VPWR sky130_fd_sc_hd__fill_2
Xfanout374 net40 VGND VGND VPWR VPWR net374 sky130_fd_sc_hd__buf_2
Xfanout352 net50 VGND VGND VPWR VPWR net352 sky130_fd_sc_hd__clkbuf_4
XTAP_TAPCELL_ROW_6_376 VGND VPWR sky130_fd_sc_hd__tapvpwrvgnd_1
Xfanout363 net47 VGND VGND VPWR VPWR net363 sky130_fd_sc_hd__dlymetal6s2s_1
Xfanout385 net37 VGND VGND VPWR VPWR net385 sky130_fd_sc_hd__buf_2
Xfanout396 net397 VGND VGND VPWR VPWR net396 sky130_fd_sc_hd__buf_4
XFILLER_47_737 VGND VGND VPWR VPWR sky130_fd_sc_hd__fill_2
XFILLER_47_726 VGND VGND VPWR VPWR sky130_fd_sc_hd__fill_2
XFILLER_19_417 VGND VGND VPWR VPWR sky130_fd_sc_hd__decap_6
X_12900_ _05707_ _05800_ _05798_ VGND VGND VPWR VPWR _05947_ sky130_fd_sc_hd__a21oi_1
X_12831_ _05869_ _05870_ VGND VGND VPWR VPWR _05871_ sky130_fd_sc_hd__or2_1
XFILLER_74_589 VGND VGND VPWR VPWR sky130_fd_sc_hd__decap_4
XFILLER_61_206 VGND VGND VPWR VPWR sky130_fd_sc_hd__fill_2
XTAP_TAPCELL_ROW_45_927 VGND VPWR sky130_fd_sc_hd__tapvpwrvgnd_1
XFILLER_27_472 VGND VGND VPWR VPWR sky130_fd_sc_hd__fill_2
XFILLER_36_41 VGND VGND VPWR VPWR sky130_fd_sc_hd__decap_4
XFILLER_14_122 VGND VGND VPWR VPWR sky130_fd_sc_hd__fill_1
X_12762_ _05793_ _05794_ VGND VGND VPWR VPWR _05796_ sky130_fd_sc_hd__xor2_1
XFILLER_36_74 VGND VGND VPWR VPWR sky130_fd_sc_hd__fill_2
XFILLER_36_96 VGND VGND VPWR VPWR sky130_fd_sc_hd__decap_6
X_11713_ net666 net302 net300 net690 VGND VGND VPWR VPWR _04650_ sky130_fd_sc_hd__a22oi_1
XFILLER_54_291 VPWR VGND VPWR VGND sky130_ef_sc_hd__decap_12
XFILLER_15_656 VGND VGND VPWR VPWR sky130_fd_sc_hd__decap_3
XTAP_TAPCELL_ROW_25_640 VGND VPWR sky130_fd_sc_hd__tapvpwrvgnd_1
XTAP_TAPCELL_ROW_25_651 VGND VPWR sky130_fd_sc_hd__tapvpwrvgnd_1
X_12693_ _05552_ _05716_ _05718_ VGND VGND VPWR VPWR _05720_ sky130_fd_sc_hd__nor3_1
X_11644_ net534 net677 VGND VGND VPWR VPWR _04576_ sky130_fd_sc_hd__nand2_1
XFILLER_30_637 VGND VGND VPWR VPWR sky130_fd_sc_hd__decap_6
XFILLER_42_475 VGND VGND VPWR VPWR sky130_fd_sc_hd__fill_1
Xinput16 in1[7] VGND VGND VPWR VPWR net16 sky130_fd_sc_hd__buf_1
XFILLER_128_547 VGND VGND VPWR VPWR sky130_fd_sc_hd__decap_3
Xinput27 in3[2] VGND VGND VPWR VPWR net27 sky130_fd_sc_hd__buf_2
X_11575_ _04361_ _04397_ _04360_ VGND VGND VPWR VPWR _04503_ sky130_fd_sc_hd__a21bo_1
Xinput38 w00[4] VGND VGND VPWR VPWR net38 sky130_fd_sc_hd__buf_1
X_13314_ net396 VGND VGND VPWR VPWR _00088_ sky130_fd_sc_hd__inv_2
X_10526_ _03353_ _03354_ VGND VGND VPWR VPWR _03356_ sky130_fd_sc_hd__xnor2_1
XFILLER_6_321 VPWR VGND VPWR VGND sky130_ef_sc_hd__decap_12
Xinput49 w01[7] VGND VGND VPWR VPWR net49 sky130_fd_sc_hd__buf_1
XFILLER_115_208 VPWR VGND VPWR VGND sky130_ef_sc_hd__decap_12
XFILLER_6_365 VPWR VGND VPWR VGND sky130_ef_sc_hd__decap_12
X_13245_ _06304_ _06308_ _06302_ VGND VGND VPWR VPWR _06321_ sky130_fd_sc_hd__a21oi_1
X_10457_ _03279_ _03280_ VGND VGND VPWR VPWR _03282_ sky130_fd_sc_hd__nor2_1
XFILLER_69_317 VPWR VGND VPWR VGND sky130_ef_sc_hd__decap_12
X_10388_ net569 net282 net280 net591 VGND VGND VPWR VPWR _03207_ sky130_fd_sc_hd__a22o_1
X_13176_ _02175_ net113 _06134_ VGND VGND VPWR VPWR _06247_ sky130_fd_sc_hd__a21oi_1
XFILLER_96_114 VGND VGND VPWR VPWR sky130_fd_sc_hd__fill_1
X_12127_ _05098_ _05099_ _05100_ VGND VGND VPWR VPWR _05102_ sky130_fd_sc_hd__nand3_1
XFILLER_77_81 VGND VGND VPWR VPWR sky130_fd_sc_hd__decap_6
X_12058_ net534 net529 net661 net658 VGND VGND VPWR VPWR _05027_ sky130_fd_sc_hd__and4_1
XFILLER_77_372 VPWR VGND VPWR VGND sky130_ef_sc_hd__decap_12
X_11009_ _03883_ _03884_ VGND VGND VPWR VPWR _03885_ sky130_fd_sc_hd__nor2_1
XFILLER_92_353 VGND VGND VPWR VPWR sky130_fd_sc_hd__fill_1
XFILLER_80_537 VGND VGND VPWR VPWR sky130_fd_sc_hd__decap_8
X_08220_ _00838_ _00840_ _00852_ VGND VGND VPWR VPWR _00955_ sky130_fd_sc_hd__nor3_1
XFILLER_21_615 VGND VGND VPWR VPWR sky130_fd_sc_hd__fill_1
XFILLER_33_497 VGND VGND VPWR VPWR sky130_fd_sc_hd__decap_6
XFILLER_20_147 VGND VGND VPWR VPWR sky130_fd_sc_hd__decap_4
X_08151_ _00747_ _00773_ _00746_ VGND VGND VPWR VPWR _00887_ sky130_fd_sc_hd__a21boi_2
X_08082_ _00816_ _00817_ VGND VGND VPWR VPWR _00819_ sky130_fd_sc_hd__xor2_1
X_07102_ _03773_ _05265_ _03500_ VGND VGND VPWR VPWR _06394_ sky130_fd_sc_hd__o21a_1
XTAP_TAPCELL_ROW_132_2145 VGND VPWR sky130_fd_sc_hd__tapvpwrvgnd_1
X_07033_ net36 net767 VGND VGND VPWR VPWR _05888_ sky130_fd_sc_hd__nand2_1
XFILLER_130_701 VPWR VGND VPWR VGND sky130_ef_sc_hd__decap_12
XFILLER_115_797 VPWR VGND VPWR VGND sky130_ef_sc_hd__decap_12
XFILLER_114_296 VPWR VGND VPWR VGND sky130_ef_sc_hd__decap_12
X_08984_ _01708_ _01709_ VGND VGND VPWR VPWR _01710_ sky130_fd_sc_hd__nor2_1
XFILLER_102_469 VGND VGND VPWR VPWR sky130_fd_sc_hd__decap_6
X_07935_ net444 _00184_ _00186_ _00496_ VGND VGND VPWR VPWR _00673_ sky130_fd_sc_hd__a2bb2o_1
XFILLER_87_169 VGND VGND VPWR VPWR sky130_fd_sc_hd__fill_1
XTAP_TAPCELL_ROW_3_335 VGND VPWR sky130_fd_sc_hd__tapvpwrvgnd_1
X_09605_ _02355_ _02356_ VGND VGND VPWR VPWR _02358_ sky130_fd_sc_hd__xnor2_2
X_07866_ _00599_ _00603_ VGND VGND VPWR VPWR _00604_ sky130_fd_sc_hd__nand2b_1
XFILLER_83_320 VGND VGND VPWR VPWR sky130_fd_sc_hd__decap_4
X_06817_ _03042_ _03074_ _03521_ VGND VGND VPWR VPWR _03532_ sky130_fd_sc_hd__o21a_1
XFILLER_113_57 VGND VGND VPWR VPWR sky130_fd_sc_hd__decap_6
X_07797_ net605 net418 net603 net410 VGND VGND VPWR VPWR _00536_ sky130_fd_sc_hd__and4_1
XFILLER_83_386 VGND VGND VPWR VPWR sky130_fd_sc_hd__decap_6
X_06748_ _02424_ _02772_ VGND VGND VPWR VPWR _02781_ sky130_fd_sc_hd__and2_1
X_09536_ net326 _02281_ VGND VGND VPWR VPWR _02283_ sky130_fd_sc_hd__and2_1
XTAP_TAPCELL_ROW_65_1210 VGND VPWR sky130_fd_sc_hd__tapvpwrvgnd_1
X_09467_ _02191_ _02207_ VGND VGND VPWR VPWR _02209_ sky130_fd_sc_hd__xor2_2
XFILLER_24_442 VGND VGND VPWR VPWR sky130_fd_sc_hd__decap_8
X_08418_ _01146_ _01147_ VGND VGND VPWR VPWR _01148_ sky130_fd_sc_hd__and2_1
X_06679_ net387 VGND VGND VPWR VPWR _02033_ sky130_fd_sc_hd__inv_2
X_09398_ _02130_ _02132_ VGND VGND VPWR VPWR _02133_ sky130_fd_sc_hd__nand2b_1
XFILLER_11_125 VPWR VGND VPWR VGND sky130_ef_sc_hd__decap_12
XFILLER_8_608 VPWR VGND VPWR VGND sky130_ef_sc_hd__decap_12
X_08349_ _01037_ _01082_ VGND VGND VPWR VPWR _01083_ sky130_fd_sc_hd__xnor2_1
XPHY_EDGE_ROW_129_Right_129 VGND VGND VPWR VPWR sky130_fd_sc_hd__decap_3
XTAP_TAPCELL_ROW_117_1929 VGND VPWR sky130_fd_sc_hd__tapvpwrvgnd_1
XTAP_TAPCELL_ROW_50_996 VGND VPWR sky130_fd_sc_hd__tapvpwrvgnd_1
X_11360_ _04253_ _04268_ VGND VGND VPWR VPWR _04269_ sky130_fd_sc_hd__xnor2_1
XFILLER_118_3 VPWR VGND VPWR VGND sky130_ef_sc_hd__decap_12
X_10311_ _03120_ _03121_ _03122_ VGND VGND VPWR VPWR _03123_ sky130_fd_sc_hd__and3_1
XFILLER_98_58 VGND VGND VPWR VPWR sky130_fd_sc_hd__decap_3
XTAP_TAPCELL_ROW_76_1361 VGND VPWR sky130_fd_sc_hd__tapvpwrvgnd_1
XFILLER_3_335 VGND VGND VPWR VPWR sky130_fd_sc_hd__fill_1
X_11291_ net408 net559 _04192_ VGND VGND VPWR VPWR _04193_ sky130_fd_sc_hd__a21o_1
X_13030_ _06086_ _06087_ VGND VGND VPWR VPWR _06089_ sky130_fd_sc_hd__and2_1
XFILLER_133_561 VPWR VGND VPWR VGND sky130_ef_sc_hd__decap_12
X_10242_ _02852_ _02863_ net226 _03047_ VGND VGND VPWR VPWR _03048_ sky130_fd_sc_hd__a211o_4
XFILLER_0_3 VPWR VGND VPWR VGND sky130_ef_sc_hd__decap_12
XFILLER_79_648 VGND VGND VPWR VPWR sky130_fd_sc_hd__decap_6
X_10173_ net354 net376 net353 net351 VGND VGND VPWR VPWR _02972_ sky130_fd_sc_hd__and4_1
XFILLER_66_309 VPWR VGND VPWR VGND sky130_ef_sc_hd__decap_12
XFILLER_87_681 VPWR VGND VPWR VGND sky130_ef_sc_hd__decap_12
XFILLER_87_670 VGND VGND VPWR VPWR sky130_fd_sc_hd__fill_2
XFILLER_59_372 VGND VGND VPWR VPWR sky130_fd_sc_hd__fill_1
XFILLER_47_523 VGND VGND VPWR VPWR sky130_fd_sc_hd__fill_2
XFILLER_47_501 VGND VGND VPWR VPWR sky130_fd_sc_hd__decap_3
XFILLER_19_225 VGND VGND VPWR VPWR sky130_fd_sc_hd__decap_4
XFILLER_90_802 VGND VGND VPWR VPWR sky130_fd_sc_hd__decap_6
XFILLER_47_567 VGND VGND VPWR VPWR sky130_fd_sc_hd__decap_4
XFILLER_35_718 VGND VGND VPWR VPWR sky130_fd_sc_hd__decap_8
XFILLER_35_729 VPWR VGND VPWR VGND sky130_ef_sc_hd__decap_12
XFILLER_62_537 VGND VGND VPWR VPWR sky130_fd_sc_hd__decap_8
X_12814_ _05843_ _05851_ VGND VGND VPWR VPWR _05852_ sky130_fd_sc_hd__xnor2_1
XFILLER_28_792 VPWR VGND VPWR VGND sky130_ef_sc_hd__decap_12
X_12745_ _05774_ _05775_ net440 net581 VGND VGND VPWR VPWR _05777_ sky130_fd_sc_hd__and4bb_1
XFILLER_43_773 VGND VGND VPWR VPWR sky130_fd_sc_hd__decap_8
XFILLER_15_486 VPWR VGND VPWR VGND sky130_ef_sc_hd__decap_12
X_12676_ _05685_ _05700_ VGND VGND VPWR VPWR _05701_ sky130_fd_sc_hd__xor2_1
X_11627_ _04431_ _04438_ _04430_ VGND VGND VPWR VPWR _04560_ sky130_fd_sc_hd__a21o_1
XFILLER_30_489 VPWR VGND VPWR VGND sky130_ef_sc_hd__decap_12
XFILLER_11_681 VGND VGND VPWR VPWR sky130_fd_sc_hd__fill_2
XFILLER_7_641 VPWR VGND VPWR VGND sky130_ef_sc_hd__decap_12
X_11558_ net247 _04211_ _04336_ VGND VGND VPWR VPWR _04485_ sky130_fd_sc_hd__or3_1
X_10509_ net686 net663 net274 net273 VGND VGND VPWR VPWR _03338_ sky130_fd_sc_hd__and4_1
XFILLER_7_685 VPWR VGND VPWR VGND sky130_ef_sc_hd__decap_12
XFILLER_6_195 VGND VGND VPWR VPWR sky130_fd_sc_hd__fill_1
X_11489_ _04406_ _04408_ VGND VGND VPWR VPWR _04410_ sky130_fd_sc_hd__xnor2_1
X_13228_ _06042_ _06176_ _06175_ VGND VGND VPWR VPWR _06305_ sky130_fd_sc_hd__a21oi_1
XFILLER_97_434 VGND VGND VPWR VPWR sky130_fd_sc_hd__fill_1
XFILLER_97_412 VGND VGND VPWR VPWR sky130_fd_sc_hd__decap_8
X_13159_ _06220_ _06228_ VGND VGND VPWR VPWR _06229_ sky130_fd_sc_hd__xnor2_1
XFILLER_111_244 VPWR VGND VPWR VGND sky130_ef_sc_hd__decap_12
XFILLER_111_222 VGND VGND VPWR VPWR sky130_fd_sc_hd__fill_2
X_07720_ _00143_ _00147_ VGND VGND VPWR VPWR _00459_ sky130_fd_sc_hd__or2_2
XFILLER_69_169 VGND VGND VPWR VPWR sky130_fd_sc_hd__decap_4
XFILLER_66_810 VGND VGND VPWR VPWR sky130_fd_sc_hd__fill_1
XFILLER_84_139 VGND VGND VPWR VPWR sky130_fd_sc_hd__fill_1
XFILLER_65_331 VGND VGND VPWR VPWR sky130_fd_sc_hd__decap_4
X_07651_ _00388_ _00389_ _00382_ VGND VGND VPWR VPWR _00391_ sky130_fd_sc_hd__a21oi_1
X_07582_ _00287_ _00321_ VGND VGND VPWR VPWR _00322_ sky130_fd_sc_hd__nand2_1
XFILLER_65_386 VGND VGND VPWR VPWR sky130_fd_sc_hd__decap_6
X_09321_ _02039_ _02048_ VGND VGND VPWR VPWR _02049_ sky130_fd_sc_hd__xor2_1
XFILLER_53_559 VGND VGND VPWR VPWR sky130_fd_sc_hd__fill_1
XFILLER_34_762 VGND VGND VPWR VPWR sky130_fd_sc_hd__fill_2
XTAP_TAPCELL_ROW_101_1708 VGND VPWR sky130_fd_sc_hd__tapvpwrvgnd_1
XFILLER_40_209 VGND VGND VPWR VPWR sky130_fd_sc_hd__decap_4
X_09252_ _01975_ VGND VGND VPWR VPWR _01976_ sky130_fd_sc_hd__inv_2
X_08203_ _00937_ _00938_ VGND VGND VPWR VPWR _00939_ sky130_fd_sc_hd__nand2_1
X_09183_ _01741_ _01739_ _01906_ _01907_ VGND VGND VPWR VPWR _01908_ sky130_fd_sc_hd__a211oi_4
XTAP_TAPCELL_ROW_60_1140 VGND VPWR sky130_fd_sc_hd__tapvpwrvgnd_1
X_08134_ net410 _00737_ _00733_ VGND VGND VPWR VPWR _00870_ sky130_fd_sc_hd__a21oi_1
XFILLER_119_388 VGND VGND VPWR VPWR sky130_fd_sc_hd__decap_4
XFILLER_119_366 VPWR VGND VPWR VGND sky130_ef_sc_hd__decap_12
X_08065_ _00801_ _00793_ VGND VGND VPWR VPWR _00802_ sky130_fd_sc_hd__nand2b_1
XFILLER_104_9 VGND VGND VPWR VPWR sky130_fd_sc_hd__decap_8
XFILLER_122_509 VGND VGND VPWR VPWR sky130_fd_sc_hd__decap_3
XFILLER_115_561 VPWR VGND VPWR VGND sky130_ef_sc_hd__decap_12
XFILLER_103_701 VPWR VGND VPWR VGND sky130_ef_sc_hd__decap_12
X_07016_ _05669_ _05680_ _05691_ VGND VGND VPWR VPWR _05702_ sky130_fd_sc_hd__or3_1
XTAP_TAPCELL_ROW_8_405 VGND VPWR sky130_fd_sc_hd__tapvpwrvgnd_1
XTAP_TAPCELL_ROW_112_1859 VGND VPWR sky130_fd_sc_hd__tapvpwrvgnd_1
XFILLER_130_531 VGND VGND VPWR VPWR sky130_fd_sc_hd__fill_1
XFILLER_88_467 VGND VGND VPWR VPWR sky130_fd_sc_hd__decap_3
XFILLER_0_349 VPWR VGND VPWR VGND sky130_ef_sc_hd__decap_12
XFILLER_102_277 VGND VGND VPWR VPWR sky130_fd_sc_hd__decap_8
X_08967_ _01691_ _01692_ VGND VGND VPWR VPWR _01693_ sky130_fd_sc_hd__nand2_1
XTAP_TAPCELL_ROW_71_1291 VGND VPWR sky130_fd_sc_hd__tapvpwrvgnd_1
X_08898_ _01622_ _01623_ VGND VGND VPWR VPWR _01624_ sky130_fd_sc_hd__xor2_1
XFILLER_84_27 VGND VGND VPWR VPWR sky130_fd_sc_hd__fill_1
X_07918_ _00654_ _00655_ VGND VGND VPWR VPWR _00656_ sky130_fd_sc_hd__nand2_1
XFILLER_68_191 VGND VGND VPWR VPWR sky130_fd_sc_hd__decap_4
XFILLER_56_331 VPWR VGND VPWR VGND sky130_ef_sc_hd__decap_12
X_07849_ _00584_ _00585_ VGND VGND VPWR VPWR _00587_ sky130_fd_sc_hd__xnor2_1
XFILLER_17_729 VGND VGND VPWR VPWR sky130_fd_sc_hd__fill_2
XFILLER_71_301 VGND VGND VPWR VPWR sky130_fd_sc_hd__fill_2
XFILLER_56_397 VPWR VGND VPWR VGND sky130_ef_sc_hd__decap_12
XFILLER_44_526 VGND VGND VPWR VPWR sky130_fd_sc_hd__decap_6
X_10860_ _02022_ net635 _03569_ _03568_ VGND VGND VPWR VPWR _03722_ sky130_fd_sc_hd__a31o_1
X_09519_ _01949_ _02264_ VGND VGND VPWR VPWR _02265_ sky130_fd_sc_hd__xnor2_1
XFILLER_71_356 VGND VGND VPWR VPWR sky130_fd_sc_hd__decap_8
XFILLER_25_773 VGND VGND VPWR VPWR sky130_fd_sc_hd__decap_8
X_10791_ net375 net344 VGND VGND VPWR VPWR _03647_ sky130_fd_sc_hd__nand2_1
XFILLER_40_721 VGND VGND VPWR VPWR sky130_fd_sc_hd__decap_4
XFILLER_12_434 VGND VGND VPWR VPWR sky130_fd_sc_hd__fill_2
XFILLER_33_20 VPWR VGND VPWR VGND sky130_ef_sc_hd__decap_12
XTAP_TAPCELL_ROW_35_790 VGND VPWR sky130_fd_sc_hd__tapvpwrvgnd_1
XFILLER_40_754 VGND VGND VPWR VPWR sky130_fd_sc_hd__fill_2
X_12530_ _05496_ _05540_ VGND VGND VPWR VPWR _05542_ sky130_fd_sc_hd__xnor2_1
X_12461_ _05463_ _05465_ _05402_ VGND VGND VPWR VPWR _05467_ sky130_fd_sc_hd__a21oi_1
XFILLER_40_765 VGND VGND VPWR VPWR sky130_fd_sc_hd__decap_4
XFILLER_12_489 VGND VGND VPWR VPWR sky130_fd_sc_hd__decap_3
X_11412_ _04315_ _04324_ VGND VGND VPWR VPWR _04325_ sky130_fd_sc_hd__and2b_1
X_12392_ _05383_ _05390_ VGND VGND VPWR VPWR _05391_ sky130_fd_sc_hd__and2_1
X_11343_ _04032_ _04040_ _04249_ VGND VGND VPWR VPWR _04250_ sky130_fd_sc_hd__a21o_1
X_11274_ net308 net343 _02240_ net331 VGND VGND VPWR VPWR _04174_ sky130_fd_sc_hd__o2bb2a_1
X_10225_ _03026_ _03027_ _03028_ VGND VGND VPWR VPWR _03029_ sky130_fd_sc_hd__nor3_1
XFILLER_4_699 VGND VGND VPWR VPWR sky130_fd_sc_hd__fill_1
X_13013_ _06055_ _06069_ VGND VGND VPWR VPWR _06070_ sky130_fd_sc_hd__xnor2_1
XFILLER_94_415 VGND VGND VPWR VPWR sky130_fd_sc_hd__decap_4
XFILLER_58_83 VGND VGND VPWR VPWR sky130_fd_sc_hd__fill_1
X_10156_ _02950_ _02952_ VGND VGND VPWR VPWR _02953_ sky130_fd_sc_hd__nor2_1
XTAP_TAPCELL_ROW_89_1541 VGND VPWR sky130_fd_sc_hd__tapvpwrvgnd_1
X_10087_ _02800_ _02842_ _02844_ _02876_ VGND VGND VPWR VPWR _02878_ sky130_fd_sc_hd__o211ai_1
XFILLER_47_331 VGND VGND VPWR VPWR sky130_fd_sc_hd__decap_4
XFILLER_81_109 VGND VGND VPWR VPWR sky130_fd_sc_hd__decap_3
XFILLER_74_161 VGND VGND VPWR VPWR sky130_fd_sc_hd__fill_1
XFILLER_90_643 VGND VGND VPWR VPWR sky130_fd_sc_hd__fill_1
XFILLER_62_389 VPWR VGND VPWR VGND sky130_ef_sc_hd__decap_12
X_10989_ _03738_ _03741_ _03862_ VGND VGND VPWR VPWR _03863_ sky130_fd_sc_hd__a21oi_2
X_12728_ net359 net361 VGND VGND VPWR VPWR _05759_ sky130_fd_sc_hd__nand2_1
XFILLER_30_253 VGND VGND VPWR VPWR sky130_fd_sc_hd__fill_1
X_12659_ _05504_ _05510_ _05681_ VGND VGND VPWR VPWR _05683_ sky130_fd_sc_hd__and3_1
XFILLER_129_653 VPWR VGND VPWR VGND sky130_ef_sc_hd__decap_12
XTAP_TAPCELL_ROW_13_473 VGND VPWR sky130_fd_sc_hd__tapvpwrvgnd_1
XFILLER_30_297 VGND VGND VPWR VPWR sky130_fd_sc_hd__fill_1
XFILLER_128_141 VPWR VGND VPWR VGND sky130_ef_sc_hd__decap_12
XFILLER_129_697 VPWR VGND VPWR VGND sky130_ef_sc_hd__decap_12
XFILLER_98_732 VGND VGND VPWR VPWR sky130_fd_sc_hd__decap_4
X_09870_ _02525_ _02537_ _02523_ VGND VGND VPWR VPWR _02646_ sky130_fd_sc_hd__a21oi_1
XFILLER_124_380 VPWR VGND VPWR VGND sky130_ef_sc_hd__decap_12
XFILLER_112_542 VGND VGND VPWR VPWR sky130_fd_sc_hd__fill_1
X_08821_ net735 net330 net328 net430 VGND VGND VPWR VPWR _01548_ sky130_fd_sc_hd__a22o_1
XFILLER_100_726 VPWR VGND VPWR VGND sky130_ef_sc_hd__decap_12
X_08752_ _01477_ _01478_ VGND VGND VPWR VPWR _01479_ sky130_fd_sc_hd__and2_1
XTAP_TAPCELL_ROW_127_2077 VGND VPWR sky130_fd_sc_hd__tapvpwrvgnd_1
XTAP_TAPCELL_ROW_127_2066 VGND VPWR sky130_fd_sc_hd__tapvpwrvgnd_1
X_07703_ net570 _00440_ _00441_ VGND VGND VPWR VPWR _00442_ sky130_fd_sc_hd__a21oi_1
X_08683_ _01409_ _01410_ VGND VGND VPWR VPWR _01411_ sky130_fd_sc_hd__nor2_1
X_07634_ _00366_ _00372_ VGND VGND VPWR VPWR _00374_ sky130_fd_sc_hd__xnor2_1
XFILLER_81_632 VPWR VGND VPWR VGND sky130_ef_sc_hd__decap_12
XFILLER_53_334 VGND VGND VPWR VPWR sky130_fd_sc_hd__fill_2
X_07565_ _00142_ _00148_ _00152_ VGND VGND VPWR VPWR _00305_ sky130_fd_sc_hd__a21o_1
XFILLER_53_367 VGND VGND VPWR VPWR sky130_fd_sc_hd__fill_1
XFILLER_80_197 VPWR VGND VPWR VGND sky130_ef_sc_hd__decap_12
X_09304_ _02026_ _02028_ _02029_ VGND VGND VPWR VPWR _02030_ sky130_fd_sc_hd__nor3_1
X_07496_ net749 net385 net383 net921 VGND VGND VPWR VPWR _00237_ sky130_fd_sc_hd__and4_1
X_09235_ _01956_ _01957_ VGND VGND VPWR VPWR _01959_ sky130_fd_sc_hd__nor2_1
XFILLER_21_253 VGND VGND VPWR VPWR sky130_fd_sc_hd__decap_3
XFILLER_107_303 VGND VGND VPWR VPWR sky130_fd_sc_hd__decap_6
X_09166_ _01855_ _01856_ _01888_ _01889_ VGND VGND VPWR VPWR _01891_ sky130_fd_sc_hd__o22a_1
X_09097_ _02219_ _01649_ VGND VGND VPWR VPWR _01822_ sky130_fd_sc_hd__or2_2
X_08117_ _00723_ _00725_ _00852_ VGND VGND VPWR VPWR _00853_ sky130_fd_sc_hd__o21ai_1
XFILLER_79_27 VGND VGND VPWR VPWR sky130_fd_sc_hd__decap_6
XFILLER_134_133 VGND VGND VPWR VPWR sky130_fd_sc_hd__decap_6
X_08048_ net305 _00440_ VGND VGND VPWR VPWR _00785_ sky130_fd_sc_hd__nand2_1
XFILLER_107_369 VGND VGND VPWR VPWR sky130_fd_sc_hd__decap_4
XFILLER_134_177 VPWR VGND VPWR VGND sky130_ef_sc_hd__decap_12
XFILLER_89_721 VGND VGND VPWR VPWR sky130_fd_sc_hd__decap_6
XTAP_TAPCELL_ROW_73_1320 VGND VPWR sky130_fd_sc_hd__tapvpwrvgnd_1
XFILLER_135_55 VGND VGND VPWR VPWR sky130_fd_sc_hd__fill_1
X_10010_ _02793_ _02794_ VGND VGND VPWR VPWR _02795_ sky130_fd_sc_hd__nor2_1
XFILLER_0_113 VPWR VGND VPWR VGND sky130_ef_sc_hd__decap_12
XFILLER_95_15 VGND VGND VPWR VPWR sky130_fd_sc_hd__decap_8
XFILLER_76_404 VPWR VGND VPWR VGND sky130_ef_sc_hd__decap_12
X_09999_ _02780_ _02782_ _02783_ VGND VGND VPWR VPWR _02784_ sky130_fd_sc_hd__nor3_1
XFILLER_130_394 VGND VGND VPWR VPWR sky130_fd_sc_hd__fill_1
XFILLER_88_297 VGND VGND VPWR VPWR sky130_fd_sc_hd__fill_1
XFILLER_57_673 VGND VGND VPWR VPWR sky130_fd_sc_hd__decap_6
X_11961_ _04918_ _04919_ _04917_ VGND VGND VPWR VPWR _04921_ sky130_fd_sc_hd__o21ai_1
XFILLER_57_695 VGND VGND VPWR VPWR sky130_fd_sc_hd__fill_2
XFILLER_28_97 VGND VGND VPWR VPWR sky130_fd_sc_hd__fill_1
XFILLER_29_375 VPWR VGND VPWR VGND sky130_ef_sc_hd__decap_12
X_10912_ _03743_ _03778_ VGND VGND VPWR VPWR _03779_ sky130_fd_sc_hd__xor2_1
X_11892_ _04647_ _04658_ _04844_ _04838_ VGND VGND VPWR VPWR _04846_ sky130_fd_sc_hd__a211o_1
XFILLER_44_356 VGND VGND VPWR VPWR sky130_fd_sc_hd__decap_8
XTAP_TAPCELL_ROW_84_1471 VGND VPWR sky130_fd_sc_hd__tapvpwrvgnd_1
XFILLER_32_529 VGND VGND VPWR VPWR sky130_fd_sc_hd__decap_3
X_10843_ _03701_ _03702_ VGND VGND VPWR VPWR _03703_ sky130_fd_sc_hd__xnor2_1
XFILLER_44_96 VGND VGND VPWR VPWR sky130_fd_sc_hd__decap_8
XFILLER_44_85 VGND VGND VPWR VPWR sky130_fd_sc_hd__fill_2
XFILLER_44_63 VGND VGND VPWR VPWR sky130_fd_sc_hd__decap_8
XFILLER_12_220 VGND VGND VPWR VPWR sky130_fd_sc_hd__fill_1
X_10774_ _03432_ _03627_ VGND VGND VPWR VPWR _03628_ sky130_fd_sc_hd__xnor2_1
XTAP_TAPCELL_ROW_30_708 VGND VPWR sky130_fd_sc_hd__tapvpwrvgnd_1
XTAP_TAPCELL_ROW_30_719 VGND VPWR sky130_fd_sc_hd__tapvpwrvgnd_1
X_12513_ net542 _05342_ _05343_ _05522_ VGND VGND VPWR VPWR _05523_ sky130_fd_sc_hd__a31o_1
XFILLER_12_264 VGND VGND VPWR VPWR sky130_fd_sc_hd__fill_1
XTAP_TAPCELL_ROW_10_432 VGND VPWR sky130_fd_sc_hd__tapvpwrvgnd_1
X_12444_ _05441_ _05442_ _05447_ VGND VGND VPWR VPWR _05448_ sky130_fd_sc_hd__a21o_1
XFILLER_126_645 VPWR VGND VPWR VGND sky130_ef_sc_hd__decap_12
XFILLER_126_623 VPWR VGND VPWR VGND sky130_ef_sc_hd__decap_12
XFILLER_125_111 VGND VGND VPWR VPWR sky130_fd_sc_hd__fill_1
X_12375_ net492 net486 net674 net672 VGND VGND VPWR VPWR _05372_ sky130_fd_sc_hd__and4_1
XFILLER_125_133 VGND VGND VPWR VPWR sky130_fd_sc_hd__fill_2
X_11326_ _04230_ _04206_ VGND VGND VPWR VPWR _04231_ sky130_fd_sc_hd__and2b_1
XFILLER_5_57 VPWR VGND VPWR VGND sky130_ef_sc_hd__decap_12
X_11257_ _03863_ _04155_ VGND VGND VPWR VPWR _04157_ sky130_fd_sc_hd__xnor2_2
XFILLER_121_350 VGND VGND VPWR VPWR sky130_fd_sc_hd__decap_4
X_10208_ _02999_ _03001_ _03000_ VGND VGND VPWR VPWR _03011_ sky130_fd_sc_hd__a21o_1
X_11188_ _04077_ _04078_ VGND VGND VPWR VPWR _04081_ sky130_fd_sc_hd__xnor2_1
X_10139_ _02874_ _02931_ _02930_ VGND VGND VPWR VPWR _02935_ sky130_fd_sc_hd__o21ai_2
XFILLER_39_139 VGND VGND VPWR VPWR sky130_fd_sc_hd__fill_2
XFILLER_94_245 VGND VGND VPWR VPWR sky130_fd_sc_hd__fill_1
XFILLER_90_440 VGND VGND VPWR VPWR sky130_fd_sc_hd__decap_6
XTAP_TAPCELL_ROW_18_543 VGND VPWR sky130_fd_sc_hd__tapvpwrvgnd_1
XFILLER_35_334 VGND VGND VPWR VPWR sky130_fd_sc_hd__fill_2
XFILLER_63_698 VGND VGND VPWR VPWR sky130_fd_sc_hd__decap_6
XFILLER_62_175 VGND VGND VPWR VPWR sky130_fd_sc_hd__decap_6
XFILLER_35_389 VGND VGND VPWR VPWR sky130_fd_sc_hd__decap_3
XFILLER_90_495 VGND VGND VPWR VPWR sky130_fd_sc_hd__decap_3
X_07350_ _06638_ _06639_ VGND VGND VPWR VPWR _06641_ sky130_fd_sc_hd__xor2_2
X_09020_ _01743_ _01744_ VGND VGND VPWR VPWR _01746_ sky130_fd_sc_hd__xnor2_1
X_07281_ _06567_ _06570_ _06571_ VGND VGND VPWR VPWR _06572_ sky130_fd_sc_hd__nand3_1
XFILLER_129_461 VPWR VGND VPWR VGND sky130_ef_sc_hd__decap_12
XFILLER_132_637 VGND VGND VPWR VPWR sky130_fd_sc_hd__decap_6
XFILLER_131_125 VPWR VGND VPWR VGND sky130_ef_sc_hd__decap_12
XTAP_TAPCELL_ROW_129_2106 VGND VPWR sky130_fd_sc_hd__tapvpwrvgnd_1
X_09922_ _02678_ _02702_ VGND VGND VPWR VPWR _02703_ sky130_fd_sc_hd__nor2_1
XTAP_TAPCELL_ROW_55_1061 VGND VPWR sky130_fd_sc_hd__tapvpwrvgnd_1
X_09853_ _02498_ _02506_ VGND VGND VPWR VPWR _02628_ sky130_fd_sc_hd__nor2_1
XFILLER_86_713 VGND VGND VPWR VPWR sky130_fd_sc_hd__fill_1
XFILLER_112_383 VGND VGND VPWR VPWR sky130_fd_sc_hd__fill_1
X_09784_ net423 _01822_ _01824_ _02430_ VGND VGND VPWR VPWR _02552_ sky130_fd_sc_hd__a2bb2o_1
X_08804_ _01393_ _01395_ _01394_ VGND VGND VPWR VPWR _01531_ sky130_fd_sc_hd__o21bai_1
X_08735_ _01459_ _01460_ VGND VGND VPWR VPWR _01462_ sky130_fd_sc_hd__xnor2_1
XFILLER_105_69 VPWR VGND VPWR VGND sky130_ef_sc_hd__decap_12
X_06996_ _05462_ _05473_ VGND VGND VPWR VPWR _05484_ sky130_fd_sc_hd__nand2b_1
XFILLER_94_790 VPWR VGND VPWR VGND sky130_ef_sc_hd__decap_12
XFILLER_39_673 VGND VGND VPWR VPWR sky130_fd_sc_hd__fill_1
X_08666_ net439 net447 net556 net554 VGND VGND VPWR VPWR _01394_ sky130_fd_sc_hd__and4_1
XFILLER_54_632 VPWR VGND VPWR VGND sky130_ef_sc_hd__decap_12
XFILLER_121_57 VPWR VGND VPWR VGND sky130_ef_sc_hd__decap_12
X_07617_ _00327_ _00356_ VGND VGND VPWR VPWR _00357_ sky130_fd_sc_hd__and2b_1
X_08597_ _01317_ _01315_ _01320_ _01324_ VGND VGND VPWR VPWR _01326_ sky130_fd_sc_hd__o211ai_2
XFILLER_53_164 VGND VGND VPWR VPWR sky130_fd_sc_hd__decap_4
XFILLER_14_529 VGND VGND VPWR VPWR sky130_fd_sc_hd__decap_3
X_07548_ net316 net306 net594 net570 VGND VGND VPWR VPWR _00288_ sky130_fd_sc_hd__and4_1
XFILLER_41_337 VGND VGND VPWR VPWR sky130_fd_sc_hd__fill_1
XTAP_TAPCELL_ROW_120_1969 VGND VPWR sky130_fd_sc_hd__tapvpwrvgnd_1
XFILLER_14_33 VGND VGND VPWR VPWR sky130_fd_sc_hd__fill_1
X_07479_ _06609_ _06612_ VGND VGND VPWR VPWR _00220_ sky130_fd_sc_hd__nand2_1
XFILLER_10_713 VPWR VGND VPWR VGND sky130_ef_sc_hd__decap_12
XFILLER_127_409 VGND VGND VPWR VPWR sky130_fd_sc_hd__decap_6
X_09218_ _01761_ _01940_ VGND VGND VPWR VPWR _01942_ sky130_fd_sc_hd__xor2_1
X_10490_ _03225_ _03316_ _03317_ VGND VGND VPWR VPWR _03318_ sky130_fd_sc_hd__nand3_1
XFILLER_10_757 VPWR VGND VPWR VGND sky130_ef_sc_hd__decap_12
XFILLER_108_645 VPWR VGND VPWR VGND sky130_ef_sc_hd__decap_12
X_09149_ net358 net335 net329 net327 VGND VGND VPWR VPWR _01874_ sky130_fd_sc_hd__and4_1
XFILLER_5_205 VPWR VGND VPWR VGND sky130_ef_sc_hd__decap_12
X_12160_ net690 net665 net293 net285 VGND VGND VPWR VPWR _05137_ sky130_fd_sc_hd__and4_1
XFILLER_5_249 VPWR VGND VPWR VGND sky130_ef_sc_hd__decap_12
XFILLER_135_497 VGND VGND VPWR VPWR sky130_fd_sc_hd__decap_6
XFILLER_123_615 VGND VGND VPWR VPWR sky130_fd_sc_hd__fill_1
X_11111_ _03993_ _03994_ VGND VGND VPWR VPWR _03997_ sky130_fd_sc_hd__xnor2_1
XFILLER_122_125 VGND VGND VPWR VPWR sky130_fd_sc_hd__fill_1
X_12091_ net421 net588 VGND VGND VPWR VPWR _05063_ sky130_fd_sc_hd__nand2_1
X_11042_ _03919_ _03920_ VGND VGND VPWR VPWR _03921_ sky130_fd_sc_hd__nor2_1
XFILLER_39_41 VPWR VGND VPWR VGND sky130_ef_sc_hd__decap_12
XFILLER_103_383 VGND VGND VPWR VPWR sky130_fd_sc_hd__fill_1
XFILLER_89_595 VGND VGND VPWR VPWR sky130_fd_sc_hd__fill_1
XFILLER_130_191 VGND VGND VPWR VPWR sky130_fd_sc_hd__decap_4
XFILLER_77_768 VPWR VGND VPWR VGND sky130_ef_sc_hd__decap_12
XFILLER_91_204 VGND VGND VPWR VPWR sky130_fd_sc_hd__fill_2
XTAP_TAPCELL_ROW_86_1500 VGND VPWR sky130_fd_sc_hd__tapvpwrvgnd_1
XFILLER_57_470 VGND VGND VPWR VPWR sky130_fd_sc_hd__decap_8
XFILLER_17_312 VGND VGND VPWR VPWR sky130_fd_sc_hd__decap_4
X_12993_ _05668_ _05827_ _06046_ VGND VGND VPWR VPWR _06048_ sky130_fd_sc_hd__or3b_1
X_11944_ net500 net677 _04901_ _04900_ _04724_ VGND VGND VPWR VPWR _04902_ sky130_fd_sc_hd__a32o_1
X_11875_ _04816_ _04815_ _04820_ _04824_ VGND VGND VPWR VPWR _04827_ sky130_fd_sc_hd__a211o_4
XTAP_TAPCELL_ROW_15_502 VGND VPWR sky130_fd_sc_hd__tapvpwrvgnd_1
XFILLER_60_624 VGND VGND VPWR VPWR sky130_fd_sc_hd__decap_3
X_10826_ _03681_ _03682_ _03333_ VGND VGND VPWR VPWR _03685_ sky130_fd_sc_hd__o21ai_1
XTAP_TAPCELL_ROW_43_899 VGND VPWR sky130_fd_sc_hd__tapvpwrvgnd_1
X_10757_ _03607_ _03608_ VGND VGND VPWR VPWR _03610_ sky130_fd_sc_hd__xnor2_1
X_10688_ _03348_ _03356_ _03355_ VGND VGND VPWR VPWR _03534_ sky130_fd_sc_hd__a21bo_1
XTAP_TAPCELL_ROW_97_1651 VGND VPWR sky130_fd_sc_hd__tapvpwrvgnd_1
X_12427_ _05226_ _05427_ VGND VGND VPWR VPWR _05430_ sky130_fd_sc_hd__xnor2_1
XFILLER_126_475 VGND VGND VPWR VPWR sky130_fd_sc_hd__fill_1
X_12358_ _05338_ _05351_ VGND VGND VPWR VPWR _05354_ sky130_fd_sc_hd__xnor2_1
XFILLER_5_783 VGND VGND VPWR VPWR sky130_fd_sc_hd__fill_1
XFILLER_99_337 VGND VGND VPWR VPWR sky130_fd_sc_hd__decap_4
X_11309_ _02087_ net635 VGND VGND VPWR VPWR _04213_ sky130_fd_sc_hd__and2_1
X_12289_ _05275_ _05277_ VGND VGND VPWR VPWR _05279_ sky130_fd_sc_hd__xnor2_1
XFILLER_113_169 VPWR VGND VPWR VGND sky130_ef_sc_hd__decap_12
X_06850_ _02954_ _03292_ _03314_ _03259_ VGND VGND VPWR VPWR _03893_ sky130_fd_sc_hd__o22ai_1
XFILLER_68_757 VGND VGND VPWR VPWR sky130_fd_sc_hd__fill_2
XFILLER_68_746 VGND VGND VPWR VPWR sky130_fd_sc_hd__decap_8
XFILLER_67_223 VGND VGND VPWR VPWR sky130_fd_sc_hd__fill_1
XTAP_TAPCELL_ROW_124_2036 VGND VPWR sky130_fd_sc_hd__tapvpwrvgnd_1
XTAP_TAPCELL_ROW_124_2025 VGND VPWR sky130_fd_sc_hd__tapvpwrvgnd_1
X_06781_ _03031_ _03129_ VGND VGND VPWR VPWR _03140_ sky130_fd_sc_hd__nor2_1
XFILLER_95_587 VPWR VGND VPWR VGND sky130_ef_sc_hd__decap_12
XFILLER_83_738 VGND VGND VPWR VPWR sky130_fd_sc_hd__fill_1
XFILLER_83_727 VGND VGND VPWR VPWR sky130_fd_sc_hd__fill_1
XFILLER_55_429 VGND VGND VPWR VPWR sky130_fd_sc_hd__fill_2
XFILLER_82_237 VGND VGND VPWR VPWR sky130_fd_sc_hd__fill_2
X_08520_ _01245_ _01248_ VGND VGND VPWR VPWR _01249_ sky130_fd_sc_hd__and2_1
X_08451_ net621 net644 net265 net263 VGND VGND VPWR VPWR _01180_ sky130_fd_sc_hd__and4_1
XFILLER_63_473 VPWR VGND VPWR VGND sky130_ef_sc_hd__decap_12
XFILLER_35_142 VGND VGND VPWR VPWR sky130_fd_sc_hd__fill_1
X_07402_ net322 net320 net543 VGND VGND VPWR VPWR _00143_ sky130_fd_sc_hd__and3_1
XTAP_TAPCELL_ROW_106_1780 VGND VPWR sky130_fd_sc_hd__tapvpwrvgnd_1
XFILLER_23_337 VGND VGND VPWR VPWR sky130_fd_sc_hd__decap_3
XFILLER_35_197 VPWR VGND VPWR VGND sky130_ef_sc_hd__decap_12
X_08382_ _01105_ _01112_ VGND VGND VPWR VPWR _01113_ sky130_fd_sc_hd__nand2_1
XFILLER_50_145 VGND VGND VPWR VPWR sky130_fd_sc_hd__decap_3
X_07333_ net105 _06623_ VGND VGND VPWR VPWR _06624_ sky130_fd_sc_hd__xnor2_1
X_07264_ _06553_ _06554_ VGND VGND VPWR VPWR _06555_ sky130_fd_sc_hd__or2_1
X_09003_ _01727_ _01728_ VGND VGND VPWR VPWR _01729_ sky130_fd_sc_hd__nand2b_1
XTAP_TAPCELL_ROW_135_2187 VGND VPWR sky130_fd_sc_hd__tapvpwrvgnd_1
X_07195_ _06117_ _06139_ _06485_ _06486_ VGND VGND VPWR VPWR _06487_ sky130_fd_sc_hd__o211ai_2
XFILLER_3_709 VPWR VGND VPWR VGND sky130_ef_sc_hd__decap_12
XFILLER_132_412 VGND VGND VPWR VPWR sky130_fd_sc_hd__decap_8
XFILLER_105_615 VGND VGND VPWR VPWR sky130_fd_sc_hd__fill_1
XFILLER_104_136 VGND VGND VPWR VPWR sky130_fd_sc_hd__decap_4
XFILLER_132_489 VPWR VGND VPWR VGND sky130_ef_sc_hd__decap_12
X_09905_ _02456_ _02582_ _02682_ VGND VGND VPWR VPWR _02684_ sky130_fd_sc_hd__and3_1
XFILLER_120_629 VPWR VGND VPWR VGND sky130_ef_sc_hd__decap_12
Xfanout501 net502 VGND VGND VPWR VPWR net501 sky130_fd_sc_hd__buf_2
Xfanout523 net525 VGND VGND VPWR VPWR net523 sky130_fd_sc_hd__buf_2
Xfanout512 net519 VGND VGND VPWR VPWR net512 sky130_fd_sc_hd__buf_2
Xfanout545 net546 VGND VGND VPWR VPWR net545 sky130_fd_sc_hd__buf_2
XFILLER_116_68 VGND VGND VPWR VPWR sky130_fd_sc_hd__fill_2
XFILLER_113_670 VGND VGND VPWR VPWR sky130_fd_sc_hd__fill_2
XFILLER_86_510 VPWR VGND VPWR VGND sky130_ef_sc_hd__decap_12
Xfanout556 net155 VGND VGND VPWR VPWR net556 sky130_fd_sc_hd__clkbuf_2
Xfanout534 net536 VGND VGND VPWR VPWR net534 sky130_fd_sc_hd__buf_2
X_09836_ _02575_ _02607_ VGND VGND VPWR VPWR _02609_ sky130_fd_sc_hd__xnor2_1
Xfanout578 net147 VGND VGND VPWR VPWR net578 sky130_fd_sc_hd__clkbuf_2
Xfanout589 net140 VGND VGND VPWR VPWR net589 sky130_fd_sc_hd__clkbuf_2
Xfanout567 net569 VGND VGND VPWR VPWR net567 sky130_fd_sc_hd__clkbuf_2
X_06979_ _05276_ _05287_ VGND VGND VPWR VPWR _05298_ sky130_fd_sc_hd__xnor2_1
X_09767_ _02390_ _02393_ _02531_ VGND VGND VPWR VPWR _02534_ sky130_fd_sc_hd__or3_1
XFILLER_46_429 VGND VGND VPWR VPWR sky130_fd_sc_hd__fill_1
X_09698_ _02456_ _02458_ VGND VGND VPWR VPWR _02459_ sky130_fd_sc_hd__nand2_1
X_08718_ _01444_ _01443_ _01340_ VGND VGND VPWR VPWR _01446_ sky130_fd_sc_hd__a21o_1
XTAP_TAPCELL_ROW_68_1241 VGND VPWR sky130_fd_sc_hd__tapvpwrvgnd_1
X_08649_ _01367_ _01376_ VGND VGND VPWR VPWR _01377_ sky130_fd_sc_hd__xnor2_2
Xrebuffer50 net749 VGND VGND VPWR VPWR net750 sky130_fd_sc_hd__dlygate4sd1_1
XTAP_TAPCELL_ROW_68_1252 VGND VPWR sky130_fd_sc_hd__tapvpwrvgnd_1
XFILLER_54_451 VGND VGND VPWR VPWR sky130_fd_sc_hd__decap_8
Xrebuffer72 net354 VGND VGND VPWR VPWR net772 sky130_fd_sc_hd__dlymetal6s4s_1
XFILLER_14_304 VGND VGND VPWR VPWR sky130_fd_sc_hd__decap_4
XFILLER_27_665 VGND VGND VPWR VPWR sky130_fd_sc_hd__decap_6
XFILLER_81_281 VPWR VGND VPWR VGND sky130_ef_sc_hd__decap_12
Xrebuffer94 net358 VGND VGND VPWR VPWR net794 sky130_fd_sc_hd__buf_1
Xrebuffer83 net786 VGND VGND VPWR VPWR net783 sky130_fd_sc_hd__dlymetal6s2s_1
XFILLER_27_698 VPWR VGND VPWR VGND sky130_ef_sc_hd__decap_12
XTAP_TAPCELL_ROW_81_1430 VGND VPWR sky130_fd_sc_hd__tapvpwrvgnd_1
X_11660_ _04591_ _04592_ VGND VGND VPWR VPWR _04593_ sky130_fd_sc_hd__xor2_1
XFILLER_42_657 VPWR VGND VPWR VGND sky130_ef_sc_hd__decap_12
X_11591_ _04519_ net744 VGND VGND VPWR VPWR _00017_ sky130_fd_sc_hd__xor2_1
X_10611_ net356 net331 net52 net349 VGND VGND VPWR VPWR _03450_ sky130_fd_sc_hd__nand4_1
X_13330_ net392 VGND VGND VPWR VPWR _00104_ sky130_fd_sc_hd__inv_2
X_10542_ _03212_ _03373_ VGND VGND VPWR VPWR _03374_ sky130_fd_sc_hd__xor2_1
XTAP_TAPCELL_ROW_40_858 VGND VPWR sky130_fd_sc_hd__tapvpwrvgnd_1
XFILLER_10_576 VGND VGND VPWR VPWR sky130_fd_sc_hd__decap_3
XFILLER_6_525 VGND VGND VPWR VPWR sky130_fd_sc_hd__decap_6
X_13261_ _06234_ _06239_ _06235_ VGND VGND VPWR VPWR _06339_ sky130_fd_sc_hd__o21a_1
XFILLER_41_64 VPWR VGND VPWR VGND sky130_ef_sc_hd__decap_12
X_10473_ _03289_ _03297_ _03298_ VGND VGND VPWR VPWR _03299_ sky130_fd_sc_hd__nand3_1
XFILLER_6_569 VPWR VGND VPWR VGND sky130_ef_sc_hd__decap_12
XTAP_TAPCELL_ROW_20_571 VGND VPWR sky130_fd_sc_hd__tapvpwrvgnd_1
X_12212_ _05191_ _05192_ VGND VGND VPWR VPWR _05194_ sky130_fd_sc_hd__xnor2_1
XFILLER_135_261 VPWR VGND VPWR VGND sky130_ef_sc_hd__decap_12
Xrebuffer184 _01730_ VGND VGND VPWR VPWR net884 sky130_fd_sc_hd__dlymetal6s2s_1
X_13192_ _06245_ _06264_ VGND VGND VPWR VPWR _06265_ sky130_fd_sc_hd__xnor2_1
XFILLER_123_423 VPWR VGND VPWR VGND sky130_ef_sc_hd__decap_12
XFILLER_108_497 VGND VGND VPWR VPWR sky130_fd_sc_hd__decap_8
X_12143_ _04967_ _04969_ _05117_ _05118_ VGND VGND VPWR VPWR _05119_ sky130_fd_sc_hd__o211ai_2
XFILLER_111_607 VGND VGND VPWR VPWR sky130_fd_sc_hd__decap_8
XFILLER_96_307 VGND VGND VPWR VPWR sky130_fd_sc_hd__fill_1
XTAP_TAPCELL_ROW_92_1581 VGND VPWR sky130_fd_sc_hd__tapvpwrvgnd_1
X_12074_ _04914_ _05041_ _05042_ VGND VGND VPWR VPWR _05044_ sky130_fd_sc_hd__and3_1
XFILLER_104_681 VPWR VGND VPWR VGND sky130_ef_sc_hd__decap_12
X_11025_ _03886_ _03901_ VGND VGND VPWR VPWR _03902_ sky130_fd_sc_hd__xor2_1
XFILLER_49_245 VGND VGND VPWR VPWR sky130_fd_sc_hd__fill_2
XFILLER_77_598 VGND VGND VPWR VPWR sky130_fd_sc_hd__decap_6
XTAP_TAPCELL_ROW_48_969 VGND VPWR sky130_fd_sc_hd__tapvpwrvgnd_1
XFILLER_18_687 VGND VGND VPWR VPWR sky130_fd_sc_hd__fill_2
X_12976_ _06028_ _06007_ VGND VGND VPWR VPWR _06029_ sky130_fd_sc_hd__and2b_1
XFILLER_33_613 VGND VGND VPWR VPWR sky130_fd_sc_hd__decap_3
X_11927_ _04881_ _04882_ VGND VGND VPWR VPWR _04884_ sky130_fd_sc_hd__or2_1
XFILLER_60_421 VPWR VGND VPWR VGND sky130_ef_sc_hd__decap_12
XTAP_TAPCELL_ROW_28_682 VGND VPWR sky130_fd_sc_hd__tapvpwrvgnd_1
XTAP_TAPCELL_ROW_28_693 VGND VPWR sky130_fd_sc_hd__tapvpwrvgnd_1
XFILLER_32_101 VPWR VGND VPWR VGND sky130_ef_sc_hd__decap_12
XFILLER_33_635 VGND VGND VPWR VPWR sky130_fd_sc_hd__decap_6
X_11858_ _04755_ _04808_ VGND VGND VPWR VPWR _04809_ sky130_fd_sc_hd__or2_1
X_11789_ _04638_ _04671_ _04673_ _04668_ VGND VGND VPWR VPWR _04733_ sky130_fd_sc_hd__o22ai_1
XANTENNA_19 net32 VGND VGND VPWR VPWR sky130_fd_sc_hd__diode_2
X_10809_ _03603_ _03663_ _03666_ VGND VGND VPWR VPWR _03667_ sky130_fd_sc_hd__and3_4
XFILLER_119_718 VGND VGND VPWR VPWR sky130_fd_sc_hd__decap_4
XFILLER_13_381 VGND VGND VPWR VPWR sky130_fd_sc_hd__decap_8
XFILLER_9_385 VGND VGND VPWR VPWR sky130_fd_sc_hd__decap_6
XFILLER_63_3 VPWR VGND VPWR VGND sky130_ef_sc_hd__decap_12
XFILLER_126_261 VGND VGND VPWR VPWR sky130_fd_sc_hd__fill_1
XFILLER_102_618 VGND VGND VPWR VPWR sky130_fd_sc_hd__fill_1
XFILLER_99_167 VGND VGND VPWR VPWR sky130_fd_sc_hd__fill_1
X_07951_ _00657_ _00688_ VGND VGND VPWR VPWR _00689_ sky130_fd_sc_hd__xnor2_1
XFILLER_101_128 VGND VGND VPWR VPWR sky130_fd_sc_hd__fill_1
X_06902_ net919 _04385_ _04156_ VGND VGND VPWR VPWR _04461_ sky130_fd_sc_hd__o21ai_1
XTAP_TAPCELL_ROW_52_1020 VGND VPWR sky130_fd_sc_hd__tapvpwrvgnd_1
X_07882_ _00618_ _00619_ VGND VGND VPWR VPWR _00620_ sky130_fd_sc_hd__xor2_1
X_09621_ _02373_ _02374_ VGND VGND VPWR VPWR _02375_ sky130_fd_sc_hd__nor2_1
X_06833_ _03675_ _03696_ VGND VGND VPWR VPWR _03707_ sky130_fd_sc_hd__xor2_1
XFILLER_56_749 VGND VGND VPWR VPWR sky130_fd_sc_hd__decap_6
X_06764_ _02566_ _02943_ VGND VGND VPWR VPWR _02954_ sky130_fd_sc_hd__nand2_1
X_09552_ _02289_ _02300_ VGND VGND VPWR VPWR _02301_ sky130_fd_sc_hd__xor2_2
XFILLER_55_237 VPWR VGND VPWR VGND sky130_ef_sc_hd__decap_12
X_08503_ net473 net550 VGND VGND VPWR VPWR _01232_ sky130_fd_sc_hd__nand2_1
X_09483_ _02224_ _02225_ VGND VGND VPWR VPWR _02226_ sky130_fd_sc_hd__nor2_1
X_06695_ net324 VGND VGND VPWR VPWR _02208_ sky130_fd_sc_hd__inv_2
XFILLER_36_473 VGND VGND VPWR VPWR sky130_fd_sc_hd__decap_3
X_08434_ _01121_ _01162_ _01163_ VGND VGND VPWR VPWR _01164_ sky130_fd_sc_hd__and3_1
X_08365_ net699 net517 net341 net338 VGND VGND VPWR VPWR _01096_ sky130_fd_sc_hd__and4_1
XTAP_TAPCELL_ROW_63_1171 VGND VPWR sky130_fd_sc_hd__tapvpwrvgnd_1
X_07316_ _06606_ _06586_ VGND VGND VPWR VPWR _06607_ sky130_fd_sc_hd__xor2_1
XTAP_TAPCELL_ROW_63_1182 VGND VPWR sky130_fd_sc_hd__tapvpwrvgnd_1
X_08296_ _00708_ _00935_ _00934_ VGND VGND VPWR VPWR _01031_ sky130_fd_sc_hd__a21o_1
XTAP_TAPCELL_ROW_119_1960 VGND VPWR sky130_fd_sc_hd__tapvpwrvgnd_1
X_07247_ _06530_ _06537_ VGND VGND VPWR VPWR _06538_ sky130_fd_sc_hd__nand2_1
X_07178_ _06467_ _06468_ _06469_ VGND VGND VPWR VPWR _06470_ sky130_fd_sc_hd__nand3_1
XFILLER_3_517 VPWR VGND VPWR VGND sky130_ef_sc_hd__decap_12
XFILLER_133_721 VGND VGND VPWR VPWR sky130_fd_sc_hd__decap_6
XFILLER_133_765 VPWR VGND VPWR VGND sky130_ef_sc_hd__decap_12
XFILLER_132_253 VPWR VGND VPWR VGND sky130_ef_sc_hd__decap_12
XFILLER_87_27 VGND VGND VPWR VPWR sky130_fd_sc_hd__decap_4
Xfanout320 net67 VGND VGND VPWR VPWR net320 sky130_fd_sc_hd__clkbuf_4
XFILLER_120_437 VPWR VGND VPWR VGND sky130_ef_sc_hd__decap_12
Xfanout331 net337 VGND VGND VPWR VPWR net331 sky130_fd_sc_hd__buf_2
Xfanout353 net50 VGND VGND VPWR VPWR net353 sky130_fd_sc_hd__clkbuf_2
XTAP_TAPCELL_ROW_6_377 VGND VPWR sky130_fd_sc_hd__tapvpwrvgnd_1
Xfanout364 net46 VGND VGND VPWR VPWR net364 sky130_fd_sc_hd__buf_2
Xfanout375 net377 VGND VGND VPWR VPWR net375 sky130_fd_sc_hd__clkbuf_4
Xfanout342 net57 VGND VGND VPWR VPWR net342 sky130_fd_sc_hd__clkbuf_4
X_09819_ _02419_ _02426_ _02333_ VGND VGND VPWR VPWR _02591_ sky130_fd_sc_hd__a21o_1
XFILLER_101_673 VPWR VGND VPWR VGND sky130_ef_sc_hd__decap_12
XFILLER_101_662 VGND VGND VPWR VPWR sky130_fd_sc_hd__decap_3
XFILLER_100_161 VGND VGND VPWR VPWR sky130_fd_sc_hd__fill_1
XFILLER_74_524 VGND VGND VPWR VPWR sky130_fd_sc_hd__fill_2
Xfanout386 net37 VGND VGND VPWR VPWR net386 sky130_fd_sc_hd__clkbuf_2
XFILLER_46_204 VPWR VGND VPWR VGND sky130_ef_sc_hd__decap_12
Xfanout397 net33 VGND VGND VPWR VPWR net397 sky130_fd_sc_hd__clkbuf_4
XFILLER_19_429 VGND VGND VPWR VPWR sky130_fd_sc_hd__decap_8
X_12830_ _05745_ _05751_ net244 VGND VGND VPWR VPWR _05870_ sky130_fd_sc_hd__a21oi_1
XTAP_TAPCELL_ROW_45_928 VGND VPWR sky130_fd_sc_hd__tapvpwrvgnd_1
X_12761_ _05793_ _05794_ VGND VGND VPWR VPWR _05795_ sky130_fd_sc_hd__nand2b_1
XFILLER_42_421 VGND VGND VPWR VPWR sky130_fd_sc_hd__decap_8
XFILLER_70_752 VGND VGND VPWR VPWR sky130_fd_sc_hd__fill_1
X_11712_ net690 net666 net302 net300 VGND VGND VPWR VPWR _04649_ sky130_fd_sc_hd__and4_1
XTAP_TAPCELL_ROW_25_641 VGND VPWR sky130_fd_sc_hd__tapvpwrvgnd_1
X_12692_ _05552_ _05716_ _05718_ VGND VGND VPWR VPWR _05719_ sky130_fd_sc_hd__o21a_1
X_11643_ net698 net471 net371 net600 VGND VGND VPWR VPWR _04575_ sky130_fd_sc_hd__and4_2
XFILLER_42_498 VGND VGND VPWR VPWR sky130_fd_sc_hd__fill_1
Xinput28 in3[3] VGND VGND VPWR VPWR net28 sky130_fd_sc_hd__clkbuf_2
XFILLER_10_340 VPWR VGND VPWR VGND sky130_ef_sc_hd__decap_12
X_11574_ _04470_ _04501_ VGND VGND VPWR VPWR _04502_ sky130_fd_sc_hd__xnor2_1
Xinput17 in2[0] VGND VGND VPWR VPWR net17 sky130_fd_sc_hd__clkbuf_2
Xinput39 w00[5] VGND VGND VPWR VPWR net39 sky130_fd_sc_hd__buf_1
X_13313_ net397 VGND VGND VPWR VPWR _00087_ sky130_fd_sc_hd__inv_2
X_10525_ _03354_ _03353_ VGND VGND VPWR VPWR _03355_ sky130_fd_sc_hd__nand2b_1
XFILLER_6_333 VPWR VGND VPWR VGND sky130_ef_sc_hd__decap_12
XTAP_TAPCELL_ROW_94_1610 VGND VPWR sky130_fd_sc_hd__tapvpwrvgnd_1
XFILLER_6_377 VPWR VGND VPWR VGND sky130_ef_sc_hd__decap_12
X_13244_ _06207_ _06312_ _06311_ VGND VGND VPWR VPWR _06320_ sky130_fd_sc_hd__a21bo_1
X_10456_ net694 net409 net580 net343 VGND VGND VPWR VPWR _03280_ sky130_fd_sc_hd__and4_1
X_13175_ _06121_ _06124_ VGND VGND VPWR VPWR _06246_ sky130_fd_sc_hd__nor2_1
XFILLER_97_605 VGND VGND VPWR VPWR sky130_fd_sc_hd__decap_8
X_10387_ net591 net569 net282 net280 VGND VGND VPWR VPWR _03206_ sky130_fd_sc_hd__and4_1
X_12126_ _04937_ net780 _04945_ VGND VGND VPWR VPWR _05100_ sky130_fd_sc_hd__a21bo_1
XFILLER_69_329 VGND VGND VPWR VPWR sky130_fd_sc_hd__decap_6
XFILLER_96_148 VGND VGND VPWR VPWR sky130_fd_sc_hd__fill_1
X_12057_ _04899_ _04907_ _04906_ VGND VGND VPWR VPWR _05026_ sky130_fd_sc_hd__a21oi_1
XFILLER_77_384 VGND VGND VPWR VPWR sky130_fd_sc_hd__fill_2
X_11008_ _03705_ _03711_ _03881_ VGND VGND VPWR VPWR _03884_ sky130_fd_sc_hd__and3_1
XFILLER_65_568 VPWR VGND VPWR VGND sky130_ef_sc_hd__decap_12
XFILLER_53_719 VGND VGND VPWR VPWR sky130_fd_sc_hd__fill_2
XFILLER_73_590 VPWR VGND VPWR VGND sky130_ef_sc_hd__decap_12
XFILLER_18_484 VGND VGND VPWR VPWR sky130_fd_sc_hd__decap_4
X_12959_ net478 net660 net658 VGND VGND VPWR VPWR _06011_ sky130_fd_sc_hd__and3_2
XFILLER_61_741 VGND VGND VPWR VPWR sky130_fd_sc_hd__decap_4
XFILLER_33_443 VGND VGND VPWR VPWR sky130_fd_sc_hd__decap_4
XFILLER_20_104 VGND VGND VPWR VPWR sky130_fd_sc_hd__fill_1
X_08150_ _00860_ _00885_ VGND VGND VPWR VPWR _00886_ sky130_fd_sc_hd__xnor2_2
X_07101_ _05254_ _06392_ VGND VGND VPWR VPWR _06393_ sky130_fd_sc_hd__xnor2_1
XFILLER_119_559 VGND VGND VPWR VPWR sky130_fd_sc_hd__fill_1
X_08081_ _00816_ _00817_ VGND VGND VPWR VPWR _00818_ sky130_fd_sc_hd__or2_1
XTAP_TAPCELL_ROW_132_2146 VGND VPWR sky130_fd_sc_hd__tapvpwrvgnd_1
X_07032_ _05833_ _05866_ VGND VGND VPWR VPWR _05877_ sky130_fd_sc_hd__xnor2_1
XFILLER_127_581 VPWR VGND VPWR VGND sky130_ef_sc_hd__decap_12
XFILLER_115_721 VGND VGND VPWR VPWR sky130_fd_sc_hd__decap_6
XFILLER_114_242 VGND VGND VPWR VPWR sky130_fd_sc_hd__fill_2
XFILLER_130_713 VPWR VGND VPWR VGND sky130_ef_sc_hd__decap_12
XTAP_TAPCELL_ROW_114_1890 VGND VPWR sky130_fd_sc_hd__tapvpwrvgnd_1
X_08983_ _01706_ _01707_ net313 net338 VGND VGND VPWR VPWR _01709_ sky130_fd_sc_hd__and4bb_1
XFILLER_130_757 VPWR VGND VPWR VGND sky130_ef_sc_hd__decap_12
X_07934_ _00665_ _00671_ VGND VGND VPWR VPWR _00672_ sky130_fd_sc_hd__xnor2_1
X_07865_ _00458_ _00602_ VGND VGND VPWR VPWR _00603_ sky130_fd_sc_hd__xnor2_1
XFILLER_84_800 VGND VGND VPWR VPWR sky130_fd_sc_hd__decap_8
XFILLER_68_362 VGND VGND VPWR VPWR sky130_fd_sc_hd__fill_2
XTAP_TAPCELL_ROW_3_336 VGND VPWR sky130_fd_sc_hd__tapvpwrvgnd_1
XFILLER_29_727 VGND VGND VPWR VPWR sky130_fd_sc_hd__fill_1
X_09604_ _02356_ _02355_ VGND VGND VPWR VPWR _02357_ sky130_fd_sc_hd__nand2b_1
XFILLER_95_181 VGND VGND VPWR VPWR sky130_fd_sc_hd__fill_2
XFILLER_68_395 VGND VGND VPWR VPWR sky130_fd_sc_hd__decap_8
X_06816_ _03456_ _03478_ VGND VGND VPWR VPWR _03521_ sky130_fd_sc_hd__xnor2_1
XFILLER_83_343 VPWR VGND VPWR VGND sky130_ef_sc_hd__decap_12
X_07796_ _00395_ _00403_ _00402_ VGND VGND VPWR VPWR _00535_ sky130_fd_sc_hd__a21o_1
X_06747_ _02729_ _02761_ VGND VGND VPWR VPWR _02772_ sky130_fd_sc_hd__xnor2_1
X_09535_ net313 net326 VGND VGND VPWR VPWR _02282_ sky130_fd_sc_hd__nand2_1
XTAP_TAPCELL_ROW_65_1211 VGND VPWR sky130_fd_sc_hd__tapvpwrvgnd_1
XTAP_TAPCELL_ROW_65_1200 VGND VPWR sky130_fd_sc_hd__tapvpwrvgnd_1
XFILLER_43_218 VGND VGND VPWR VPWR sky130_fd_sc_hd__decap_6
XFILLER_24_421 VGND VGND VPWR VPWR sky130_fd_sc_hd__decap_4
X_06678_ net527 VGND VGND VPWR VPWR _02022_ sky130_fd_sc_hd__clkinv_4
X_09466_ _02192_ _02205_ VGND VGND VPWR VPWR _02207_ sky130_fd_sc_hd__xnor2_1
X_08417_ _01144_ _01145_ VGND VGND VPWR VPWR _01147_ sky130_fd_sc_hd__nand2_1
XTAP_TAPCELL_ROW_22_600 VGND VPWR sky130_fd_sc_hd__tapvpwrvgnd_1
X_09397_ net493 net626 net625 net502 VGND VGND VPWR VPWR _02132_ sky130_fd_sc_hd__a22o_1
XFILLER_11_137 VGND VGND VPWR VPWR sky130_fd_sc_hd__decap_6
X_08348_ _01038_ _01081_ VGND VGND VPWR VPWR _01082_ sky130_fd_sc_hd__xnor2_1
XFILLER_22_22 VGND VGND VPWR VPWR sky130_fd_sc_hd__fill_1
X_08279_ _00989_ _01013_ VGND VGND VPWR VPWR _01014_ sky130_fd_sc_hd__xnor2_1
XTAP_TAPCELL_ROW_50_997 VGND VPWR sky130_fd_sc_hd__tapvpwrvgnd_1
XFILLER_20_682 VGND VGND VPWR VPWR sky130_fd_sc_hd__fill_2
XFILLER_22_55 VGND VGND VPWR VPWR sky130_fd_sc_hd__fill_1
XFILLER_98_15 VPWR VGND VPWR VGND sky130_ef_sc_hd__decap_12
X_10310_ net459 net574 _02947_ _02946_ VGND VGND VPWR VPWR _03122_ sky130_fd_sc_hd__a31o_1
X_11290_ _04096_ _04191_ VGND VGND VPWR VPWR _04192_ sky130_fd_sc_hd__nor2_1
X_10241_ _03038_ _03041_ _03040_ VGND VGND VPWR VPWR _03047_ sky130_fd_sc_hd__o21ba_4
XFILLER_106_754 VGND VGND VPWR VPWR sky130_fd_sc_hd__fill_2
XTAP_TAPCELL_ROW_76_1362 VGND VPWR sky130_fd_sc_hd__tapvpwrvgnd_1
XFILLER_133_573 VPWR VGND VPWR VGND sky130_ef_sc_hd__decap_12
XFILLER_79_627 VGND VGND VPWR VPWR sky130_fd_sc_hd__decap_3
X_10172_ net426 net52 VGND VGND VPWR VPWR _02971_ sky130_fd_sc_hd__nand2_1
XFILLER_120_223 VPWR VGND VPWR VGND sky130_ef_sc_hd__decap_12
XFILLER_59_340 VPWR VGND VPWR VGND sky130_ef_sc_hd__decap_12
XFILLER_87_693 VGND VGND VPWR VPWR sky130_fd_sc_hd__decap_4
XFILLER_74_365 VPWR VGND VPWR VGND sky130_ef_sc_hd__decap_12
XFILLER_74_354 VGND VGND VPWR VPWR sky130_fd_sc_hd__decap_8
XFILLER_47_96 VGND VGND VPWR VPWR sky130_fd_sc_hd__decap_6
X_12813_ _05845_ _05849_ VGND VGND VPWR VPWR _05851_ sky130_fd_sc_hd__xnor2_1
XFILLER_63_51 VGND VGND VPWR VPWR sky130_fd_sc_hd__decap_4
XFILLER_43_741 VGND VGND VPWR VPWR sky130_fd_sc_hd__decap_8
X_12744_ net440 net581 _05774_ _05775_ VGND VGND VPWR VPWR _05776_ sky130_fd_sc_hd__o2bb2a_1
XFILLER_27_281 VGND VGND VPWR VPWR sky130_fd_sc_hd__decap_8
XFILLER_70_571 VPWR VGND VPWR VGND sky130_ef_sc_hd__decap_12
XFILLER_15_498 VGND VGND VPWR VPWR sky130_fd_sc_hd__decap_6
X_12675_ _05697_ _05698_ VGND VGND VPWR VPWR _05700_ sky130_fd_sc_hd__xnor2_1
X_11626_ _04554_ _04557_ VGND VGND VPWR VPWR _04558_ sky130_fd_sc_hd__xnor2_1
XFILLER_10_170 VGND VGND VPWR VPWR sky130_fd_sc_hd__fill_2
X_11557_ _04211_ _04336_ net247 VGND VGND VPWR VPWR _04484_ sky130_fd_sc_hd__o21a_1
XFILLER_116_529 VGND VGND VPWR VPWR sky130_fd_sc_hd__decap_3
XFILLER_116_518 VGND VGND VPWR VPWR sky130_fd_sc_hd__decap_4
X_10508_ _03226_ _03253_ _03251_ VGND VGND VPWR VPWR _03337_ sky130_fd_sc_hd__o21a_1
XFILLER_7_653 VPWR VGND VPWR VGND sky130_ef_sc_hd__decap_12
XFILLER_6_141 VPWR VGND VPWR VGND sky130_ef_sc_hd__decap_12
XFILLER_7_697 VPWR VGND VPWR VGND sky130_ef_sc_hd__decap_12
X_11488_ _04408_ _04406_ VGND VGND VPWR VPWR _04409_ sky130_fd_sc_hd__and2b_1
X_13227_ _06300_ _06301_ VGND VGND VPWR VPWR _06304_ sky130_fd_sc_hd__xnor2_1
X_10439_ net443 net149 VGND VGND VPWR VPWR _03262_ sky130_fd_sc_hd__nand2_1
XFILLER_112_724 VGND VGND VPWR VPWR sky130_fd_sc_hd__decap_4
X_13158_ _06100_ _06222_ _06225_ _06227_ VGND VGND VPWR VPWR _06228_ sky130_fd_sc_hd__o211a_1
XFILLER_112_757 VPWR VGND VPWR VGND sky130_ef_sc_hd__decap_12
X_12109_ _05077_ _05078_ _05080_ VGND VGND VPWR VPWR _05082_ sky130_fd_sc_hd__or3_1
X_13089_ _06149_ _06151_ VGND VGND VPWR VPWR _06153_ sky130_fd_sc_hd__xor2_1
XFILLER_111_256 VPWR VGND VPWR VGND sky130_ef_sc_hd__decap_12
XFILLER_78_660 VGND VGND VPWR VPWR sky130_fd_sc_hd__fill_2
X_07650_ _00382_ _00389_ _00388_ VGND VGND VPWR VPWR _00390_ sky130_fd_sc_hd__and3_1
XFILLER_53_505 VPWR VGND VPWR VGND sky130_ef_sc_hd__decap_12
XFILLER_26_719 VPWR VGND VPWR VGND sky130_ef_sc_hd__decap_12
X_07581_ _00304_ _00320_ VGND VGND VPWR VPWR _00321_ sky130_fd_sc_hd__xnor2_1
X_09320_ _02040_ _02046_ VGND VGND VPWR VPWR _02048_ sky130_fd_sc_hd__xnor2_1
XFILLER_34_741 VGND VGND VPWR VPWR sky130_fd_sc_hd__fill_1
XTAP_TAPCELL_ROW_101_1709 VGND VPWR sky130_fd_sc_hd__tapvpwrvgnd_1
X_09251_ net488 net479 net631 net629 VGND VGND VPWR VPWR _01975_ sky130_fd_sc_hd__and4_1
X_08202_ _00818_ _00820_ _00936_ VGND VGND VPWR VPWR _00938_ sky130_fd_sc_hd__nand3_1
XFILLER_21_435 VPWR VGND VPWR VGND sky130_ef_sc_hd__decap_12
XFILLER_33_273 VGND VGND VPWR VPWR sky130_fd_sc_hd__decap_6
X_09182_ _01903_ _01905_ _01753_ VGND VGND VPWR VPWR _01907_ sky130_fd_sc_hd__a21oi_2
XTAP_TAPCELL_ROW_60_1141 VGND VPWR sky130_fd_sc_hd__tapvpwrvgnd_1
XTAP_TAPCELL_ROW_60_1130 VGND VPWR sky130_fd_sc_hd__tapvpwrvgnd_1
X_08133_ net418 _00184_ _00186_ _00760_ VGND VGND VPWR VPWR _00869_ sky130_fd_sc_hd__a2bb2o_1
XFILLER_119_378 VGND VGND VPWR VPWR sky130_fd_sc_hd__decap_4
X_08064_ _00794_ _00799_ VGND VGND VPWR VPWR _00801_ sky130_fd_sc_hd__xnor2_1
XFILLER_107_529 VGND VGND VPWR VPWR sky130_fd_sc_hd__fill_1
X_07015_ net612 net436 net445 net610 VGND VGND VPWR VPWR _05691_ sky130_fd_sc_hd__a22oi_2
XTAP_TAPCELL_ROW_8_406 VGND VPWR sky130_fd_sc_hd__tapvpwrvgnd_1
XFILLER_115_573 VGND VGND VPWR VPWR sky130_fd_sc_hd__decap_6
XFILLER_103_713 VGND VGND VPWR VPWR sky130_fd_sc_hd__decap_6
XFILLER_0_328 VGND VGND VPWR VPWR sky130_fd_sc_hd__decap_8
XFILLER_102_245 VGND VGND VPWR VPWR sky130_fd_sc_hd__decap_6
XFILLER_130_587 VGND VGND VPWR VPWR sky130_fd_sc_hd__fill_1
X_08966_ _01689_ _01690_ _01681_ VGND VGND VPWR VPWR _01692_ sky130_fd_sc_hd__a21o_1
X_08897_ net18 net128 _01367_ VGND VGND VPWR VPWR _01623_ sky130_fd_sc_hd__and3_1
X_07917_ _00533_ _00551_ _00532_ VGND VGND VPWR VPWR _00655_ sky130_fd_sc_hd__a21o_1
XTAP_TAPCELL_ROW_71_1292 VGND VPWR sky130_fd_sc_hd__tapvpwrvgnd_1
X_07848_ _00584_ _00585_ VGND VGND VPWR VPWR _00586_ sky130_fd_sc_hd__or2_1
XFILLER_56_343 VGND VGND VPWR VPWR sky130_fd_sc_hd__fill_1
XPHY_EDGE_ROW_3_Left_140 VGND VGND VPWR VPWR sky130_fd_sc_hd__decap_3
X_09518_ _02132_ _02134_ _02130_ VGND VGND VPWR VPWR _02264_ sky130_fd_sc_hd__a21oi_1
X_07779_ _00515_ _00516_ VGND VGND VPWR VPWR _00518_ sky130_fd_sc_hd__xnor2_1
XFILLER_17_77 VPWR VGND VPWR VGND sky130_ef_sc_hd__decap_12
XFILLER_71_379 VGND VGND VPWR VPWR sky130_fd_sc_hd__decap_4
XFILLER_12_402 VGND VGND VPWR VPWR sky130_fd_sc_hd__decap_3
XFILLER_24_251 VGND VGND VPWR VPWR sky130_fd_sc_hd__fill_1
XFILLER_25_785 VPWR VGND VPWR VGND sky130_ef_sc_hd__decap_12
X_10790_ _03644_ _03645_ VGND VGND VPWR VPWR _03646_ sky130_fd_sc_hd__and2b_1
X_09449_ _02187_ _02188_ VGND VGND VPWR VPWR _02189_ sky130_fd_sc_hd__and2b_1
XFILLER_52_582 VGND VGND VPWR VPWR sky130_fd_sc_hd__decap_6
XFILLER_33_32 VGND VGND VPWR VPWR sky130_fd_sc_hd__decap_4
XTAP_TAPCELL_ROW_35_780 VGND VPWR sky130_fd_sc_hd__tapvpwrvgnd_1
XTAP_TAPCELL_ROW_35_791 VGND VPWR sky130_fd_sc_hd__tapvpwrvgnd_1
XFILLER_130_3 VPWR VGND VPWR VGND sky130_ef_sc_hd__decap_12
XFILLER_12_468 VGND VGND VPWR VPWR sky130_fd_sc_hd__decap_8
XFILLER_33_65 VGND VGND VPWR VPWR sky130_fd_sc_hd__fill_1
X_12460_ _05402_ _05463_ _05465_ VGND VGND VPWR VPWR _05466_ sky130_fd_sc_hd__and3_4
X_11411_ _04322_ _04323_ VGND VGND VPWR VPWR _04324_ sky130_fd_sc_hd__nor2_1
X_12391_ _05387_ _05389_ VGND VGND VPWR VPWR _05390_ sky130_fd_sc_hd__xnor2_1
XFILLER_126_805 VGND VGND VPWR VPWR sky130_fd_sc_hd__decap_6
XPHY_EDGE_ROW_49_Left_186 VGND VGND VPWR VPWR sky130_fd_sc_hd__decap_3
XFILLER_4_601 VPWR VGND VPWR VGND sky130_ef_sc_hd__decap_12
X_11342_ _04242_ _04248_ VGND VGND VPWR VPWR _04249_ sky130_fd_sc_hd__xnor2_1
XFILLER_20_490 VGND VGND VPWR VPWR sky130_fd_sc_hd__decap_8
XFILLER_125_337 VGND VGND VPWR VPWR sky130_fd_sc_hd__fill_2
XFILLER_3_111 VGND VGND VPWR VPWR sky130_fd_sc_hd__fill_1
XFILLER_4_645 VPWR VGND VPWR VGND sky130_ef_sc_hd__decap_12
X_11273_ net308 _04069_ _03946_ VGND VGND VPWR VPWR _04173_ sky130_fd_sc_hd__a21oi_1
X_10224_ _03017_ _03025_ _03024_ VGND VGND VPWR VPWR _03028_ sky130_fd_sc_hd__a21oi_1
X_13012_ _06066_ _06067_ VGND VGND VPWR VPWR _06069_ sky130_fd_sc_hd__xor2_1
XFILLER_79_457 VGND VGND VPWR VPWR sky130_fd_sc_hd__fill_2
X_10155_ _02950_ _02951_ net468 net574 VGND VGND VPWR VPWR _02952_ sky130_fd_sc_hd__and4bb_1
XFILLER_75_630 VGND VGND VPWR VPWR sky130_fd_sc_hd__decap_3
XFILLER_66_129 VGND VGND VPWR VPWR sky130_fd_sc_hd__fill_1
XPHY_EDGE_ROW_58_Left_195 VGND VGND VPWR VPWR sky130_fd_sc_hd__decap_3
X_10086_ _02842_ _02874_ _02875_ VGND VGND VPWR VPWR _02876_ sky130_fd_sc_hd__a21o_1
XFILLER_47_321 VGND VGND VPWR VPWR sky130_fd_sc_hd__fill_1
XTAP_TAPCELL_ROW_89_1542 VGND VPWR sky130_fd_sc_hd__tapvpwrvgnd_1
XFILLER_35_505 VPWR VGND VPWR VGND sky130_ef_sc_hd__decap_12
X_10988_ _03519_ _03716_ _03713_ VGND VGND VPWR VPWR _03862_ sky130_fd_sc_hd__a21oi_1
X_12727_ net359 net362 _05603_ _05602_ VGND VGND VPWR VPWR _05758_ sky130_fd_sc_hd__a31o_1
XFILLER_129_610 VGND VGND VPWR VPWR sky130_fd_sc_hd__decap_6
XFILLER_90_60 VGND VGND VPWR VPWR sky130_fd_sc_hd__fill_1
X_12658_ _05504_ _05510_ _05681_ VGND VGND VPWR VPWR _05682_ sky130_fd_sc_hd__a21oi_1
X_11609_ _04530_ _04539_ VGND VGND VPWR VPWR _04540_ sky130_fd_sc_hd__xnor2_1
XTAP_TAPCELL_ROW_13_474 VGND VPWR sky130_fd_sc_hd__tapvpwrvgnd_1
XFILLER_129_665 VGND VGND VPWR VPWR sky130_fd_sc_hd__decap_6
XFILLER_128_153 VPWR VGND VPWR VGND sky130_ef_sc_hd__decap_12
X_12589_ _05605_ _05606_ VGND VGND VPWR VPWR _05607_ sky130_fd_sc_hd__xnor2_1
XFILLER_98_722 VGND VGND VPWR VPWR sky130_fd_sc_hd__decap_3
XFILLER_124_392 VPWR VGND VPWR VGND sky130_ef_sc_hd__decap_12
XFILLER_97_232 VPWR VGND VPWR VGND sky130_ef_sc_hd__decap_12
X_08820_ net430 net735 net330 net328 VGND VGND VPWR VPWR _01547_ sky130_fd_sc_hd__and4_1
X_08751_ _01475_ _01476_ VGND VGND VPWR VPWR _01478_ sky130_fd_sc_hd__or2_1
XFILLER_100_738 VGND VGND VPWR VPWR sky130_fd_sc_hd__fill_2
XFILLER_97_287 VGND VGND VPWR VPWR sky130_fd_sc_hd__fill_1
XFILLER_85_449 VPWR VGND VPWR VGND sky130_ef_sc_hd__decap_12
XTAP_TAPCELL_ROW_127_2078 VGND VPWR sky130_fd_sc_hd__tapvpwrvgnd_1
X_07702_ net306 net570 net543 net316 VGND VGND VPWR VPWR _00441_ sky130_fd_sc_hd__a22oi_1
XTAP_TAPCELL_ROW_127_2067 VGND VPWR sky130_fd_sc_hd__tapvpwrvgnd_1
XFILLER_66_641 VGND VGND VPWR VPWR sky130_fd_sc_hd__decap_3
X_08682_ net788 net330 net328 net517 VGND VGND VPWR VPWR _01410_ sky130_fd_sc_hd__a22oi_1
X_07633_ _00366_ _00372_ VGND VGND VPWR VPWR _00373_ sky130_fd_sc_hd__or2_1
XFILLER_81_644 VGND VGND VPWR VPWR sky130_fd_sc_hd__decap_3
XFILLER_80_121 VGND VGND VPWR VPWR sky130_fd_sc_hd__fill_1
X_07564_ _06672_ _00302_ VGND VGND VPWR VPWR _00304_ sky130_fd_sc_hd__xor2_1
XFILLER_110_15 VPWR VGND VPWR VGND sky130_ef_sc_hd__decap_12
X_07495_ _00233_ _00232_ _00234_ VGND VGND VPWR VPWR _00236_ sky130_fd_sc_hd__a21o_1
X_09303_ _01866_ _01867_ _02027_ VGND VGND VPWR VPWR _02029_ sky130_fd_sc_hd__and3_1
X_09234_ _01956_ _01957_ VGND VGND VPWR VPWR _01958_ sky130_fd_sc_hd__nand2_1
XPHY_EDGE_ROW_3_Right_3 VGND VGND VPWR VPWR sky130_fd_sc_hd__decap_3
XFILLER_22_777 VPWR VGND VPWR VGND sky130_ef_sc_hd__decap_12
X_09165_ _01855_ _01856_ _01888_ _01889_ VGND VGND VPWR VPWR _01890_ sky130_fd_sc_hd__nor4_4
XFILLER_119_131 VGND VGND VPWR VPWR sky130_fd_sc_hd__fill_1
XFILLER_108_805 VGND VGND VPWR VPWR sky130_fd_sc_hd__decap_6
X_08116_ _00850_ _00851_ VGND VGND VPWR VPWR _00852_ sky130_fd_sc_hd__and2_1
XFILLER_119_57 VPWR VGND VPWR VGND sky130_ef_sc_hd__decap_12
XFILLER_107_337 VPWR VGND VPWR VGND sky130_ef_sc_hd__decap_12
X_09096_ net466 net161 VGND VGND VPWR VPWR _01821_ sky130_fd_sc_hd__and2b_1
X_08047_ _00582_ _00783_ VGND VGND VPWR VPWR _00784_ sky130_fd_sc_hd__xnor2_1
XFILLER_102_7 VPWR VGND VPWR VGND sky130_ef_sc_hd__decap_12
XFILLER_134_189 VGND VGND VPWR VPWR sky130_fd_sc_hd__decap_6
XFILLER_122_307 VGND VGND VPWR VPWR sky130_fd_sc_hd__fill_1
XTAP_TAPCELL_ROW_73_1321 VGND VPWR sky130_fd_sc_hd__tapvpwrvgnd_1
XTAP_TAPCELL_ROW_73_1310 VGND VPWR sky130_fd_sc_hd__tapvpwrvgnd_1
XFILLER_1_615 VGND VGND VPWR VPWR sky130_fd_sc_hd__fill_1
XFILLER_115_381 VGND VGND VPWR VPWR sky130_fd_sc_hd__fill_1
XFILLER_0_125 VPWR VGND VPWR VGND sky130_ef_sc_hd__decap_12
XFILLER_76_416 VGND VGND VPWR VPWR sky130_fd_sc_hd__decap_4
X_09998_ net531 net655 VGND VGND VPWR VPWR _02783_ sky130_fd_sc_hd__nand2_1
XFILLER_0_169 VPWR VGND VPWR VGND sky130_ef_sc_hd__decap_12
X_08949_ _01532_ _01534_ VGND VGND VPWR VPWR _01675_ sky130_fd_sc_hd__nand2_1
X_11960_ _04917_ _04918_ _04919_ VGND VGND VPWR VPWR _04920_ sky130_fd_sc_hd__or3_1
XFILLER_28_65 VPWR VGND VPWR VGND sky130_ef_sc_hd__decap_12
XFILLER_29_387 VGND VGND VPWR VPWR sky130_fd_sc_hd__decap_4
X_10911_ _03744_ _03776_ VGND VGND VPWR VPWR _03778_ sky130_fd_sc_hd__xnor2_1
X_11891_ _04647_ _04658_ _04838_ _04844_ VGND VGND VPWR VPWR _04845_ sky130_fd_sc_hd__a211oi_4
X_10842_ net615 net274 VGND VGND VPWR VPWR _03702_ sky130_fd_sc_hd__nand2_1
XTAP_TAPCELL_ROW_84_1472 VGND VPWR sky130_fd_sc_hd__tapvpwrvgnd_1
XFILLER_13_733 VPWR VGND VPWR VGND sky130_ef_sc_hd__decap_12
X_10773_ net512 net57 VGND VGND VPWR VPWR _03627_ sky130_fd_sc_hd__nand2b_1
XTAP_TAPCELL_ROW_30_709 VGND VPWR sky130_fd_sc_hd__tapvpwrvgnd_1
X_12512_ net542 net298 VGND VGND VPWR VPWR _05522_ sky130_fd_sc_hd__and2_1
XFILLER_100_70 VPWR VGND VPWR VGND sky130_ef_sc_hd__decap_12
XTAP_TAPCELL_ROW_10_433 VGND VPWR sky130_fd_sc_hd__tapvpwrvgnd_1
X_12443_ _05445_ _05446_ VGND VGND VPWR VPWR _05447_ sky130_fd_sc_hd__xnor2_1
XFILLER_126_635 VGND VGND VPWR VPWR sky130_fd_sc_hd__decap_8
X_12374_ _05369_ _05370_ VGND VGND VPWR VPWR _05371_ sky130_fd_sc_hd__xnor2_1
XFILLER_126_657 VPWR VGND VPWR VGND sky130_ef_sc_hd__decap_12
XFILLER_125_145 VPWR VGND VPWR VGND sky130_ef_sc_hd__decap_12
X_11325_ _04207_ _04228_ VGND VGND VPWR VPWR _04230_ sky130_fd_sc_hd__xor2_1
XFILLER_113_318 VPWR VGND VPWR VGND sky130_ef_sc_hd__decap_12
XFILLER_5_69 VPWR VGND VPWR VGND sky130_ef_sc_hd__decap_12
XFILLER_4_475 VGND VGND VPWR VPWR sky130_fd_sc_hd__fill_1
X_11256_ _04152_ _04153_ VGND VGND VPWR VPWR _04155_ sky130_fd_sc_hd__xor2_2
XFILLER_95_703 VGND VGND VPWR VPWR sky130_fd_sc_hd__decap_6
XFILLER_79_265 VGND VGND VPWR VPWR sky130_fd_sc_hd__fill_1
XFILLER_67_405 VPWR VGND VPWR VGND sky130_ef_sc_hd__decap_12
XPHY_EDGE_ROW_66_Left_203 VGND VGND VPWR VPWR sky130_fd_sc_hd__decap_3
X_10207_ _03004_ _03006_ _02966_ VGND VGND VPWR VPWR _03010_ sky130_fd_sc_hd__o21a_1
X_11187_ _04077_ _04078_ VGND VGND VPWR VPWR _04080_ sky130_fd_sc_hd__nor2_1
X_10138_ _02874_ _02931_ VGND VGND VPWR VPWR _02934_ sky130_fd_sc_hd__nor2_1
XFILLER_94_257 VGND VGND VPWR VPWR sky130_fd_sc_hd__decap_8
X_10069_ _02857_ _02858_ VGND VGND VPWR VPWR _02859_ sky130_fd_sc_hd__xnor2_1
XFILLER_82_419 VGND VGND VPWR VPWR sky130_fd_sc_hd__fill_1
XFILLER_75_471 VPWR VGND VPWR VGND sky130_ef_sc_hd__decap_12
XFILLER_63_611 VGND VGND VPWR VPWR sky130_fd_sc_hd__decap_4
XFILLER_48_696 VGND VGND VPWR VPWR sky130_fd_sc_hd__decap_4
XFILLER_63_633 VGND VGND VPWR VPWR sky130_fd_sc_hd__fill_1
XFILLER_62_110 VGND VGND VPWR VPWR sky130_fd_sc_hd__decap_4
XTAP_TAPCELL_ROW_18_544 VGND VPWR sky130_fd_sc_hd__tapvpwrvgnd_1
XPHY_EDGE_ROW_75_Left_212 VGND VGND VPWR VPWR sky130_fd_sc_hd__decap_3
XFILLER_93_3 VPWR VGND VPWR VGND sky130_ef_sc_hd__decap_12
X_07280_ net452 net604 _06568_ _06569_ VGND VGND VPWR VPWR _06571_ sky130_fd_sc_hd__nand4_1
XFILLER_129_440 VGND VGND VPWR VPWR sky130_fd_sc_hd__decap_8
XFILLER_129_473 VPWR VGND VPWR VGND sky130_ef_sc_hd__decap_12
XFILLER_8_781 VPWR VGND VPWR VGND sky130_ef_sc_hd__decap_12
X_09921_ _02687_ _02701_ VGND VGND VPWR VPWR _02702_ sky130_fd_sc_hd__xnor2_1
XFILLER_104_318 VPWR VGND VPWR VGND sky130_ef_sc_hd__decap_12
XFILLER_104_307 VGND VGND VPWR VPWR sky130_fd_sc_hd__fill_1
XFILLER_131_137 VPWR VGND VPWR VGND sky130_ef_sc_hd__decap_12
XPHY_EDGE_ROW_84_Left_221 VGND VGND VPWR VPWR sky130_fd_sc_hd__decap_3
XTAP_TAPCELL_ROW_129_2107 VGND VPWR sky130_fd_sc_hd__tapvpwrvgnd_1
X_09852_ _02625_ _02626_ VGND VGND VPWR VPWR _02627_ sky130_fd_sc_hd__and2b_1
XFILLER_58_405 VPWR VGND VPWR VGND sky130_ef_sc_hd__decap_12
XTAP_TAPCELL_ROW_55_1062 VGND VPWR sky130_fd_sc_hd__tapvpwrvgnd_1
XFILLER_112_395 VGND VGND VPWR VPWR sky130_fd_sc_hd__fill_2
XFILLER_105_26 VGND VGND VPWR VPWR sky130_fd_sc_hd__fill_2
X_09783_ _02419_ _02549_ VGND VGND VPWR VPWR _02551_ sky130_fd_sc_hd__xnor2_1
X_08803_ _01527_ _01528_ _01525_ VGND VGND VPWR VPWR _01530_ sky130_fd_sc_hd__o21ai_1
X_08734_ _01460_ _01459_ VGND VGND VPWR VPWR _01461_ sky130_fd_sc_hd__nand2b_1
X_06995_ _05429_ _05440_ _05451_ VGND VGND VPWR VPWR _05473_ sky130_fd_sc_hd__a21o_1
XFILLER_85_246 VGND VGND VPWR VPWR sky130_fd_sc_hd__decap_6
XFILLER_65_19 VPWR VGND VPWR VGND sky130_ef_sc_hd__decap_12
XFILLER_100_579 VGND VGND VPWR VPWR sky130_fd_sc_hd__decap_8
XFILLER_73_419 VGND VGND VPWR VPWR sky130_fd_sc_hd__fill_1
XFILLER_66_460 VPWR VGND VPWR VGND sky130_ef_sc_hd__decap_12
XFILLER_39_696 VPWR VGND VPWR VGND sky130_ef_sc_hd__decap_12
X_08665_ net455 net552 VGND VGND VPWR VPWR _01393_ sky130_fd_sc_hd__nand2_1
XFILLER_66_493 VGND VGND VPWR VPWR sky130_fd_sc_hd__fill_2
XFILLER_38_195 VGND VGND VPWR VPWR sky130_fd_sc_hd__fill_1
XFILLER_121_69 VPWR VGND VPWR VGND sky130_ef_sc_hd__decap_12
X_07616_ _00343_ _00355_ VGND VGND VPWR VPWR _00356_ sky130_fd_sc_hd__xnor2_1
XPHY_EDGE_ROW_93_Left_230 VGND VGND VPWR VPWR sky130_fd_sc_hd__decap_3
X_08596_ _01320_ _01324_ _01317_ _01315_ VGND VGND VPWR VPWR _01325_ sky130_fd_sc_hd__a211oi_4
XFILLER_54_688 VGND VGND VPWR VPWR sky130_fd_sc_hd__fill_1
XFILLER_41_305 VGND VGND VPWR VPWR sky130_fd_sc_hd__fill_1
X_07547_ _00165_ _00198_ _00197_ VGND VGND VPWR VPWR _00287_ sky130_fd_sc_hd__a21o_1
X_07478_ _00216_ _00217_ _06600_ _06602_ VGND VGND VPWR VPWR _00219_ sky130_fd_sc_hd__o211a_1
XFILLER_10_725 VPWR VGND VPWR VGND sky130_ef_sc_hd__decap_12
X_09217_ _01940_ VGND VGND VPWR VPWR _01941_ sky130_fd_sc_hd__inv_2
XFILLER_10_769 VPWR VGND VPWR VGND sky130_ef_sc_hd__decap_12
X_09148_ _01869_ _01870_ _01871_ VGND VGND VPWR VPWR _01873_ sky130_fd_sc_hd__a21o_1
XFILLER_5_217 VGND VGND VPWR VPWR sky130_fd_sc_hd__decap_6
XFILLER_108_657 VGND VGND VPWR VPWR sky130_fd_sc_hd__decap_3
X_09079_ _01675_ _01695_ _01694_ VGND VGND VPWR VPWR _01804_ sky130_fd_sc_hd__a21oi_1
XFILLER_107_156 VGND VGND VPWR VPWR sky130_fd_sc_hd__fill_1
X_11110_ _03994_ _03993_ VGND VGND VPWR VPWR _03996_ sky130_fd_sc_hd__nand2b_1
XFILLER_122_137 VGND VGND VPWR VPWR sky130_fd_sc_hd__decap_3
X_12090_ net446 net141 VGND VGND VPWR VPWR _05062_ sky130_fd_sc_hd__nand2_1
X_11041_ _03752_ _03916_ _03918_ VGND VGND VPWR VPWR _03920_ sky130_fd_sc_hd__nor3_1
XFILLER_131_671 VGND VGND VPWR VPWR sky130_fd_sc_hd__fill_1
XFILLER_39_53 VGND VGND VPWR VPWR sky130_fd_sc_hd__decap_3
XFILLER_92_706 VGND VGND VPWR VPWR sky130_fd_sc_hd__decap_3
XFILLER_76_257 VGND VGND VPWR VPWR sky130_fd_sc_hd__decap_4
XFILLER_39_97 VGND VGND VPWR VPWR sky130_fd_sc_hd__fill_1
XTAP_TAPCELL_ROW_86_1501 VGND VPWR sky130_fd_sc_hd__tapvpwrvgnd_1
X_12992_ _05668_ _05827_ _06046_ VGND VGND VPWR VPWR _06047_ sky130_fd_sc_hd__o21bai_2
XFILLER_91_238 VGND VGND VPWR VPWR sky130_fd_sc_hd__decap_3
XFILLER_84_290 VGND VGND VPWR VPWR sky130_fd_sc_hd__fill_2
X_11943_ net492 net676 VGND VGND VPWR VPWR _04901_ sky130_fd_sc_hd__and2_1
XFILLER_44_121 VGND VGND VPWR VPWR sky130_fd_sc_hd__fill_2
XFILLER_17_324 VGND VGND VPWR VPWR sky130_fd_sc_hd__decap_4
XFILLER_29_173 VGND VGND VPWR VPWR sky130_fd_sc_hd__fill_1
X_11874_ _04820_ net229 _04815_ _04816_ VGND VGND VPWR VPWR _04826_ sky130_fd_sc_hd__o211ai_4
XFILLER_55_74 VGND VGND VPWR VPWR sky130_fd_sc_hd__decap_8
XFILLER_45_677 VGND VGND VPWR VPWR sky130_fd_sc_hd__fill_1
X_10825_ _03333_ _03681_ _03682_ VGND VGND VPWR VPWR _03684_ sky130_fd_sc_hd__or3_4
XFILLER_44_187 VGND VGND VPWR VPWR sky130_fd_sc_hd__decap_8
XTAP_TAPCELL_ROW_15_503 VGND VPWR sky130_fd_sc_hd__tapvpwrvgnd_1
XFILLER_71_40 VPWR VGND VPWR VGND sky130_ef_sc_hd__decap_12
XFILLER_25_390 VGND VGND VPWR VPWR sky130_fd_sc_hd__fill_2
X_10756_ net450 net560 VGND VGND VPWR VPWR _03608_ sky130_fd_sc_hd__nand2_1
X_10687_ _03530_ _03531_ VGND VGND VPWR VPWR _03533_ sky130_fd_sc_hd__nand2_1
XFILLER_13_596 VPWR VGND VPWR VGND sky130_ef_sc_hd__decap_12
XFILLER_126_421 VPWR VGND VPWR VGND sky130_ef_sc_hd__decap_12
XTAP_TAPCELL_ROW_97_1652 VGND VPWR sky130_fd_sc_hd__tapvpwrvgnd_1
XFILLER_65_7 VPWR VGND VPWR VGND sky130_ef_sc_hd__decap_12
XFILLER_9_589 VPWR VGND VPWR VGND sky130_ef_sc_hd__decap_12
X_12426_ _05225_ _05427_ VGND VGND VPWR VPWR _05428_ sky130_fd_sc_hd__nand2_1
X_12357_ _05338_ _05351_ VGND VGND VPWR VPWR _05353_ sky130_fd_sc_hd__nand2_1
XFILLER_126_498 VPWR VGND VPWR VGND sky130_ef_sc_hd__decap_12
X_11308_ net826 _04211_ _04209_ VGND VGND VPWR VPWR _04212_ sky130_fd_sc_hd__a21oi_1
X_12288_ _05277_ _05275_ VGND VGND VPWR VPWR _05278_ sky130_fd_sc_hd__nand2b_1
X_11239_ _04133_ _04135_ VGND VGND VPWR VPWR _04137_ sky130_fd_sc_hd__xor2_1
XFILLER_122_682 VGND VGND VPWR VPWR sky130_fd_sc_hd__decap_8
XFILLER_95_511 VPWR VGND VPWR VGND sky130_ef_sc_hd__decap_12
XFILLER_121_181 VPWR VGND VPWR VGND sky130_ef_sc_hd__decap_12
XFILLER_83_706 VGND VGND VPWR VPWR sky130_fd_sc_hd__decap_4
XFILLER_67_257 VGND VGND VPWR VPWR sky130_fd_sc_hd__fill_2
XTAP_TAPCELL_ROW_124_2026 VGND VPWR sky130_fd_sc_hd__tapvpwrvgnd_1
X_06780_ _03107_ _03118_ VGND VGND VPWR VPWR _03129_ sky130_fd_sc_hd__nand2_1
XFILLER_82_216 VGND VGND VPWR VPWR sky130_fd_sc_hd__fill_1
XTAP_TAPCELL_ROW_124_2037 VGND VPWR sky130_fd_sc_hd__tapvpwrvgnd_1
XFILLER_35_110 VGND VGND VPWR VPWR sky130_fd_sc_hd__fill_2
X_08450_ _01176_ _01178_ VGND VGND VPWR VPWR _01179_ sky130_fd_sc_hd__or2_1
XFILLER_23_305 VGND VGND VPWR VPWR sky130_fd_sc_hd__fill_1
XFILLER_24_806 VGND VGND VPWR VPWR sky130_fd_sc_hd__fill_2
XFILLER_35_165 VGND VGND VPWR VPWR sky130_fd_sc_hd__decap_3
XTAP_TAPCELL_ROW_106_1781 VGND VPWR sky130_fd_sc_hd__tapvpwrvgnd_1
X_07401_ _06409_ _06554_ _06553_ VGND VGND VPWR VPWR _00142_ sky130_fd_sc_hd__o21bai_1
X_08381_ _01111_ VGND VGND VPWR VPWR _01112_ sky130_fd_sc_hd__inv_2
X_07332_ net73 net373 VGND VGND VPWR VPWR _06623_ sky130_fd_sc_hd__xor2_1
XFILLER_51_669 VGND VGND VPWR VPWR sky130_fd_sc_hd__decap_3
X_07263_ net684 net491 net484 net251 VGND VGND VPWR VPWR _06554_ sky130_fd_sc_hd__a22oi_1
XFILLER_31_393 VGND VGND VPWR VPWR sky130_fd_sc_hd__decap_6
X_07194_ _06484_ _06483_ _06431_ VGND VGND VPWR VPWR _06486_ sky130_fd_sc_hd__a21o_1
X_09002_ _01539_ _01567_ _01566_ VGND VGND VPWR VPWR _01728_ sky130_fd_sc_hd__a21bo_1
XTAP_TAPCELL_ROW_135_2188 VGND VPWR sky130_fd_sc_hd__tapvpwrvgnd_1
XFILLER_2_209 VPWR VGND VPWR VGND sky130_ef_sc_hd__decap_12
XFILLER_104_115 VGND VGND VPWR VPWR sky130_fd_sc_hd__fill_1
X_09904_ _02456_ _02582_ _02682_ VGND VGND VPWR VPWR _02683_ sky130_fd_sc_hd__a21oi_1
Xfanout502 net21 VGND VGND VPWR VPWR net502 sky130_fd_sc_hd__clkbuf_2
Xfanout513 net519 VGND VGND VPWR VPWR net513 sky130_fd_sc_hd__clkbuf_2
Xfanout524 net525 VGND VGND VPWR VPWR net524 sky130_fd_sc_hd__buf_2
Xfanout546 net547 VGND VGND VPWR VPWR net546 sky130_fd_sc_hd__clkbuf_4
X_09835_ _02575_ _02607_ VGND VGND VPWR VPWR _02608_ sky130_fd_sc_hd__and2b_1
XFILLER_98_371 VGND VGND VPWR VPWR sky130_fd_sc_hd__decap_4
Xfanout535 net536 VGND VGND VPWR VPWR net535 sky130_fd_sc_hd__clkbuf_4
XFILLER_86_533 VPWR VGND VPWR VGND sky130_ef_sc_hd__decap_12
XFILLER_86_522 VGND VGND VPWR VPWR sky130_fd_sc_hd__fill_1
Xfanout557 net154 VGND VGND VPWR VPWR net557 sky130_fd_sc_hd__clkbuf_4
XFILLER_76_29 VPWR VGND VPWR VGND sky130_ef_sc_hd__decap_12
XFILLER_58_213 VPWR VGND VPWR VGND sky130_ef_sc_hd__decap_12
XFILLER_100_321 VGND VGND VPWR VPWR sky130_fd_sc_hd__fill_1
XFILLER_86_555 VGND VGND VPWR VPWR sky130_fd_sc_hd__decap_6
Xfanout579 net580 VGND VGND VPWR VPWR net579 sky130_fd_sc_hd__buf_2
Xfanout568 net569 VGND VGND VPWR VPWR net568 sky130_fd_sc_hd__clkbuf_2
X_06978_ _03500_ _03543_ VGND VGND VPWR VPWR _05287_ sky130_fd_sc_hd__nor2_1
XFILLER_86_577 VGND VGND VPWR VPWR sky130_fd_sc_hd__fill_1
X_09766_ _02390_ _02393_ _02531_ VGND VGND VPWR VPWR _02532_ sky130_fd_sc_hd__o21ai_1
XFILLER_46_419 VGND VGND VPWR VPWR sky130_fd_sc_hd__fill_1
XFILLER_39_460 VGND VGND VPWR VPWR sky130_fd_sc_hd__decap_4
XFILLER_39_471 VPWR VGND VPWR VGND sky130_ef_sc_hd__decap_12
X_09697_ _02090_ _02245_ _02455_ VGND VGND VPWR VPWR _02458_ sky130_fd_sc_hd__or3b_1
X_08717_ _01340_ _01443_ _01444_ VGND VGND VPWR VPWR _01445_ sky130_fd_sc_hd__nand3_4
XFILLER_73_238 VGND VGND VPWR VPWR sky130_fd_sc_hd__decap_8
X_08648_ _01374_ _01375_ VGND VGND VPWR VPWR _01376_ sky130_fd_sc_hd__and2b_1
Xrebuffer40 _01262_ VGND VGND VPWR VPWR net740 sky130_fd_sc_hd__dlygate4sd1_1
XTAP_TAPCELL_ROW_68_1253 VGND VPWR sky130_fd_sc_hd__tapvpwrvgnd_1
XTAP_TAPCELL_ROW_68_1242 VGND VPWR sky130_fd_sc_hd__tapvpwrvgnd_1
Xrebuffer51 _03142_ VGND VGND VPWR VPWR net751 sky130_fd_sc_hd__buf_2
Xrebuffer73 _03681_ VGND VGND VPWR VPWR net773 sky130_fd_sc_hd__clkbuf_2
Xrebuffer84 net378 VGND VGND VPWR VPWR net784 sky130_fd_sc_hd__dlymetal6s2s_1
XFILLER_54_474 VGND VGND VPWR VPWR sky130_fd_sc_hd__fill_2
Xrebuffer95 net4 VGND VGND VPWR VPWR net795 sky130_fd_sc_hd__dlygate4sd1_1
XFILLER_41_113 VGND VGND VPWR VPWR sky130_fd_sc_hd__decap_6
X_08579_ _01146_ _01174_ VGND VGND VPWR VPWR _01308_ sky130_fd_sc_hd__and2_1
XTAP_TAPCELL_ROW_81_1431 VGND VPWR sky130_fd_sc_hd__tapvpwrvgnd_1
XFILLER_81_293 VGND VGND VPWR VPWR sky130_fd_sc_hd__decap_6
XFILLER_42_669 VPWR VGND VPWR VGND sky130_ef_sc_hd__decap_12
X_11590_ _04286_ _04412_ _04295_ _04414_ VGND VGND VPWR VPWR _04520_ sky130_fd_sc_hd__o31ai_4
X_10610_ net512 net345 _03287_ _03286_ VGND VGND VPWR VPWR _03449_ sky130_fd_sc_hd__a31o_1
X_10541_ _03363_ _03371_ VGND VGND VPWR VPWR _03373_ sky130_fd_sc_hd__xnor2_1
XFILLER_10_533 VGND VGND VPWR VPWR sky130_fd_sc_hd__fill_2
XTAP_TAPCELL_ROW_40_848 VGND VPWR sky130_fd_sc_hd__tapvpwrvgnd_1
XTAP_TAPCELL_ROW_40_859 VGND VPWR sky130_fd_sc_hd__tapvpwrvgnd_1
XFILLER_41_10 VGND VGND VPWR VPWR sky130_fd_sc_hd__fill_2
XFILLER_10_555 VGND VGND VPWR VPWR sky130_fd_sc_hd__decap_8
X_13260_ _06233_ _06240_ _06232_ VGND VGND VPWR VPWR _06338_ sky130_fd_sc_hd__a21o_1
XFILLER_108_421 VPWR VGND VPWR VGND sky130_ef_sc_hd__decap_12
X_10472_ _03294_ _03295_ _03296_ VGND VGND VPWR VPWR _03298_ sky130_fd_sc_hd__a21o_1
XTAP_TAPCELL_ROW_20_572 VGND VPWR sky130_fd_sc_hd__tapvpwrvgnd_1
X_12211_ net462 net581 _05192_ VGND VGND VPWR VPWR _05193_ sky130_fd_sc_hd__and3_1
XFILLER_41_76 VPWR VGND VPWR VGND sky130_ef_sc_hd__decap_12
XFILLER_136_785 VPWR VGND VPWR VGND sky130_ef_sc_hd__decap_12
Xrebuffer185 _01424_ VGND VGND VPWR VPWR net885 sky130_fd_sc_hd__buf_1
X_13191_ _06246_ _06262_ VGND VGND VPWR VPWR _06264_ sky130_fd_sc_hd__xnor2_1
XFILLER_135_273 VGND VGND VPWR VPWR sky130_fd_sc_hd__decap_6
XFILLER_123_435 VPWR VGND VPWR VGND sky130_ef_sc_hd__decap_12
X_12142_ _05116_ _05115_ _05024_ VGND VGND VPWR VPWR _05118_ sky130_fd_sc_hd__a21o_1
XTAP_TAPCELL_ROW_92_1582 VGND VPWR sky130_fd_sc_hd__tapvpwrvgnd_1
X_12073_ _05041_ _05042_ _04914_ VGND VGND VPWR VPWR _05043_ sky130_fd_sc_hd__a21oi_1
XFILLER_104_693 VGND VGND VPWR VPWR sky130_fd_sc_hd__fill_1
XFILLER_2_15 VPWR VGND VPWR VGND sky130_ef_sc_hd__decap_12
X_11024_ _03898_ _03899_ VGND VGND VPWR VPWR _03901_ sky130_fd_sc_hd__xnor2_1
XFILLER_106_80 VGND VGND VPWR VPWR sky130_fd_sc_hd__decap_4
XFILLER_103_181 VGND VGND VPWR VPWR sky130_fd_sc_hd__fill_2
XFILLER_49_268 VPWR VGND VPWR VGND sky130_ef_sc_hd__decap_12
XFILLER_92_558 VPWR VGND VPWR VGND sky130_ef_sc_hd__decap_12
XFILLER_17_110 VGND VGND VPWR VPWR sky130_fd_sc_hd__fill_2
XFILLER_17_121 VGND VGND VPWR VPWR sky130_fd_sc_hd__decap_4
X_12975_ _06015_ _06027_ VGND VGND VPWR VPWR _06028_ sky130_fd_sc_hd__xnor2_1
X_11926_ _04734_ _04880_ VGND VGND VPWR VPWR _04882_ sky130_fd_sc_hd__nor2_1
XFILLER_73_783 VGND VGND VPWR VPWR sky130_fd_sc_hd__fill_1
XFILLER_72_260 VGND VGND VPWR VPWR sky130_fd_sc_hd__fill_1
XTAP_TAPCELL_ROW_28_683 VGND VPWR sky130_fd_sc_hd__tapvpwrvgnd_1
XFILLER_32_113 VGND VGND VPWR VPWR sky130_fd_sc_hd__fill_2
XFILLER_60_433 VGND VGND VPWR VPWR sky130_fd_sc_hd__decap_8
X_11857_ _04628_ _04754_ VGND VGND VPWR VPWR _04808_ sky130_fd_sc_hd__nor2_1
XFILLER_21_809 VGND VGND VPWR VPWR sky130_fd_sc_hd__fill_2
X_11788_ _04722_ _04731_ VGND VGND VPWR VPWR _04732_ sky130_fd_sc_hd__xnor2_1
XFILLER_60_477 VGND VGND VPWR VPWR sky130_fd_sc_hd__decap_6
X_10808_ net236 _03662_ _03479_ _03481_ VGND VGND VPWR VPWR _03666_ sky130_fd_sc_hd__o211ai_2
XFILLER_119_708 VGND VGND VPWR VPWR sky130_fd_sc_hd__decap_3
X_10739_ net475 net654 VGND VGND VPWR VPWR _03590_ sky130_fd_sc_hd__nand2_4
XFILLER_127_741 VPWR VGND VPWR VGND sky130_ef_sc_hd__decap_12
XFILLER_127_785 VPWR VGND VPWR VGND sky130_ef_sc_hd__decap_12
XFILLER_126_251 VGND VGND VPWR VPWR sky130_fd_sc_hd__fill_1
X_13389_ clknet_3_0__leaf_clk _00012_ _00099_ VGND VGND VPWR VPWR net203 sky130_fd_sc_hd__dfrtp_1
XFILLER_56_3 VGND VGND VPWR VPWR sky130_fd_sc_hd__fill_2
X_12409_ net413 net405 net599 net588 VGND VGND VPWR VPWR _05410_ sky130_fd_sc_hd__nand4_1
XFILLER_114_435 VGND VGND VPWR VPWR sky130_fd_sc_hd__decap_8
XFILLER_99_135 VPWR VGND VPWR VGND sky130_ef_sc_hd__decap_12
XFILLER_99_113 VPWR VGND VPWR VGND sky130_ef_sc_hd__decap_12
X_07950_ _00658_ _00686_ VGND VGND VPWR VPWR _00688_ sky130_fd_sc_hd__xnor2_1
XFILLER_101_118 VGND VGND VPWR VPWR sky130_fd_sc_hd__fill_1
X_06901_ net613 net435 _04417_ _04428_ VGND VGND VPWR VPWR _04450_ sky130_fd_sc_hd__a22o_1
XTAP_TAPCELL_ROW_52_1021 VGND VPWR sky130_fd_sc_hd__tapvpwrvgnd_1
XFILLER_95_341 VGND VGND VPWR VPWR sky130_fd_sc_hd__fill_1
X_07881_ net381 net309 VGND VGND VPWR VPWR _00619_ sky130_fd_sc_hd__nand2_1
XFILLER_68_533 VGND VGND VPWR VPWR sky130_fd_sc_hd__fill_1
X_09620_ _02099_ _02259_ _02258_ VGND VGND VPWR VPWR _02374_ sky130_fd_sc_hd__a21oi_1
X_06832_ _03357_ _03686_ VGND VGND VPWR VPWR _03696_ sky130_fd_sc_hd__or2_1
XFILLER_28_419 VGND VGND VPWR VPWR sky130_fd_sc_hd__fill_1
XTAP_TAPCELL_ROW_108_1810 VGND VPWR sky130_fd_sc_hd__tapvpwrvgnd_1
X_06763_ _02555_ _02921_ _02932_ _02533_ VGND VGND VPWR VPWR _02943_ sky130_fd_sc_hd__o22a_1
X_09551_ _02290_ _02299_ VGND VGND VPWR VPWR _02300_ sky130_fd_sc_hd__xnor2_2
XFILLER_55_249 VGND VGND VPWR VPWR sky130_fd_sc_hd__decap_4
XFILLER_49_791 VGND VGND VPWR VPWR sky130_fd_sc_hd__decap_3
XFILLER_102_27 VGND VGND VPWR VPWR sky130_fd_sc_hd__fill_1
X_08502_ _01227_ _01229_ VGND VGND VPWR VPWR _01231_ sky130_fd_sc_hd__xor2_2
X_06694_ net97 VGND VGND VPWR VPWR _02197_ sky130_fd_sc_hd__inv_2
X_09482_ _01922_ _02067_ _02065_ VGND VGND VPWR VPWR _02225_ sky130_fd_sc_hd__a21boi_1
XFILLER_102_38 VGND VGND VPWR VPWR sky130_fd_sc_hd__decap_8
XFILLER_91_580 VGND VGND VPWR VPWR sky130_fd_sc_hd__fill_2
XFILLER_63_260 VGND VGND VPWR VPWR sky130_fd_sc_hd__decap_3
XFILLER_23_113 VPWR VGND VPWR VGND sky130_ef_sc_hd__decap_12
X_08433_ _01159_ _01160_ VGND VGND VPWR VPWR _01163_ sky130_fd_sc_hd__nand2_1
XFILLER_51_455 VPWR VGND VPWR VGND sky130_ef_sc_hd__decap_12
XFILLER_24_658 VGND VGND VPWR VPWR sky130_fd_sc_hd__fill_1
X_08364_ net517 net341 net338 net699 VGND VGND VPWR VPWR _01095_ sky130_fd_sc_hd__a22o_1
X_07315_ _06457_ _06604_ VGND VGND VPWR VPWR _06606_ sky130_fd_sc_hd__xor2_2
XTAP_TAPCELL_ROW_63_1183 VGND VPWR sky130_fd_sc_hd__tapvpwrvgnd_1
XTAP_TAPCELL_ROW_63_1172 VGND VPWR sky130_fd_sc_hd__tapvpwrvgnd_1
X_08295_ _00929_ _01029_ VGND VGND VPWR VPWR _01030_ sky130_fd_sc_hd__xnor2_1
XFILLER_118_741 VGND VGND VPWR VPWR sky130_fd_sc_hd__decap_4
XTAP_TAPCELL_ROW_119_1961 VGND VPWR sky130_fd_sc_hd__tapvpwrvgnd_1
X_07246_ _06531_ _06536_ VGND VGND VPWR VPWR _06537_ sky130_fd_sc_hd__xor2_1
XPHY_EDGE_ROW_12_Left_149 VGND VGND VPWR VPWR sky130_fd_sc_hd__decap_3
X_07177_ _05888_ _05910_ _05899_ VGND VGND VPWR VPWR _06469_ sky130_fd_sc_hd__o21bai_1
XFILLER_127_57 VPWR VGND VPWR VGND sky130_ef_sc_hd__decap_12
XFILLER_11_68 VPWR VGND VPWR VGND sky130_ef_sc_hd__decap_12
XFILLER_3_529 VPWR VGND VPWR VGND sky130_ef_sc_hd__decap_12
XFILLER_133_777 VGND VGND VPWR VPWR sky130_fd_sc_hd__decap_6
XFILLER_105_457 VGND VGND VPWR VPWR sky130_fd_sc_hd__decap_3
XFILLER_132_265 VGND VGND VPWR VPWR sky130_fd_sc_hd__decap_8
Xfanout321 net67 VGND VGND VPWR VPWR net321 sky130_fd_sc_hd__clkbuf_2
Xfanout310 net311 VGND VGND VPWR VPWR net310 sky130_fd_sc_hd__clkbuf_2
Xfanout332 net333 VGND VGND VPWR VPWR net332 sky130_fd_sc_hd__buf_6
XFILLER_120_449 VGND VGND VPWR VPWR sky130_fd_sc_hd__decap_4
XFILLER_113_490 VGND VGND VPWR VPWR sky130_fd_sc_hd__fill_2
Xfanout354 net355 VGND VGND VPWR VPWR net354 sky130_fd_sc_hd__buf_8
Xfanout343 net56 VGND VGND VPWR VPWR net343 sky130_fd_sc_hd__buf_2
Xfanout365 net46 VGND VGND VPWR VPWR net365 sky130_fd_sc_hd__buf_1
X_09818_ _02110_ _02470_ _02467_ VGND VGND VPWR VPWR _02590_ sky130_fd_sc_hd__o21ai_1
XFILLER_101_685 VPWR VGND VPWR VGND sky130_ef_sc_hd__decap_12
XFILLER_86_363 VGND VGND VPWR VPWR sky130_fd_sc_hd__fill_1
Xfanout398 net399 VGND VGND VPWR VPWR net398 sky130_fd_sc_hd__buf_4
Xfanout387 net36 VGND VGND VPWR VPWR net387 sky130_fd_sc_hd__buf_2
XFILLER_47_706 VPWR VGND VPWR VGND sky130_ef_sc_hd__decap_12
Xfanout376 net377 VGND VGND VPWR VPWR net376 sky130_fd_sc_hd__buf_4
XTAP_TAPCELL_ROW_6_378 VGND VPWR sky130_fd_sc_hd__tapvpwrvgnd_1
XPHY_EDGE_ROW_21_Left_158 VGND VGND VPWR VPWR sky130_fd_sc_hd__decap_3
XFILLER_74_547 VPWR VGND VPWR VGND sky130_ef_sc_hd__decap_12
X_09749_ net291 net325 _02208_ net314 VGND VGND VPWR VPWR _02514_ sky130_fd_sc_hd__o2bb2a_1
XFILLER_46_249 VGND VGND VPWR VPWR sky130_fd_sc_hd__decap_3
XFILLER_46_216 VGND VGND VPWR VPWR sky130_fd_sc_hd__decap_6
XTAP_TAPCELL_ROW_45_918 VGND VPWR sky130_fd_sc_hd__tapvpwrvgnd_1
XFILLER_15_603 VGND VGND VPWR VPWR sky130_fd_sc_hd__decap_8
XTAP_TAPCELL_ROW_45_929 VGND VPWR sky130_fd_sc_hd__tapvpwrvgnd_1
XFILLER_15_636 VPWR VGND VPWR VGND sky130_ef_sc_hd__decap_12
X_12760_ _05601_ _05635_ _05634_ VGND VGND VPWR VPWR _05794_ sky130_fd_sc_hd__a21bo_1
X_11711_ _04599_ _04646_ VGND VGND VPWR VPWR _04648_ sky130_fd_sc_hd__xor2_1
XTAP_TAPCELL_ROW_25_642 VGND VPWR sky130_fd_sc_hd__tapvpwrvgnd_1
X_12691_ net486 net662 VGND VGND VPWR VPWR _05718_ sky130_fd_sc_hd__nand2_1
X_11642_ _04573_ VGND VGND VPWR VPWR _04574_ sky130_fd_sc_hd__inv_2
XFILLER_42_477 VGND VGND VPWR VPWR sky130_fd_sc_hd__decap_4
X_13312_ net396 VGND VGND VPWR VPWR _00086_ sky130_fd_sc_hd__inv_2
Xinput18 in2[1] VGND VGND VPWR VPWR net18 sky130_fd_sc_hd__clkbuf_4
X_11573_ _04471_ _04499_ VGND VGND VPWR VPWR _04501_ sky130_fd_sc_hd__xnor2_1
XFILLER_10_352 VPWR VGND VPWR VGND sky130_ef_sc_hd__decap_12
XFILLER_6_301 VGND VGND VPWR VPWR sky130_fd_sc_hd__decap_6
XPHY_EDGE_ROW_30_Left_167 VGND VGND VPWR VPWR sky130_fd_sc_hd__decap_3
X_10524_ _03189_ _03191_ _03188_ VGND VGND VPWR VPWR _03354_ sky130_fd_sc_hd__o21ba_1
Xinput29 in3[4] VGND VGND VPWR VPWR net29 sky130_fd_sc_hd__buf_1
XFILLER_109_785 VPWR VGND VPWR VGND sky130_ef_sc_hd__decap_12
XTAP_TAPCELL_ROW_94_1611 VGND VPWR sky130_fd_sc_hd__tapvpwrvgnd_1
XFILLER_6_345 VPWR VGND VPWR VGND sky130_ef_sc_hd__decap_12
X_13243_ _06316_ _06318_ _06315_ VGND VGND VPWR VPWR _06319_ sky130_fd_sc_hd__o21ai_2
X_10455_ net409 net580 net343 net694 VGND VGND VPWR VPWR _03279_ sky130_fd_sc_hd__a22oi_1
XFILLER_136_582 VGND VGND VPWR VPWR sky130_fd_sc_hd__fill_2
XFILLER_123_210 VGND VGND VPWR VPWR sky130_fd_sc_hd__decap_3
XFILLER_6_389 VPWR VGND VPWR VGND sky130_ef_sc_hd__decap_12
X_13174_ _06138_ _06153_ _06152_ VGND VGND VPWR VPWR _06245_ sky130_fd_sc_hd__a21o_1
XFILLER_124_755 VGND VGND VPWR VPWR sky130_fd_sc_hd__fill_1
X_12125_ _05096_ _05097_ _05088_ VGND VGND VPWR VPWR _05099_ sky130_fd_sc_hd__a21o_1
X_10386_ net565 net281 VGND VGND VPWR VPWR _03204_ sky130_fd_sc_hd__nand2_1
XFILLER_42_9 VGND VGND VPWR VPWR sky130_fd_sc_hd__fill_2
XFILLER_96_105 VGND VGND VPWR VPWR sky130_fd_sc_hd__decap_3
XFILLER_111_449 VGND VGND VPWR VPWR sky130_fd_sc_hd__decap_8
X_12056_ _04984_ _05022_ VGND VGND VPWR VPWR _05024_ sky130_fd_sc_hd__xnor2_1
XFILLER_65_503 VGND VGND VPWR VPWR sky130_fd_sc_hd__fill_1
X_11007_ _03705_ _03711_ _03881_ VGND VGND VPWR VPWR _03883_ sky130_fd_sc_hd__a21oi_1
XFILLER_92_333 VPWR VGND VPWR VGND sky130_ef_sc_hd__decap_12
XFILLER_46_783 VPWR VGND VPWR VGND sky130_ef_sc_hd__decap_12
XFILLER_45_260 VGND VGND VPWR VPWR sky130_fd_sc_hd__fill_1
X_12958_ net478 net660 net658 net486 VGND VGND VPWR VPWR _06010_ sky130_fd_sc_hd__a22oi_1
XFILLER_33_411 VPWR VGND VPWR VGND sky130_ef_sc_hd__decap_12
XFILLER_61_764 VGND VGND VPWR VPWR sky130_fd_sc_hd__decap_8
X_11909_ _04679_ _04862_ VGND VGND VPWR VPWR _04864_ sky130_fd_sc_hd__or2_1
X_12889_ _05922_ _05934_ VGND VGND VPWR VPWR _05935_ sky130_fd_sc_hd__xnor2_1
XTAP_TAPCELL_ROW_103_1740 VGND VPWR sky130_fd_sc_hd__tapvpwrvgnd_1
XFILLER_33_477 VGND VGND VPWR VPWR sky130_fd_sc_hd__decap_8
XFILLER_20_138 VGND VGND VPWR VPWR sky130_fd_sc_hd__fill_2
XFILLER_119_505 VPWR VGND VPWR VGND sky130_ef_sc_hd__decap_12
X_07100_ _06382_ _06391_ VGND VGND VPWR VPWR _06392_ sky130_fd_sc_hd__xor2_1
X_08080_ _00578_ _00696_ _00695_ VGND VGND VPWR VPWR _00817_ sky130_fd_sc_hd__a21oi_1
XFILLER_9_172 VPWR VGND VPWR VGND sky130_ef_sc_hd__decap_12
XTAP_TAPCELL_ROW_132_2136 VGND VPWR sky130_fd_sc_hd__tapvpwrvgnd_1
X_07031_ _05844_ _05855_ VGND VGND VPWR VPWR _05866_ sky130_fd_sc_hd__nor2_1
XTAP_TAPCELL_ROW_132_2147 VGND VPWR sky130_fd_sc_hd__tapvpwrvgnd_1
XFILLER_127_593 VGND VGND VPWR VPWR sky130_fd_sc_hd__decap_4
XFILLER_115_766 VPWR VGND VPWR VGND sky130_ef_sc_hd__decap_12
XFILLER_88_617 VGND VGND VPWR VPWR sky130_fd_sc_hd__fill_1
XFILLER_130_725 VPWR VGND VPWR VGND sky130_ef_sc_hd__decap_12
XTAP_TAPCELL_ROW_114_1891 VGND VPWR sky130_fd_sc_hd__tapvpwrvgnd_1
XFILLER_114_276 VGND VGND VPWR VPWR sky130_fd_sc_hd__fill_1
XFILLER_88_639 VGND VGND VPWR VPWR sky130_fd_sc_hd__decap_4
X_08982_ net313 net338 _01706_ _01707_ VGND VGND VPWR VPWR _01708_ sky130_fd_sc_hd__o2bb2a_1
XFILLER_130_769 VPWR VGND VPWR VGND sky130_ef_sc_hd__decap_12
X_07933_ _00668_ _00670_ VGND VGND VPWR VPWR _00671_ sky130_fd_sc_hd__nor2_1
XFILLER_87_138 VGND VGND VPWR VPWR sky130_fd_sc_hd__fill_1
X_07864_ net249 _00600_ VGND VGND VPWR VPWR _00602_ sky130_fd_sc_hd__xnor2_1
XFILLER_96_650 VGND VGND VPWR VPWR sky130_fd_sc_hd__decap_8
XFILLER_113_15 VPWR VGND VPWR VGND sky130_ef_sc_hd__decap_12
X_06815_ _03434_ _03489_ VGND VGND VPWR VPWR _03510_ sky130_fd_sc_hd__xor2_1
X_09603_ _02162_ _02213_ _02212_ VGND VGND VPWR VPWR _02356_ sky130_fd_sc_hd__a21oi_2
XFILLER_56_536 VGND VGND VPWR VPWR sky130_fd_sc_hd__decap_6
XTAP_TAPCELL_ROW_3_337 VGND VPWR sky130_fd_sc_hd__tapvpwrvgnd_1
X_07795_ _00370_ _00371_ _00373_ VGND VGND VPWR VPWR _00534_ sky130_fd_sc_hd__o21ai_1
XFILLER_44_709 VPWR VGND VPWR VGND sky130_ef_sc_hd__decap_12
X_06746_ _02739_ _02750_ VGND VGND VPWR VPWR _02761_ sky130_fd_sc_hd__and2b_1
X_09534_ _02167_ _02280_ VGND VGND VPWR VPWR _02281_ sky130_fd_sc_hd__nor2_1
XTAP_TAPCELL_ROW_65_1201 VGND VPWR sky130_fd_sc_hd__tapvpwrvgnd_1
XFILLER_37_783 VGND VGND VPWR VPWR sky130_fd_sc_hd__fill_1
X_09465_ _02205_ _02192_ VGND VGND VPWR VPWR _02206_ sky130_fd_sc_hd__and2b_1
X_06677_ net695 VGND VGND VPWR VPWR _02011_ sky130_fd_sc_hd__clkinv_4
X_08416_ _01144_ _01145_ VGND VGND VPWR VPWR _01146_ sky130_fd_sc_hd__or2_1
XTAP_TAPCELL_ROW_22_601 VGND VPWR sky130_fd_sc_hd__tapvpwrvgnd_1
XFILLER_24_466 VGND VGND VPWR VPWR sky130_fd_sc_hd__decap_8
XFILLER_24_477 VGND VGND VPWR VPWR sky130_fd_sc_hd__decap_8
X_09396_ net502 net493 net626 net625 VGND VGND VPWR VPWR _02130_ sky130_fd_sc_hd__and4_1
XFILLER_51_274 VGND VGND VPWR VPWR sky130_fd_sc_hd__decap_6
X_08347_ _01041_ _01080_ VGND VGND VPWR VPWR _01081_ sky130_fd_sc_hd__xnor2_1
X_08278_ _01011_ _01012_ VGND VGND VPWR VPWR _01013_ sky130_fd_sc_hd__nand2_1
XTAP_TAPCELL_ROW_50_998 VGND VPWR sky130_fd_sc_hd__tapvpwrvgnd_1
X_07229_ _06517_ _06518_ VGND VGND VPWR VPWR _06520_ sky130_fd_sc_hd__xnor2_1
XFILLER_118_560 VPWR VGND VPWR VGND sky130_ef_sc_hd__decap_12
XFILLER_4_805 VGND VGND VPWR VPWR sky130_fd_sc_hd__decap_6
XFILLER_106_722 VGND VGND VPWR VPWR sky130_fd_sc_hd__decap_8
XFILLER_98_27 VGND VGND VPWR VPWR sky130_fd_sc_hd__fill_1
XTAP_TAPCELL_ROW_76_1352 VGND VPWR sky130_fd_sc_hd__tapvpwrvgnd_1
X_10240_ _03044_ _03045_ VGND VGND VPWR VPWR _03046_ sky130_fd_sc_hd__nor2_2
XFILLER_133_541 VPWR VGND VPWR VGND sky130_ef_sc_hd__decap_12
XFILLER_121_703 VGND VGND VPWR VPWR sky130_fd_sc_hd__fill_1
XTAP_TAPCELL_ROW_76_1363 VGND VPWR sky130_fd_sc_hd__tapvpwrvgnd_1
XFILLER_3_337 VPWR VGND VPWR VGND sky130_ef_sc_hd__decap_12
XFILLER_133_585 VPWR VGND VPWR VGND sky130_ef_sc_hd__decap_12
XFILLER_121_714 VPWR VGND VPWR VGND sky130_ef_sc_hd__decap_12
X_10171_ _02968_ _02969_ VGND VGND VPWR VPWR _02970_ sky130_fd_sc_hd__nor2_1
XFILLER_120_235 VPWR VGND VPWR VGND sky130_ef_sc_hd__decap_12
XPHY_EDGE_ROW_110_Right_110 VGND VGND VPWR VPWR sky130_fd_sc_hd__decap_3
XFILLER_78_149 VGND VGND VPWR VPWR sky130_fd_sc_hd__fill_1
XFILLER_59_330 VGND VGND VPWR VPWR sky130_fd_sc_hd__decap_6
XFILLER_120_279 VPWR VGND VPWR VGND sky130_ef_sc_hd__decap_12
XFILLER_93_108 VGND VGND VPWR VPWR sky130_fd_sc_hd__decap_4
XFILLER_59_352 VPWR VGND VPWR VGND sky130_ef_sc_hd__decap_12
XFILLER_101_482 VGND VGND VPWR VPWR sky130_fd_sc_hd__fill_2
XFILLER_74_377 VGND VGND VPWR VPWR sky130_fd_sc_hd__decap_4
XFILLER_62_528 VGND VGND VPWR VPWR sky130_fd_sc_hd__decap_4
XFILLER_43_720 VGND VGND VPWR VPWR sky130_fd_sc_hd__decap_8
XFILLER_15_400 VPWR VGND VPWR VGND sky130_ef_sc_hd__decap_12
X_12812_ _05845_ _05849_ VGND VGND VPWR VPWR _05850_ sky130_fd_sc_hd__nand2b_1
XFILLER_15_444 VGND VGND VPWR VPWR sky130_fd_sc_hd__decap_4
X_12743_ net413 net585 net583 net420 VGND VGND VPWR VPWR _05775_ sky130_fd_sc_hd__a22oi_1
XFILLER_70_550 VGND VGND VPWR VPWR sky130_fd_sc_hd__decap_8
XFILLER_70_583 VGND VGND VPWR VPWR sky130_fd_sc_hd__decap_4
X_12674_ _05697_ _05698_ VGND VGND VPWR VPWR _05699_ sky130_fd_sc_hd__or2_1
XFILLER_42_285 VGND VGND VPWR VPWR sky130_fd_sc_hd__fill_1
X_11625_ _04555_ _04556_ VGND VGND VPWR VPWR _04557_ sky130_fd_sc_hd__xnor2_1
X_11556_ _04208_ _04338_ _04120_ VGND VGND VPWR VPWR _04482_ sky130_fd_sc_hd__o21ai_1
X_10507_ _03202_ _03221_ _03219_ VGND VGND VPWR VPWR _03336_ sky130_fd_sc_hd__o21bai_1
XFILLER_7_665 VGND VGND VPWR VPWR sky130_fd_sc_hd__decap_6
XFILLER_6_153 VPWR VGND VPWR VGND sky130_ef_sc_hd__decap_12
X_13226_ _06300_ _06301_ VGND VGND VPWR VPWR _06302_ sky130_fd_sc_hd__and2b_1
X_11487_ _04164_ _04278_ _04277_ VGND VGND VPWR VPWR _04408_ sky130_fd_sc_hd__o21ba_1
XFILLER_124_541 VGND VGND VPWR VPWR sky130_fd_sc_hd__decap_3
X_10438_ _03256_ _03260_ VGND VGND VPWR VPWR _03261_ sky130_fd_sc_hd__xnor2_1
XFILLER_6_197 VPWR VGND VPWR VGND sky130_ef_sc_hd__decap_12
X_10369_ _02963_ _03108_ _03110_ VGND VGND VPWR VPWR _03186_ sky130_fd_sc_hd__o21bai_2
X_13157_ _06099_ _06223_ VGND VGND VPWR VPWR _06227_ sky130_fd_sc_hd__nand2_1
XFILLER_112_769 VPWR VGND VPWR VGND sky130_ef_sc_hd__decap_12
XFILLER_97_447 VGND VGND VPWR VPWR sky130_fd_sc_hd__fill_1
X_12108_ _05078_ _05080_ VGND VGND VPWR VPWR _05081_ sky130_fd_sc_hd__nor2_1
X_13088_ _06149_ _06151_ VGND VGND VPWR VPWR _06152_ sky130_fd_sc_hd__nor2_1
XFILLER_111_268 VPWR VGND VPWR VGND sky130_ef_sc_hd__decap_12
XFILLER_97_469 VPWR VGND VPWR VGND sky130_ef_sc_hd__decap_12
X_12039_ net569 net301 net299 net593 VGND VGND VPWR VPWR _05006_ sky130_fd_sc_hd__a22o_1
XFILLER_92_141 VPWR VGND VPWR VGND sky130_ef_sc_hd__decap_12
X_07580_ _00316_ _00317_ VGND VGND VPWR VPWR _00320_ sky130_fd_sc_hd__xor2_1
XFILLER_53_539 VPWR VGND VPWR VGND sky130_ef_sc_hd__decap_12
XFILLER_53_517 VPWR VGND VPWR VGND sky130_ef_sc_hd__decap_12
XFILLER_18_293 VGND VGND VPWR VPWR sky130_fd_sc_hd__fill_1
X_09250_ net479 net631 net629 VGND VGND VPWR VPWR _01974_ sky130_fd_sc_hd__nand3_2
XFILLER_61_561 VGND VGND VPWR VPWR sky130_fd_sc_hd__decap_8
X_08201_ _00818_ _00820_ _00936_ VGND VGND VPWR VPWR _00937_ sky130_fd_sc_hd__a21o_1
X_09181_ _01905_ _01903_ _01753_ VGND VGND VPWR VPWR _01906_ sky130_fd_sc_hd__and3_4
XTAP_TAPCELL_ROW_60_1131 VGND VPWR sky130_fd_sc_hd__tapvpwrvgnd_1
XFILLER_21_447 VGND VGND VPWR VPWR sky130_fd_sc_hd__fill_1
X_08132_ _00750_ _00867_ VGND VGND VPWR VPWR _00868_ sky130_fd_sc_hd__xor2_1
X_08063_ _00794_ _00799_ VGND VGND VPWR VPWR _00800_ sky130_fd_sc_hd__nand2_1
XTAP_TAPCELL_ROW_116_1920 VGND VPWR sky130_fd_sc_hd__tapvpwrvgnd_1
XFILLER_108_15 VPWR VGND VPWR VGND sky130_ef_sc_hd__decap_12
X_07014_ net611 net610 net435 net444 VGND VGND VPWR VPWR _05680_ sky130_fd_sc_hd__and4_1
XFILLER_127_390 VGND VGND VPWR VPWR sky130_fd_sc_hd__fill_2
XTAP_TAPCELL_ROW_8_407 VGND VPWR sky130_fd_sc_hd__tapvpwrvgnd_1
XFILLER_103_725 VGND VGND VPWR VPWR sky130_fd_sc_hd__decap_3
XFILLER_130_533 VPWR VGND VPWR VGND sky130_ef_sc_hd__decap_12
X_08965_ _01681_ _01689_ _01690_ VGND VGND VPWR VPWR _01691_ sky130_fd_sc_hd__nand3_1
X_07916_ _00640_ _00653_ VGND VGND VPWR VPWR _00654_ sky130_fd_sc_hd__xnor2_1
XTAP_TAPCELL_ROW_71_1282 VGND VPWR sky130_fd_sc_hd__tapvpwrvgnd_1
XFILLER_29_503 VGND VGND VPWR VPWR sky130_fd_sc_hd__fill_1
X_08896_ _01620_ _01621_ VGND VGND VPWR VPWR _01622_ sky130_fd_sc_hd__or2_1
XTAP_TAPCELL_ROW_71_1293 VGND VPWR sky130_fd_sc_hd__tapvpwrvgnd_1
XFILLER_68_182 VGND VGND VPWR VPWR sky130_fd_sc_hd__fill_2
XFILLER_29_525 VGND VGND VPWR VPWR sky130_fd_sc_hd__fill_1
X_07847_ net570 _00440_ _00443_ VGND VGND VPWR VPWR _00585_ sky130_fd_sc_hd__a21oi_1
XFILLER_84_642 VGND VGND VPWR VPWR sky130_fd_sc_hd__fill_2
X_07778_ _00516_ _00515_ VGND VGND VPWR VPWR _00517_ sky130_fd_sc_hd__and2b_1
X_09517_ _02135_ _02145_ _02143_ VGND VGND VPWR VPWR _02263_ sky130_fd_sc_hd__a21oi_1
X_06729_ _02533_ _02544_ _02566_ VGND VGND VPWR VPWR _02577_ sky130_fd_sc_hd__a21o_1
XFILLER_17_89 VGND VGND VPWR VPWR sky130_fd_sc_hd__fill_1
XFILLER_24_230 VGND VGND VPWR VPWR sky130_fd_sc_hd__decap_4
XFILLER_40_701 VPWR VGND VPWR VGND sky130_ef_sc_hd__decap_12
X_09448_ _02038_ _02049_ _02037_ VGND VGND VPWR VPWR _02188_ sky130_fd_sc_hd__a21bo_1
XFILLER_52_594 VPWR VGND VPWR VGND sky130_ef_sc_hd__decap_12
XFILLER_25_797 VGND VGND VPWR VPWR sky130_fd_sc_hd__decap_8
XTAP_TAPCELL_ROW_35_781 VGND VPWR sky130_fd_sc_hd__tapvpwrvgnd_1
X_09379_ _01969_ _01971_ _01968_ VGND VGND VPWR VPWR _02112_ sky130_fd_sc_hd__a21oi_1
XFILLER_12_458 VGND VGND VPWR VPWR sky130_fd_sc_hd__decap_4
XFILLER_33_55 VGND VGND VPWR VPWR sky130_fd_sc_hd__fill_1
X_11410_ _04179_ _04181_ _04321_ VGND VGND VPWR VPWR _04323_ sky130_fd_sc_hd__and3_1
X_12390_ net478 net676 VGND VGND VPWR VPWR _05389_ sky130_fd_sc_hd__nand2_4
XFILLER_123_3 VPWR VGND VPWR VGND sky130_ef_sc_hd__decap_12
XPHY_EDGE_ROW_104_Left_241 VGND VGND VPWR VPWR sky130_fd_sc_hd__decap_3
X_11341_ _04246_ _04247_ VGND VGND VPWR VPWR _04248_ sky130_fd_sc_hd__nand2_1
XFILLER_125_316 VGND VGND VPWR VPWR sky130_fd_sc_hd__fill_1
XFILLER_4_613 VPWR VGND VPWR VGND sky130_ef_sc_hd__decap_12
XFILLER_106_530 VGND VGND VPWR VPWR sky130_fd_sc_hd__fill_2
XFILLER_4_657 VPWR VGND VPWR VGND sky130_ef_sc_hd__decap_12
X_11272_ _03427_ _04081_ _04080_ VGND VGND VPWR VPWR _04172_ sky130_fd_sc_hd__o21bai_1
X_10223_ _02848_ _02881_ VGND VGND VPWR VPWR _03027_ sky130_fd_sc_hd__xor2_1
XFILLER_3_167 VGND VGND VPWR VPWR sky130_fd_sc_hd__fill_1
X_13011_ _06066_ _06067_ VGND VGND VPWR VPWR _06068_ sky130_fd_sc_hd__nand2b_1
XFILLER_133_393 VPWR VGND VPWR VGND sky130_ef_sc_hd__decap_12
X_10154_ net451 net578 net576 net459 VGND VGND VPWR VPWR _02951_ sky130_fd_sc_hd__a22oi_1
XFILLER_58_85 VGND VGND VPWR VPWR sky130_fd_sc_hd__decap_4
X_10085_ net520 net504 net656 net654 VGND VGND VPWR VPWR _02875_ sky130_fd_sc_hd__and4_1
XPHY_EDGE_ROW_113_Left_250 VGND VGND VPWR VPWR sky130_fd_sc_hd__decap_3
XTAP_TAPCELL_ROW_89_1543 VGND VPWR sky130_fd_sc_hd__tapvpwrvgnd_1
XFILLER_90_623 VGND VGND VPWR VPWR sky130_fd_sc_hd__fill_1
XFILLER_35_517 VPWR VGND VPWR VGND sky130_ef_sc_hd__decap_12
XFILLER_90_645 VPWR VGND VPWR VGND sky130_ef_sc_hd__decap_12
X_10987_ _03516_ _03694_ _03693_ VGND VGND VPWR VPWR _03861_ sky130_fd_sc_hd__a21o_1
XFILLER_43_561 VPWR VGND VPWR VGND sky130_ef_sc_hd__decap_12
XFILLER_16_753 VGND VGND VPWR VPWR sky130_fd_sc_hd__decap_3
X_12726_ net428 _02284_ _05623_ _05627_ VGND VGND VPWR VPWR _05756_ sky130_fd_sc_hd__o31ai_2
X_12657_ _05676_ _05679_ VGND VGND VPWR VPWR _05681_ sky130_fd_sc_hd__xnor2_1
XFILLER_128_121 VPWR VGND VPWR VGND sky130_ef_sc_hd__decap_12
XFILLER_90_83 VGND VGND VPWR VPWR sky130_fd_sc_hd__fill_1
X_11608_ _04531_ _04538_ VGND VGND VPWR VPWR _04539_ sky130_fd_sc_hd__xnor2_1
XTAP_TAPCELL_ROW_13_475 VGND VPWR sky130_fd_sc_hd__tapvpwrvgnd_1
XFILLER_11_480 VGND VGND VPWR VPWR sky130_fd_sc_hd__decap_4
X_12588_ net359 net362 VGND VGND VPWR VPWR _05606_ sky130_fd_sc_hd__nand2_1
XFILLER_116_327 VGND VGND VPWR VPWR sky130_fd_sc_hd__fill_2
X_11539_ _04443_ _04463_ VGND VGND VPWR VPWR _04464_ sky130_fd_sc_hd__xor2_1
XFILLER_7_462 VPWR VGND VPWR VGND sky130_ef_sc_hd__decap_12
X_13209_ _06011_ _06135_ _05524_ VGND VGND VPWR VPWR _06284_ sky130_fd_sc_hd__o21a_1
XFILLER_112_533 VGND VGND VPWR VPWR sky130_fd_sc_hd__fill_2
XFILLER_98_745 VGND VGND VPWR VPWR sky130_fd_sc_hd__decap_8
XFILLER_112_566 VGND VGND VPWR VPWR sky130_fd_sc_hd__decap_3
XTAP_TAPCELL_ROW_111_1850 VGND VPWR sky130_fd_sc_hd__tapvpwrvgnd_1
XFILLER_97_244 VGND VGND VPWR VPWR sky130_fd_sc_hd__fill_1
X_08750_ _01475_ _01476_ VGND VGND VPWR VPWR _01477_ sky130_fd_sc_hd__nand2_1
XTAP_TAPCELL_ROW_127_2079 VGND VPWR sky130_fd_sc_hd__tapvpwrvgnd_1
X_07701_ net316 net306 net543 VGND VGND VPWR VPWR _00440_ sky130_fd_sc_hd__and3_1
XTAP_TAPCELL_ROW_127_2068 VGND VPWR sky130_fd_sc_hd__tapvpwrvgnd_1
XFILLER_66_653 VGND VGND VPWR VPWR sky130_fd_sc_hd__decap_3
X_08681_ net517 net788 net330 net327 VGND VGND VPWR VPWR _01409_ sky130_fd_sc_hd__and4_1
XFILLER_65_130 VGND VGND VPWR VPWR sky130_fd_sc_hd__fill_1
XFILLER_38_355 VGND VGND VPWR VPWR sky130_fd_sc_hd__decap_4
X_07632_ _00370_ _00371_ VGND VGND VPWR VPWR _00372_ sky130_fd_sc_hd__xnor2_1
X_07563_ _00302_ VGND VGND VPWR VPWR _00303_ sky130_fd_sc_hd__inv_2
X_09302_ _01866_ _01867_ _02027_ VGND VGND VPWR VPWR _02028_ sky130_fd_sc_hd__a21oi_1
XFILLER_0_81 VGND VGND VPWR VPWR sky130_fd_sc_hd__decap_3
XFILLER_22_701 VGND VGND VPWR VPWR sky130_fd_sc_hd__decap_6
XFILLER_110_27 VGND VGND VPWR VPWR sky130_fd_sc_hd__fill_1
X_07494_ _00232_ _00233_ _00234_ VGND VGND VPWR VPWR _00235_ sky130_fd_sc_hd__nand3_1
XFILLER_22_734 VGND VGND VPWR VPWR sky130_fd_sc_hd__fill_1
X_09233_ _01778_ _01793_ _01792_ VGND VGND VPWR VPWR _01957_ sky130_fd_sc_hd__o21ai_2
XFILLER_61_391 VGND VGND VPWR VPWR sky130_fd_sc_hd__fill_1
XTAP_TAPCELL_ROW_32_740 VGND VPWR sky130_fd_sc_hd__tapvpwrvgnd_1
X_09164_ _01886_ _01887_ _01719_ _01721_ VGND VGND VPWR VPWR _01889_ sky130_fd_sc_hd__a211oi_2
XFILLER_22_789 VPWR VGND VPWR VGND sky130_ef_sc_hd__decap_12
X_08115_ _00644_ _00849_ VGND VGND VPWR VPWR _00851_ sky130_fd_sc_hd__or2_1
XFILLER_119_69 VPWR VGND VPWR VGND sky130_ef_sc_hd__decap_12
X_09095_ net423 net553 _01680_ _01678_ VGND VGND VPWR VPWR _01820_ sky130_fd_sc_hd__a31o_1
X_08046_ net305 net543 VGND VGND VPWR VPWR _00783_ sky130_fd_sc_hd__nand2_1
XFILLER_107_349 VGND VGND VPWR VPWR sky130_fd_sc_hd__fill_1
XTAP_TAPCELL_ROW_73_1322 VGND VPWR sky130_fd_sc_hd__tapvpwrvgnd_1
XTAP_TAPCELL_ROW_73_1311 VGND VPWR sky130_fd_sc_hd__tapvpwrvgnd_1
XFILLER_103_544 VPWR VGND VPWR VGND sky130_ef_sc_hd__decap_12
XFILLER_103_511 VGND VGND VPWR VPWR sky130_fd_sc_hd__fill_1
XFILLER_135_57 VPWR VGND VPWR VGND sky130_ef_sc_hd__decap_12
XFILLER_130_363 VGND VGND VPWR VPWR sky130_fd_sc_hd__fill_1
XFILLER_88_244 VGND VGND VPWR VPWR sky130_fd_sc_hd__fill_1
X_09997_ net694 net467 net352 net579 VGND VGND VPWR VPWR _02782_ sky130_fd_sc_hd__and4_1
XFILLER_0_137 VGND VGND VPWR VPWR sky130_fd_sc_hd__decap_3
X_08948_ _01639_ _01673_ VGND VGND VPWR VPWR _01674_ sky130_fd_sc_hd__xnor2_2
X_08879_ net545 net264 VGND VGND VPWR VPWR _01605_ sky130_fd_sc_hd__nand2_1
XFILLER_28_44 VGND VGND VPWR VPWR sky130_fd_sc_hd__fill_1
XFILLER_56_141 VGND VGND VPWR VPWR sky130_fd_sc_hd__fill_2
XFILLER_28_77 VGND VGND VPWR VPWR sky130_fd_sc_hd__decap_6
X_10910_ _03744_ _03776_ VGND VGND VPWR VPWR _03777_ sky130_fd_sc_hd__and2b_1
XFILLER_71_100 VGND VGND VPWR VPWR sky130_fd_sc_hd__fill_2
X_11890_ _04834_ _04837_ _04836_ VGND VGND VPWR VPWR _04844_ sky130_fd_sc_hd__a21oi_2
XFILLER_25_561 VPWR VGND VPWR VGND sky130_ef_sc_hd__decap_12
X_10841_ _03699_ _03700_ VGND VGND VPWR VPWR _03701_ sky130_fd_sc_hd__and2b_1
XTAP_TAPCELL_ROW_84_1473 VGND VPWR sky130_fd_sc_hd__tapvpwrvgnd_1
X_10772_ _03460_ _03462_ VGND VGND VPWR VPWR _03626_ sky130_fd_sc_hd__or2_1
XFILLER_52_391 VPWR VGND VPWR VGND sky130_ef_sc_hd__decap_12
XFILLER_13_745 VPWR VGND VPWR VGND sky130_ef_sc_hd__decap_12
X_12511_ _02022_ net657 _05368_ _05367_ VGND VGND VPWR VPWR _05521_ sky130_fd_sc_hd__a31o_1
XFILLER_40_531 VGND VGND VPWR VPWR sky130_fd_sc_hd__fill_1
XFILLER_100_82 VGND VGND VPWR VPWR sky130_fd_sc_hd__fill_2
X_12442_ net791 net363 VGND VGND VPWR VPWR _05446_ sky130_fd_sc_hd__nand2_1
XTAP_TAPCELL_ROW_10_434 VGND VPWR sky130_fd_sc_hd__tapvpwrvgnd_1
XFILLER_125_113 VPWR VGND VPWR VGND sky130_ef_sc_hd__decap_12
X_12373_ _02022_ net657 VGND VGND VPWR VPWR _05370_ sky130_fd_sc_hd__and2_1
XFILLER_126_669 VPWR VGND VPWR VGND sky130_ef_sc_hd__decap_12
XFILLER_99_509 VPWR VGND VPWR VGND sky130_ef_sc_hd__decap_12
XFILLER_5_15 VPWR VGND VPWR VGND sky130_ef_sc_hd__decap_12
XFILLER_4_421 VPWR VGND VPWR VGND sky130_ef_sc_hd__decap_12
X_11324_ _04228_ _04207_ VGND VGND VPWR VPWR _04229_ sky130_fd_sc_hd__and2b_1
XFILLER_125_157 VGND VGND VPWR VPWR sky130_fd_sc_hd__decap_8
XFILLER_109_80 VGND VGND VPWR VPWR sky130_fd_sc_hd__decap_4
XFILLER_69_40 VPWR VGND VPWR VGND sky130_ef_sc_hd__decap_12
X_11255_ _04152_ _04153_ VGND VGND VPWR VPWR _04154_ sky130_fd_sc_hd__nor2_1
X_10206_ _02966_ _03004_ _03006_ VGND VGND VPWR VPWR _03008_ sky130_fd_sc_hd__or3_4
XFILLER_133_190 VPWR VGND VPWR VGND sky130_ef_sc_hd__decap_12
XFILLER_121_330 VGND VGND VPWR VPWR sky130_fd_sc_hd__decap_6
X_11186_ net754 net342 VGND VGND VPWR VPWR _04078_ sky130_fd_sc_hd__nand2b_1
XFILLER_94_225 VPWR VGND VPWR VGND sky130_ef_sc_hd__decap_12
XFILLER_67_417 VPWR VGND VPWR VGND sky130_ef_sc_hd__decap_12
X_10137_ _02931_ VGND VGND VPWR VPWR _02933_ sky130_fd_sc_hd__inv_2
X_10068_ net268 net279 VGND VGND VPWR VPWR _02858_ sky130_fd_sc_hd__nand2_1
XFILLER_47_130 VGND VGND VPWR VPWR sky130_fd_sc_hd__decap_3
XPHY_EDGE_ROW_13_Right_13 VGND VGND VPWR VPWR sky130_fd_sc_hd__decap_3
XFILLER_35_314 VPWR VGND VPWR VGND sky130_ef_sc_hd__decap_12
XFILLER_75_494 VGND VGND VPWR VPWR sky130_fd_sc_hd__decap_8
XFILLER_75_483 VGND VGND VPWR VPWR sky130_fd_sc_hd__fill_1
XFILLER_62_122 VGND VGND VPWR VPWR sky130_fd_sc_hd__fill_2
XTAP_TAPCELL_ROW_18_545 VGND VPWR sky130_fd_sc_hd__tapvpwrvgnd_1
X_12709_ _05734_ _05736_ VGND VGND VPWR VPWR _05738_ sky130_fd_sc_hd__xnor2_1
XPHY_EDGE_ROW_22_Right_22 VGND VGND VPWR VPWR sky130_fd_sc_hd__decap_3
XFILLER_31_597 VGND VGND VPWR VPWR sky130_fd_sc_hd__fill_1
XFILLER_129_485 VPWR VGND VPWR VGND sky130_ef_sc_hd__decap_12
XFILLER_8_793 VPWR VGND VPWR VGND sky130_ef_sc_hd__decap_12
XFILLER_7_281 VPWR VGND VPWR VGND sky130_ef_sc_hd__decap_12
XFILLER_131_105 VGND VGND VPWR VPWR sky130_fd_sc_hd__decap_6
X_09920_ _02699_ _02700_ VGND VGND VPWR VPWR _02701_ sky130_fd_sc_hd__or2_1
XFILLER_98_531 VGND VGND VPWR VPWR sky130_fd_sc_hd__fill_1
XFILLER_131_149 VPWR VGND VPWR VGND sky130_ef_sc_hd__decap_12
X_09851_ _02492_ _02494_ _02624_ VGND VGND VPWR VPWR _02626_ sky130_fd_sc_hd__nand3_1
XTAP_TAPCELL_ROW_55_1063 VGND VPWR sky130_fd_sc_hd__tapvpwrvgnd_1
X_06994_ _05429_ _05440_ _05451_ VGND VGND VPWR VPWR _05462_ sky130_fd_sc_hd__and3_1
X_09782_ _02419_ _02549_ VGND VGND VPWR VPWR _02550_ sky130_fd_sc_hd__and2_1
XFILLER_85_225 VGND VGND VPWR VPWR sky130_fd_sc_hd__fill_2
X_08802_ _01525_ _01527_ _01528_ VGND VGND VPWR VPWR _01529_ sky130_fd_sc_hd__or3_1
XFILLER_58_417 VGND VGND VPWR VPWR sky130_fd_sc_hd__decap_3
XPHY_EDGE_ROW_31_Right_31 VGND VGND VPWR VPWR sky130_fd_sc_hd__decap_3
X_08733_ _01342_ _01344_ _01341_ VGND VGND VPWR VPWR _01460_ sky130_fd_sc_hd__o21ba_1
XFILLER_85_269 VGND VGND VPWR VPWR sky130_fd_sc_hd__fill_1
XFILLER_66_472 VGND VGND VPWR VPWR sky130_fd_sc_hd__decap_4
XFILLER_121_15 VPWR VGND VPWR VGND sky130_ef_sc_hd__decap_12
X_08664_ _01390_ _01391_ VGND VGND VPWR VPWR _01392_ sky130_fd_sc_hd__or2_1
XFILLER_54_645 VGND VGND VPWR VPWR sky130_fd_sc_hd__decap_8
XTAP_TAPCELL_ROW_37_810 VGND VPWR sky130_fd_sc_hd__tapvpwrvgnd_1
X_07615_ _00351_ _00352_ VGND VGND VPWR VPWR _00355_ sky130_fd_sc_hd__xnor2_1
X_08595_ _01320_ _01322_ _01323_ VGND VGND VPWR VPWR _01324_ sky130_fd_sc_hd__nand3_4
XFILLER_53_155 VGND VGND VPWR VPWR sky130_fd_sc_hd__fill_1
XFILLER_53_144 VGND VGND VPWR VPWR sky130_fd_sc_hd__fill_1
X_07546_ _00158_ _00160_ VGND VGND VPWR VPWR _00286_ sky130_fd_sc_hd__nand2_1
XFILLER_22_531 VGND VGND VPWR VPWR sky130_fd_sc_hd__fill_1
XFILLER_34_380 VGND VGND VPWR VPWR sky130_fd_sc_hd__fill_1
X_09216_ _01938_ _01939_ VGND VGND VPWR VPWR _01940_ sky130_fd_sc_hd__or2_1
X_07477_ _06600_ _06602_ _00216_ _00217_ VGND VGND VPWR VPWR _00218_ sky130_fd_sc_hd__a211oi_2
XFILLER_14_57 VGND VGND VPWR VPWR sky130_fd_sc_hd__fill_1
XFILLER_22_575 VPWR VGND VPWR VGND sky130_ef_sc_hd__decap_12
XPHY_EDGE_ROW_40_Right_40 VGND VGND VPWR VPWR sky130_fd_sc_hd__decap_3
XFILLER_10_737 VPWR VGND VPWR VGND sky130_ef_sc_hd__decap_12
XFILLER_108_603 VPWR VGND VPWR VGND sky130_ef_sc_hd__decap_12
X_09147_ _01869_ _01870_ _01871_ VGND VGND VPWR VPWR _01872_ sky130_fd_sc_hd__nand3_1
XFILLER_107_113 VGND VGND VPWR VPWR sky130_fd_sc_hd__decap_4
X_09078_ _01667_ _01669_ VGND VGND VPWR VPWR _01803_ sky130_fd_sc_hd__nand2_1
XFILLER_123_617 VPWR VGND VPWR VGND sky130_ef_sc_hd__decap_12
XFILLER_122_105 VGND VGND VPWR VPWR sky130_fd_sc_hd__decap_6
X_08029_ _00673_ _00679_ _00678_ VGND VGND VPWR VPWR _00766_ sky130_fd_sc_hd__a21oi_1
XFILLER_30_78 VGND VGND VPWR VPWR sky130_fd_sc_hd__decap_6
XFILLER_122_149 VGND VGND VPWR VPWR sky130_fd_sc_hd__decap_4
XFILLER_103_352 VGND VGND VPWR VPWR sky130_fd_sc_hd__decap_6
X_11040_ _03752_ _03916_ _03918_ VGND VGND VPWR VPWR _03919_ sky130_fd_sc_hd__o21a_1
XTAP_TAPCELL_ROW_86_1502 VGND VPWR sky130_fd_sc_hd__tapvpwrvgnd_1
X_12991_ _05825_ _06045_ VGND VGND VPWR VPWR _06046_ sky130_fd_sc_hd__xor2_1
XFILLER_55_42 VGND VGND VPWR VPWR sky130_fd_sc_hd__decap_8
X_11942_ net492 net677 VGND VGND VPWR VPWR _04900_ sky130_fd_sc_hd__nand2_1
X_11873_ _04822_ _04820_ _04823_ VGND VGND VPWR VPWR _04825_ sky130_fd_sc_hd__or3_4
XFILLER_55_86 VGND VGND VPWR VPWR sky130_fd_sc_hd__fill_1
X_10824_ _03333_ net773 net745 VGND VGND VPWR VPWR _03683_ sky130_fd_sc_hd__nor3_2
XTAP_TAPCELL_ROW_15_504 VGND VPWR sky130_fd_sc_hd__tapvpwrvgnd_1
XFILLER_71_52 VGND VGND VPWR VPWR sky130_fd_sc_hd__decap_4
XFILLER_9_513 VGND VGND VPWR VPWR sky130_fd_sc_hd__decap_3
X_10755_ _03605_ _03606_ VGND VGND VPWR VPWR _03607_ sky130_fd_sc_hd__and2b_1
XFILLER_9_557 VGND VGND VPWR VPWR sky130_fd_sc_hd__decap_3
X_10686_ _03519_ _03520_ _03529_ VGND VGND VPWR VPWR _03531_ sky130_fd_sc_hd__o21ai_1
X_12425_ _05231_ _05426_ VGND VGND VPWR VPWR _05427_ sky130_fd_sc_hd__xnor2_1
XFILLER_126_433 VPWR VGND VPWR VGND sky130_ef_sc_hd__decap_12
XTAP_TAPCELL_ROW_97_1653 VGND VPWR sky130_fd_sc_hd__tapvpwrvgnd_1
X_12356_ _05349_ _05350_ VGND VGND VPWR VPWR _05351_ sky130_fd_sc_hd__xnor2_1
XFILLER_5_741 VPWR VGND VPWR VGND sky130_ef_sc_hd__decap_12
XFILLER_126_477 VPWR VGND VPWR VGND sky130_ef_sc_hd__decap_12
XFILLER_99_306 VGND VGND VPWR VPWR sky130_fd_sc_hd__decap_8
XFILLER_4_251 VGND VGND VPWR VPWR sky130_fd_sc_hd__fill_1
X_11307_ net481 net647 net636 VGND VGND VPWR VPWR _04211_ sky130_fd_sc_hd__and3_2
XFILLER_113_116 VGND VGND VPWR VPWR sky130_fd_sc_hd__fill_1
X_12287_ _05083_ _05103_ _05102_ VGND VGND VPWR VPWR _05277_ sky130_fd_sc_hd__a21boi_1
XFILLER_5_785 VPWR VGND VPWR VGND sky130_ef_sc_hd__decap_12
X_11238_ _04133_ _04135_ VGND VGND VPWR VPWR _04136_ sky130_fd_sc_hd__nor2_1
XFILLER_95_523 VGND VGND VPWR VPWR sky130_fd_sc_hd__decap_8
XFILLER_67_225 VGND VGND VPWR VPWR sky130_fd_sc_hd__fill_2
X_11169_ _04055_ _04056_ VGND VGND VPWR VPWR _04060_ sky130_fd_sc_hd__xor2_1
XFILLER_121_193 VPWR VGND VPWR VGND sky130_ef_sc_hd__decap_12
XFILLER_96_93 VGND VGND VPWR VPWR sky130_fd_sc_hd__decap_4
XTAP_TAPCELL_ROW_124_2027 VGND VPWR sky130_fd_sc_hd__tapvpwrvgnd_1
XFILLER_76_781 VPWR VGND VPWR VGND sky130_ef_sc_hd__decap_12
XFILLER_48_472 VGND VGND VPWR VPWR sky130_fd_sc_hd__decap_4
XFILLER_48_450 VGND VGND VPWR VPWR sky130_fd_sc_hd__decap_6
XFILLER_36_667 VGND VGND VPWR VPWR sky130_fd_sc_hd__decap_3
XTAP_TAPCELL_ROW_106_1782 VGND VPWR sky130_fd_sc_hd__tapvpwrvgnd_1
X_07400_ _06556_ _06565_ _06564_ VGND VGND VPWR VPWR _00141_ sky130_fd_sc_hd__o21a_1
X_08380_ _01106_ _01107_ _01110_ VGND VGND VPWR VPWR _01111_ sky130_fd_sc_hd__a21o_1
X_07331_ net73 net373 VGND VGND VPWR VPWR _06622_ sky130_fd_sc_hd__and2_1
X_07262_ net251 net684 net491 net484 VGND VGND VPWR VPWR _06553_ sky130_fd_sc_hd__and4_1
XFILLER_129_260 VGND VGND VPWR VPWR sky130_fd_sc_hd__fill_1
X_07193_ _06431_ _06483_ net835 VGND VGND VPWR VPWR _06485_ sky130_fd_sc_hd__nand3_2
X_09001_ _01696_ _01725_ VGND VGND VPWR VPWR _01727_ sky130_fd_sc_hd__xnor2_1
XTAP_TAPCELL_ROW_135_2189 VGND VPWR sky130_fd_sc_hd__tapvpwrvgnd_1
XTAP_TAPCELL_ROW_135_2178 VGND VPWR sky130_fd_sc_hd__tapvpwrvgnd_1
XFILLER_117_477 VGND VGND VPWR VPWR sky130_fd_sc_hd__decap_4
XFILLER_116_15 VPWR VGND VPWR VGND sky130_ef_sc_hd__decap_12
X_09903_ _02680_ _02681_ VGND VGND VPWR VPWR _02682_ sky130_fd_sc_hd__or2_1
Xfanout514 net519 VGND VGND VPWR VPWR net514 sky130_fd_sc_hd__buf_2
Xfanout503 net511 VGND VGND VPWR VPWR net503 sky130_fd_sc_hd__buf_2
Xfanout547 net16 VGND VGND VPWR VPWR net547 sky130_fd_sc_hd__buf_4
X_09834_ _02576_ _02606_ VGND VGND VPWR VPWR _02607_ sky130_fd_sc_hd__xnor2_1
Xfanout525 net19 VGND VGND VPWR VPWR net525 sky130_fd_sc_hd__clkbuf_4
Xfanout536 net17 VGND VGND VPWR VPWR net536 sky130_fd_sc_hd__buf_2
XFILLER_86_545 VGND VGND VPWR VPWR sky130_fd_sc_hd__decap_6
Xfanout558 net154 VGND VGND VPWR VPWR net558 sky130_fd_sc_hd__clkbuf_2
XFILLER_58_225 VGND VGND VPWR VPWR sky130_fd_sc_hd__decap_8
Xfanout569 net15 VGND VGND VPWR VPWR net569 sky130_fd_sc_hd__clkbuf_4
X_06977_ _03773_ _05265_ VGND VGND VPWR VPWR _05276_ sky130_fd_sc_hd__xor2_1
X_09765_ _02529_ _02530_ VGND VGND VPWR VPWR _02531_ sky130_fd_sc_hd__and2b_1
XFILLER_73_206 VGND VGND VPWR VPWR sky130_fd_sc_hd__fill_1
X_09696_ _02090_ _02245_ _02455_ VGND VGND VPWR VPWR _02456_ sky130_fd_sc_hd__o21bai_2
X_08716_ net227 _01442_ _01313_ _01316_ VGND VGND VPWR VPWR _01444_ sky130_fd_sc_hd__o211ai_4
XFILLER_92_18 VGND VGND VPWR VPWR sky130_fd_sc_hd__decap_8
Xrebuffer30 _03043_ VGND VGND VPWR VPWR net730 sky130_fd_sc_hd__dlymetal6s2s_1
XFILLER_26_111 VGND VGND VPWR VPWR sky130_fd_sc_hd__fill_1
XFILLER_39_483 VGND VGND VPWR VPWR sky130_fd_sc_hd__decap_8
X_08647_ _01371_ _01372_ _01373_ VGND VGND VPWR VPWR _01375_ sky130_fd_sc_hd__a21o_1
Xrebuffer41 _01284_ VGND VGND VPWR VPWR net741 sky130_fd_sc_hd__buf_1
Xrebuffer52 net816 VGND VGND VPWR VPWR net752 sky130_fd_sc_hd__buf_1
XTAP_TAPCELL_ROW_68_1243 VGND VPWR sky130_fd_sc_hd__tapvpwrvgnd_1
Xrebuffer85 net784 VGND VGND VPWR VPWR net785 sky130_fd_sc_hd__dlymetal6s2s_1
Xrebuffer74 net234 VGND VGND VPWR VPWR net774 sky130_fd_sc_hd__buf_4
XFILLER_41_103 VGND VGND VPWR VPWR sky130_fd_sc_hd__decap_8
XTAP_TAPCELL_ROW_81_1432 VGND VPWR sky130_fd_sc_hd__tapvpwrvgnd_1
X_08578_ _01299_ _01305_ _01306_ VGND VGND VPWR VPWR _01307_ sky130_fd_sc_hd__and3_4
X_07529_ _00269_ _00267_ _06664_ VGND VGND VPWR VPWR _00270_ sky130_fd_sc_hd__and3_4
XFILLER_22_361 VGND VGND VPWR VPWR sky130_fd_sc_hd__decap_3
XFILLER_25_89 VGND VGND VPWR VPWR sky130_fd_sc_hd__fill_1
XFILLER_41_169 VPWR VGND VPWR VGND sky130_ef_sc_hd__decap_12
X_10540_ _03363_ _03371_ VGND VGND VPWR VPWR _03372_ sky130_fd_sc_hd__nand2_1
XFILLER_22_394 VGND VGND VPWR VPWR sky130_fd_sc_hd__decap_6
XTAP_TAPCELL_ROW_40_849 VGND VPWR sky130_fd_sc_hd__tapvpwrvgnd_1
XFILLER_127_219 VGND VGND VPWR VPWR sky130_fd_sc_hd__decap_4
Xrebuffer120 net818 VGND VGND VPWR VPWR net820 sky130_fd_sc_hd__dlygate4sd1_1
X_10471_ _03294_ _03295_ _03296_ VGND VGND VPWR VPWR _03297_ sky130_fd_sc_hd__nand3_1
XFILLER_136_720 VGND VGND VPWR VPWR sky130_fd_sc_hd__decap_8
XFILLER_108_433 VGND VGND VPWR VPWR sky130_fd_sc_hd__decap_6
Xrebuffer164 net902 VGND VGND VPWR VPWR net864 sky130_fd_sc_hd__clkbuf_2
XTAP_TAPCELL_ROW_20_573 VGND VPWR sky130_fd_sc_hd__tapvpwrvgnd_1
X_12210_ net471 net145 VGND VGND VPWR VPWR _05192_ sky130_fd_sc_hd__and2b_1
XFILLER_41_88 VPWR VGND VPWR VGND sky130_ef_sc_hd__decap_12
Xrebuffer186 _01908_ VGND VGND VPWR VPWR net886 sky130_fd_sc_hd__dlygate4sd1_1
XTAP_TAPCELL_ROW_79_1394 VGND VPWR sky130_fd_sc_hd__tapvpwrvgnd_1
Xrebuffer197 _03004_ VGND VGND VPWR VPWR net897 sky130_fd_sc_hd__clkbuf_2
X_13190_ _06246_ _06262_ VGND VGND VPWR VPWR _06263_ sky130_fd_sc_hd__and2b_1
XFILLER_136_797 VPWR VGND VPWR VGND sky130_ef_sc_hd__decap_12
X_12141_ _05024_ _05115_ _05116_ VGND VGND VPWR VPWR _05117_ sky130_fd_sc_hd__nand3_1
XFILLER_123_447 VGND VGND VPWR VPWR sky130_fd_sc_hd__fill_1
XFILLER_96_309 VGND VGND VPWR VPWR sky130_fd_sc_hd__decap_8
X_12072_ net250 _02262_ _04901_ VGND VGND VPWR VPWR _05042_ sky130_fd_sc_hd__or3b_4
XFILLER_2_755 VGND VGND VPWR VPWR sky130_fd_sc_hd__fill_1
XTAP_TAPCELL_ROW_92_1583 VGND VPWR sky130_fd_sc_hd__tapvpwrvgnd_1
X_11023_ _03898_ _03899_ VGND VGND VPWR VPWR _03900_ sky130_fd_sc_hd__or2_1
XFILLER_2_27 VGND VGND VPWR VPWR sky130_fd_sc_hd__fill_1
XFILLER_66_41 VGND VGND VPWR VPWR sky130_fd_sc_hd__fill_1
XFILLER_65_729 VGND VGND VPWR VPWR sky130_fd_sc_hd__decap_8
XFILLER_18_601 VPWR VGND VPWR VGND sky130_ef_sc_hd__decap_12
XFILLER_66_96 VGND VGND VPWR VPWR sky130_fd_sc_hd__decap_6
XFILLER_66_85 VGND VGND VPWR VPWR sky130_fd_sc_hd__decap_3
XFILLER_66_74 VGND VGND VPWR VPWR sky130_fd_sc_hd__decap_8
X_12974_ _06024_ _06025_ VGND VGND VPWR VPWR _06027_ sky130_fd_sc_hd__xor2_1
XFILLER_18_623 VPWR VGND VPWR VGND sky130_ef_sc_hd__decap_12
X_11925_ _04734_ _04880_ VGND VGND VPWR VPWR _04881_ sky130_fd_sc_hd__and2_1
XFILLER_17_133 VPWR VGND VPWR VGND sky130_ef_sc_hd__decap_12
XFILLER_60_401 VGND VGND VPWR VPWR sky130_fd_sc_hd__fill_1
XFILLER_45_497 VGND VGND VPWR VPWR sky130_fd_sc_hd__decap_6
XTAP_TAPCELL_ROW_28_684 VGND VPWR sky130_fd_sc_hd__tapvpwrvgnd_1
X_11856_ _04624_ net946 net729 VGND VGND VPWR VPWR _04806_ sky130_fd_sc_hd__nand3_2
X_11787_ _04727_ _04729_ VGND VGND VPWR VPWR _04731_ sky130_fd_sc_hd__xor2_1
XFILLER_60_489 VGND VGND VPWR VPWR sky130_fd_sc_hd__decap_6
X_10807_ _03663_ VGND VGND VPWR VPWR _03665_ sky130_fd_sc_hd__inv_2
XFILLER_41_670 VGND VGND VPWR VPWR sky130_fd_sc_hd__fill_2
X_10738_ net475 net654 VGND VGND VPWR VPWR _03589_ sky130_fd_sc_hd__and2_1
XFILLER_41_692 VGND VGND VPWR VPWR sky130_fd_sc_hd__decap_6
XFILLER_40_191 VGND VGND VPWR VPWR sky130_fd_sc_hd__decap_4
XFILLER_127_753 VPWR VGND VPWR VGND sky130_ef_sc_hd__decap_12
XPHY_EDGE_ROW_124_Right_124 VGND VGND VPWR VPWR sky130_fd_sc_hd__decap_3
X_10669_ _03385_ _03422_ _03420_ VGND VGND VPWR VPWR _03513_ sky130_fd_sc_hd__o21ba_1
X_12408_ _05406_ _05408_ VGND VGND VPWR VPWR _05409_ sky130_fd_sc_hd__xnor2_1
X_13388_ clknet_3_0__leaf_clk _00002_ _00098_ VGND VGND VPWR VPWR net202 sky130_fd_sc_hd__dfrtp_1
XFILLER_127_797 VPWR VGND VPWR VGND sky130_ef_sc_hd__decap_12
XFILLER_114_414 VGND VGND VPWR VPWR sky130_fd_sc_hd__decap_6
XFILLER_99_125 VGND VGND VPWR VPWR sky130_fd_sc_hd__decap_3
X_12339_ _05147_ _05156_ _05154_ VGND VGND VPWR VPWR _05333_ sky130_fd_sc_hd__a21bo_1
XFILLER_99_169 VPWR VGND VPWR VGND sky130_ef_sc_hd__decap_12
XFILLER_99_147 VPWR VGND VPWR VGND sky130_ef_sc_hd__decap_12
X_06900_ net613 net435 _04417_ _04428_ VGND VGND VPWR VPWR _04439_ sky130_fd_sc_hd__nand4_2
XTAP_TAPCELL_ROW_52_1022 VGND VPWR sky130_fd_sc_hd__tapvpwrvgnd_1
XFILLER_110_620 VPWR VGND VPWR VGND sky130_ef_sc_hd__decap_12
XFILLER_95_331 VGND VGND VPWR VPWR sky130_fd_sc_hd__decap_4
X_07880_ _00616_ _00617_ VGND VGND VPWR VPWR _00618_ sky130_fd_sc_hd__nor2_1
X_06831_ _03107_ _03587_ VGND VGND VPWR VPWR _03686_ sky130_fd_sc_hd__xnor2_1
XTAP_TAPCELL_ROW_108_1800 VGND VPWR sky130_fd_sc_hd__tapvpwrvgnd_1
XFILLER_49_770 VGND VGND VPWR VPWR sky130_fd_sc_hd__fill_2
XFILLER_110_697 VGND VGND VPWR VPWR sky130_fd_sc_hd__decap_3
XTAP_TAPCELL_ROW_108_1811 VGND VPWR sky130_fd_sc_hd__tapvpwrvgnd_1
X_06762_ net251 net521 VGND VGND VPWR VPWR _02932_ sky130_fd_sc_hd__nand2_1
X_09550_ _02291_ _02297_ VGND VGND VPWR VPWR _02299_ sky130_fd_sc_hd__xor2_2
X_09481_ _02085_ _02223_ VGND VGND VPWR VPWR _02224_ sky130_fd_sc_hd__xnor2_1
X_08501_ _01227_ _01229_ VGND VGND VPWR VPWR _01230_ sky130_fd_sc_hd__and2b_1
XFILLER_83_559 VGND VGND VPWR VPWR sky130_fd_sc_hd__fill_1
XFILLER_70_209 VPWR VGND VPWR VGND sky130_ef_sc_hd__decap_12
XFILLER_36_453 VGND VGND VPWR VPWR sky130_fd_sc_hd__fill_1
X_06693_ net634 VGND VGND VPWR VPWR _02186_ sky130_fd_sc_hd__inv_2
X_08432_ _01161_ VGND VGND VPWR VPWR _01162_ sky130_fd_sc_hd__inv_2
XFILLER_64_795 VGND VGND VPWR VPWR sky130_fd_sc_hd__fill_1
XFILLER_36_486 VPWR VGND VPWR VGND sky130_ef_sc_hd__decap_12
XFILLER_23_125 VGND VGND VPWR VPWR sky130_fd_sc_hd__decap_8
X_08363_ _01093_ _01094_ VGND VGND VPWR VPWR _00009_ sky130_fd_sc_hd__and2_1
XFILLER_51_467 VPWR VGND VPWR VGND sky130_ef_sc_hd__decap_12
XFILLER_11_309 VGND VGND VPWR VPWR sky130_fd_sc_hd__decap_6
X_08294_ _01026_ _01027_ VGND VGND VPWR VPWR _01029_ sky130_fd_sc_hd__xnor2_1
X_07314_ _06457_ _06604_ VGND VGND VPWR VPWR _06605_ sky130_fd_sc_hd__nor2_1
XTAP_TAPCELL_ROW_63_1173 VGND VPWR sky130_fd_sc_hd__tapvpwrvgnd_1
X_07245_ _06534_ _06535_ VGND VGND VPWR VPWR _06536_ sky130_fd_sc_hd__xnor2_1
XTAP_TAPCELL_ROW_119_1962 VGND VPWR sky130_fd_sc_hd__tapvpwrvgnd_1
XFILLER_118_753 VGND VGND VPWR VPWR sky130_fd_sc_hd__decap_3
XFILLER_117_241 VGND VGND VPWR VPWR sky130_fd_sc_hd__decap_8
X_07176_ _06465_ _06466_ _06464_ VGND VGND VPWR VPWR _06468_ sky130_fd_sc_hd__o21ai_1
XFILLER_132_200 VPWR VGND VPWR VGND sky130_ef_sc_hd__decap_12
XFILLER_117_263 VPWR VGND VPWR VGND sky130_ef_sc_hd__decap_12
XFILLER_105_403 VGND VGND VPWR VPWR sky130_fd_sc_hd__decap_3
XFILLER_127_69 VPWR VGND VPWR VGND sky130_ef_sc_hd__decap_12
XFILLER_78_309 VPWR VGND VPWR VGND sky130_ef_sc_hd__decap_12
Xfanout322 net66 VGND VGND VPWR VPWR net322 sky130_fd_sc_hd__buf_2
XFILLER_99_681 VGND VGND VPWR VPWR sky130_fd_sc_hd__fill_1
XFILLER_99_670 VGND VGND VPWR VPWR sky130_fd_sc_hd__fill_2
Xfanout311 net7 VGND VGND VPWR VPWR net311 sky130_fd_sc_hd__clkbuf_4
Xfanout300 net75 VGND VGND VPWR VPWR net300 sky130_fd_sc_hd__clkbuf_2
XFILLER_59_545 VGND VGND VPWR VPWR sky130_fd_sc_hd__fill_1
Xfanout355 net356 VGND VGND VPWR VPWR net355 sky130_fd_sc_hd__buf_8
Xfanout333 net337 VGND VGND VPWR VPWR net333 sky130_fd_sc_hd__buf_8
Xfanout366 net45 VGND VGND VPWR VPWR net366 sky130_fd_sc_hd__buf_2
Xfanout344 net55 VGND VGND VPWR VPWR net344 sky130_fd_sc_hd__buf_2
X_09817_ _02451_ _02587_ VGND VGND VPWR VPWR _02589_ sky130_fd_sc_hd__xnor2_1
XFILLER_100_141 VPWR VGND VPWR VGND sky130_ef_sc_hd__decap_12
Xfanout399 net33 VGND VGND VPWR VPWR net399 sky130_fd_sc_hd__clkbuf_8
Xfanout388 net389 VGND VGND VPWR VPWR net388 sky130_fd_sc_hd__buf_6
XFILLER_47_729 VGND VGND VPWR VPWR sky130_fd_sc_hd__decap_8
XFILLER_47_718 VGND VGND VPWR VPWR sky130_fd_sc_hd__decap_8
XTAP_TAPCELL_ROW_6_379 VGND VPWR sky130_fd_sc_hd__tapvpwrvgnd_1
Xfanout377 net4 VGND VGND VPWR VPWR net377 sky130_fd_sc_hd__buf_8
XFILLER_101_697 VPWR VGND VPWR VGND sky130_ef_sc_hd__decap_12
X_09748_ _02167_ _02283_ VGND VGND VPWR VPWR _02513_ sky130_fd_sc_hd__or2_2
XFILLER_46_239 VGND VGND VPWR VPWR sky130_fd_sc_hd__decap_3
XFILLER_74_559 VPWR VGND VPWR VGND sky130_ef_sc_hd__decap_12
XFILLER_55_751 VGND VGND VPWR VPWR sky130_fd_sc_hd__fill_1
XTAP_TAPCELL_ROW_45_919 VGND VPWR sky130_fd_sc_hd__tapvpwrvgnd_1
XFILLER_27_442 VGND VGND VPWR VPWR sky130_fd_sc_hd__fill_2
XFILLER_27_453 VGND VGND VPWR VPWR sky130_fd_sc_hd__fill_1
X_09679_ _02436_ _02437_ VGND VGND VPWR VPWR _02438_ sky130_fd_sc_hd__xnor2_1
X_11710_ _04599_ _04646_ VGND VGND VPWR VPWR _04647_ sky130_fd_sc_hd__nand2b_1
XFILLER_27_464 VGND VGND VPWR VPWR sky130_fd_sc_hd__decap_8
XFILLER_15_648 VGND VGND VPWR VPWR sky130_fd_sc_hd__decap_8
XTAP_TAPCELL_ROW_25_643 VGND VPWR sky130_fd_sc_hd__tapvpwrvgnd_1
X_12690_ _05552_ _05716_ VGND VGND VPWR VPWR _05717_ sky130_fd_sc_hd__nor2_1
X_11641_ net698 net371 net600 net471 VGND VGND VPWR VPWR _04573_ sky130_fd_sc_hd__a22o_1
XFILLER_42_467 VGND VGND VPWR VPWR sky130_fd_sc_hd__decap_8
X_11572_ _04471_ _04499_ VGND VGND VPWR VPWR _04500_ sky130_fd_sc_hd__and2b_1
X_13311_ net396 VGND VGND VPWR VPWR _00085_ sky130_fd_sc_hd__inv_2
X_10523_ _03204_ _03352_ VGND VGND VPWR VPWR _03353_ sky130_fd_sc_hd__xnor2_2
Xinput19 in2[2] VGND VGND VPWR VPWR net19 sky130_fd_sc_hd__buf_1
XFILLER_128_539 VGND VGND VPWR VPWR sky130_fd_sc_hd__decap_8
XFILLER_109_742 VPWR VGND VPWR VGND sky130_ef_sc_hd__decap_12
XFILLER_136_561 VGND VGND VPWR VPWR sky130_fd_sc_hd__fill_2
XFILLER_124_701 VPWR VGND VPWR VGND sky130_ef_sc_hd__decap_12
XTAP_TAPCELL_ROW_94_1612 VGND VPWR sky130_fd_sc_hd__tapvpwrvgnd_1
X_10454_ _03133_ _03135_ _03134_ VGND VGND VPWR VPWR _03278_ sky130_fd_sc_hd__o21ba_1
XFILLER_6_357 VGND VGND VPWR VPWR sky130_fd_sc_hd__decap_6
X_13242_ _06316_ _06318_ VGND VGND VPWR VPWR _00030_ sky130_fd_sc_hd__xor2_1
XFILLER_109_797 VPWR VGND VPWR VGND sky130_ef_sc_hd__decap_12
XFILLER_108_263 VGND VGND VPWR VPWR sky130_fd_sc_hd__decap_4
X_10385_ net531 net648 _03097_ _03095_ VGND VGND VPWR VPWR _03203_ sky130_fd_sc_hd__a31o_1
X_13173_ _06241_ _06242_ VGND VGND VPWR VPWR _06244_ sky130_fd_sc_hd__xor2_1
X_12124_ _05088_ _05096_ _05097_ VGND VGND VPWR VPWR _05098_ sky130_fd_sc_hd__nand3_1
XFILLER_96_128 VPWR VGND VPWR VGND sky130_ef_sc_hd__decap_12
XFILLER_89_191 VPWR VGND VPWR VGND sky130_ef_sc_hd__decap_12
X_12055_ _05022_ _04984_ VGND VGND VPWR VPWR _05023_ sky130_fd_sc_hd__and2b_1
X_11006_ _03877_ _03880_ VGND VGND VPWR VPWR _03881_ sky130_fd_sc_hd__xnor2_1
XFILLER_92_345 VGND VGND VPWR VPWR sky130_fd_sc_hd__decap_8
XFILLER_46_795 VGND VGND VPWR VPWR sky130_fd_sc_hd__decap_6
XFILLER_18_475 VGND VGND VPWR VPWR sky130_fd_sc_hd__fill_1
X_12957_ net662 _05552_ _05716_ _05916_ VGND VGND VPWR VPWR _06009_ sky130_fd_sc_hd__a22o_2
XTAP_TAPCELL_ROW_103_1730 VGND VPWR sky130_fd_sc_hd__tapvpwrvgnd_1
XFILLER_93_94 VGND VGND VPWR VPWR sky130_fd_sc_hd__decap_3
X_11908_ _04679_ _04862_ VGND VGND VPWR VPWR _04863_ sky130_fd_sc_hd__nand2_1
X_12888_ _05930_ _05931_ VGND VGND VPWR VPWR _05934_ sky130_fd_sc_hd__xor2_1
XFILLER_33_423 VGND VGND VPWR VPWR sky130_fd_sc_hd__decap_4
XFILLER_33_434 VGND VGND VPWR VPWR sky130_fd_sc_hd__fill_2
XTAP_TAPCELL_ROW_103_1741 VGND VPWR sky130_fd_sc_hd__tapvpwrvgnd_1
XFILLER_60_253 VGND VGND VPWR VPWR sky130_fd_sc_hd__decap_6
X_11839_ _04778_ _04779_ _04786_ VGND VGND VPWR VPWR _04788_ sky130_fd_sc_hd__a21o_1
XFILLER_21_607 VGND VGND VPWR VPWR sky130_fd_sc_hd__decap_8
XFILLER_33_456 VGND VGND VPWR VPWR sky130_fd_sc_hd__decap_6
XFILLER_20_128 VGND VGND VPWR VPWR sky130_fd_sc_hd__fill_1
XFILLER_119_517 VGND VGND VPWR VPWR sky130_fd_sc_hd__decap_4
XFILLER_9_151 VPWR VGND VPWR VGND sky130_ef_sc_hd__decap_12
XFILLER_9_184 VGND VGND VPWR VPWR sky130_fd_sc_hd__fill_1
XTAP_TAPCELL_ROW_132_2137 VGND VPWR sky130_fd_sc_hd__tapvpwrvgnd_1
X_07030_ net743 net386 net384 net514 VGND VGND VPWR VPWR _05855_ sky130_fd_sc_hd__a22oi_1
XTAP_TAPCELL_ROW_132_2148 VGND VPWR sky130_fd_sc_hd__tapvpwrvgnd_1
XFILLER_115_778 VGND VGND VPWR VPWR sky130_fd_sc_hd__decap_6
XFILLER_115_745 VGND VGND VPWR VPWR sky130_fd_sc_hd__fill_2
XFILLER_130_737 VPWR VGND VPWR VGND sky130_ef_sc_hd__decap_12
XTAP_TAPCELL_ROW_114_1892 VGND VPWR sky130_fd_sc_hd__tapvpwrvgnd_1
XFILLER_102_417 VGND VGND VPWR VPWR sky130_fd_sc_hd__decap_3
XFILLER_88_629 VGND VGND VPWR VPWR sky130_fd_sc_hd__decap_4
X_08981_ net291 net340 net161 VGND VGND VPWR VPWR _01707_ sky130_fd_sc_hd__and3_1
X_07932_ _00333_ _00487_ _00667_ VGND VGND VPWR VPWR _00670_ sky130_fd_sc_hd__and3b_1
XFILLER_110_450 VGND VGND VPWR VPWR sky130_fd_sc_hd__fill_1
X_07863_ _00600_ net249 VGND VGND VPWR VPWR _00601_ sky130_fd_sc_hd__nand2b_1
XFILLER_96_673 VPWR VGND VPWR VGND sky130_ef_sc_hd__decap_12
XFILLER_68_353 VGND VGND VPWR VPWR sky130_fd_sc_hd__fill_2
XFILLER_3_81 VPWR VGND VPWR VGND sky130_ef_sc_hd__decap_12
XFILLER_29_729 VGND VGND VPWR VPWR sky130_fd_sc_hd__decap_4
XFILLER_113_27 VPWR VGND VPWR VGND sky130_ef_sc_hd__decap_12
XFILLER_110_483 VGND VGND VPWR VPWR sky130_fd_sc_hd__decap_6
X_06814_ _03434_ _03489_ VGND VGND VPWR VPWR _03500_ sky130_fd_sc_hd__and2_1
X_09602_ _02321_ _02353_ VGND VGND VPWR VPWR _02355_ sky130_fd_sc_hd__xor2_2
XTAP_TAPCELL_ROW_3_338 VGND VPWR sky130_fd_sc_hd__tapvpwrvgnd_1
X_07794_ _00530_ _00531_ VGND VGND VPWR VPWR _00533_ sky130_fd_sc_hd__xnor2_1
X_09533_ net329 net327 net292 VGND VGND VPWR VPWR _02280_ sky130_fd_sc_hd__o21ai_1
XFILLER_37_751 VPWR VGND VPWR VGND sky130_ef_sc_hd__decap_12
X_06745_ net516 net388 net839 net390 VGND VGND VPWR VPWR _02750_ sky130_fd_sc_hd__a22o_1
XTAP_TAPCELL_ROW_65_1202 VGND VPWR sky130_fd_sc_hd__tapvpwrvgnd_1
X_09464_ _02198_ _02204_ VGND VGND VPWR VPWR _02205_ sky130_fd_sc_hd__xnor2_1
XFILLER_36_283 VPWR VGND VPWR VGND sky130_ef_sc_hd__decap_12
X_08415_ net535 net631 VGND VGND VPWR VPWR _01145_ sky130_fd_sc_hd__nand2_1
X_09395_ _02000_ _02018_ _02017_ VGND VGND VPWR VPWR _02129_ sky130_fd_sc_hd__a21oi_1
XFILLER_52_776 VPWR VGND VPWR VGND sky130_ef_sc_hd__decap_12
XFILLER_12_618 VPWR VGND VPWR VGND sky130_ef_sc_hd__decap_12
X_08346_ _01022_ _01079_ VGND VGND VPWR VPWR _01080_ sky130_fd_sc_hd__xnor2_1
XTAP_TAPCELL_ROW_22_602 VGND VPWR sky130_fd_sc_hd__tapvpwrvgnd_1
X_08277_ _01009_ _01010_ _00998_ VGND VGND VPWR VPWR _01012_ sky130_fd_sc_hd__o21ai_1
XTAP_TAPCELL_ROW_50_999 VGND VPWR sky130_fd_sc_hd__tapvpwrvgnd_1
XTAP_TAPCELL_ROW_50_988 VGND VPWR sky130_fd_sc_hd__tapvpwrvgnd_1
X_07228_ net322 net543 _06518_ VGND VGND VPWR VPWR _06519_ sky130_fd_sc_hd__and3_1
XFILLER_106_701 VGND VGND VPWR VPWR sky130_fd_sc_hd__decap_8
XFILLER_118_572 VPWR VGND VPWR VGND sky130_ef_sc_hd__decap_12
X_07159_ _06449_ _06450_ VGND VGND VPWR VPWR _06451_ sky130_fd_sc_hd__nor2_1
XFILLER_3_305 VPWR VGND VPWR VGND sky130_ef_sc_hd__decap_12
XFILLER_133_553 VGND VGND VPWR VPWR sky130_fd_sc_hd__decap_6
XFILLER_105_244 VPWR VGND VPWR VGND sky130_ef_sc_hd__decap_12
XFILLER_79_607 VGND VGND VPWR VPWR sky130_fd_sc_hd__decap_3
XTAP_TAPCELL_ROW_76_1364 VGND VPWR sky130_fd_sc_hd__tapvpwrvgnd_1
XTAP_TAPCELL_ROW_76_1353 VGND VPWR sky130_fd_sc_hd__tapvpwrvgnd_1
XFILLER_3_349 VPWR VGND VPWR VGND sky130_ef_sc_hd__decap_12
XFILLER_121_726 VGND VGND VPWR VPWR sky130_fd_sc_hd__fill_2
X_10170_ net512 net348 net346 net694 VGND VGND VPWR VPWR _02969_ sky130_fd_sc_hd__a22oi_1
XFILLER_133_597 VPWR VGND VPWR VGND sky130_ef_sc_hd__decap_12
XFILLER_59_320 VGND VGND VPWR VPWR sky130_fd_sc_hd__decap_6
XFILLER_120_247 VGND VGND VPWR VPWR sky130_fd_sc_hd__decap_4
XFILLER_59_364 VGND VGND VPWR VPWR sky130_fd_sc_hd__decap_8
XFILLER_86_172 VPWR VGND VPWR VGND sky130_ef_sc_hd__decap_12
XFILLER_59_397 VPWR VGND VPWR VGND sky130_ef_sc_hd__decap_12
XFILLER_47_515 VGND VGND VPWR VPWR sky130_fd_sc_hd__decap_8
XFILLER_19_206 VPWR VGND VPWR VGND sky130_ef_sc_hd__decap_12
XFILLER_74_334 VGND VGND VPWR VPWR sky130_fd_sc_hd__fill_1
XFILLER_62_507 VGND VGND VPWR VPWR sky130_fd_sc_hd__fill_2
XFILLER_47_559 VGND VGND VPWR VPWR sky130_fd_sc_hd__fill_1
X_12811_ _05688_ _05847_ VGND VGND VPWR VPWR _05849_ sky130_fd_sc_hd__xnor2_1
XFILLER_34_209 VGND VGND VPWR VPWR sky130_fd_sc_hd__fill_1
XFILLER_15_412 VPWR VGND VPWR VGND sky130_ef_sc_hd__decap_12
X_12742_ net420 net412 net585 net583 VGND VGND VPWR VPWR _05774_ sky130_fd_sc_hd__and4_1
XPHY_EDGE_ROW_69_Right_69 VGND VGND VPWR VPWR sky130_fd_sc_hd__decap_3
X_12673_ _05518_ _05531_ _05530_ VGND VGND VPWR VPWR _05698_ sky130_fd_sc_hd__a21oi_1
XFILLER_42_253 VGND VGND VPWR VPWR sky130_fd_sc_hd__decap_8
XFILLER_63_86 VGND VGND VPWR VPWR sky130_fd_sc_hd__fill_1
X_11624_ _04433_ _04437_ _04435_ VGND VGND VPWR VPWR _04556_ sky130_fd_sc_hd__a21oi_1
XFILLER_8_15 VPWR VGND VPWR VGND sky130_ef_sc_hd__decap_12
XFILLER_11_673 VGND VGND VPWR VPWR sky130_fd_sc_hd__decap_8
X_11555_ _03890_ _04381_ _04380_ VGND VGND VPWR VPWR _04481_ sky130_fd_sc_hd__a21bo_1
X_10506_ _03200_ _03332_ VGND VGND VPWR VPWR _03334_ sky130_fd_sc_hd__xnor2_1
X_11486_ _04401_ _04405_ VGND VGND VPWR VPWR _04406_ sky130_fd_sc_hd__xor2_1
XFILLER_109_561 VGND VGND VPWR VPWR sky130_fd_sc_hd__fill_2
X_10437_ _03257_ _03258_ VGND VGND VPWR VPWR _03260_ sky130_fd_sc_hd__and2b_1
XFILLER_6_165 VPWR VGND VPWR VGND sky130_ef_sc_hd__decap_12
X_13225_ _06163_ _06199_ _06162_ VGND VGND VPWR VPWR _06301_ sky130_fd_sc_hd__a21bo_1
XPHY_EDGE_ROW_78_Right_78 VGND VGND VPWR VPWR sky130_fd_sc_hd__decap_3
XFILLER_124_575 VGND VGND VPWR VPWR sky130_fd_sc_hd__fill_1
X_10368_ _03065_ _03066_ _03080_ _03078_ _02906_ VGND VGND VPWR VPWR _03185_ sky130_fd_sc_hd__a32o_1
X_13156_ _06222_ _06224_ VGND VGND VPWR VPWR _06225_ sky130_fd_sc_hd__nand2_1
XFILLER_111_225 VGND VGND VPWR VPWR sky130_fd_sc_hd__decap_6
X_10299_ _03109_ _03087_ VGND VGND VPWR VPWR _03110_ sky130_fd_sc_hd__and2b_1
X_13087_ _06017_ _06021_ _06023_ VGND VGND VPWR VPWR _06151_ sky130_fd_sc_hd__a21oi_1
X_12107_ net698 net413 net601 net361 VGND VGND VPWR VPWR _05080_ sky130_fd_sc_hd__and4_1
XFILLER_78_651 VGND VGND VPWR VPWR sky130_fd_sc_hd__fill_2
X_12038_ net593 net569 net301 net299 VGND VGND VPWR VPWR _05005_ sky130_fd_sc_hd__and4_1
XFILLER_120_781 VGND VGND VPWR VPWR sky130_fd_sc_hd__decap_8
XFILLER_92_153 VGND VGND VPWR VPWR sky130_fd_sc_hd__fill_2
XFILLER_53_529 VGND VGND VPWR VPWR sky130_fd_sc_hd__decap_6
XFILLER_92_197 VPWR VGND VPWR VGND sky130_ef_sc_hd__decap_12
XPHY_EDGE_ROW_87_Right_87 VGND VGND VPWR VPWR sky130_fd_sc_hd__decap_3
XFILLER_80_359 VGND VGND VPWR VPWR sky130_fd_sc_hd__fill_1
XFILLER_80_337 VGND VGND VPWR VPWR sky130_fd_sc_hd__decap_4
X_08200_ _00708_ _00935_ VGND VGND VPWR VPWR _00936_ sky130_fd_sc_hd__xnor2_1
X_09180_ _01902_ _01901_ _01734_ _01736_ VGND VGND VPWR VPWR _01905_ sky130_fd_sc_hd__a211o_1
XTAP_TAPCELL_ROW_60_1132 VGND VPWR sky130_fd_sc_hd__tapvpwrvgnd_1
X_08131_ _00865_ _00866_ VGND VGND VPWR VPWR _00867_ sky130_fd_sc_hd__xnor2_1
X_08062_ _00459_ _00797_ VGND VGND VPWR VPWR _00799_ sky130_fd_sc_hd__xnor2_1
XTAP_TAPCELL_ROW_116_1921 VGND VPWR sky130_fd_sc_hd__tapvpwrvgnd_1
XPHY_EDGE_ROW_96_Right_96 VGND VGND VPWR VPWR sky130_fd_sc_hd__decap_3
X_07013_ net452 net608 VGND VGND VPWR VPWR _05669_ sky130_fd_sc_hd__nand2_1
XFILLER_108_27 VGND VGND VPWR VPWR sky130_fd_sc_hd__fill_1
XTAP_TAPCELL_ROW_8_408 VGND VPWR sky130_fd_sc_hd__tapvpwrvgnd_1
XFILLER_1_809 VGND VGND VPWR VPWR sky130_fd_sc_hd__fill_2
XFILLER_130_501 VPWR VGND VPWR VGND sky130_ef_sc_hd__decap_12
XFILLER_88_415 VGND VGND VPWR VPWR sky130_fd_sc_hd__decap_4
XFILLER_88_404 VGND VGND VPWR VPWR sky130_fd_sc_hd__decap_8
XFILLER_130_545 VPWR VGND VPWR VGND sky130_ef_sc_hd__decap_12
XFILLER_102_225 VPWR VGND VPWR VGND sky130_ef_sc_hd__decap_12
XFILLER_88_459 VGND VGND VPWR VPWR sky130_fd_sc_hd__decap_8
X_08964_ _01686_ _01687_ _01688_ VGND VGND VPWR VPWR _01690_ sky130_fd_sc_hd__a21o_1
XFILLER_124_15 VPWR VGND VPWR VGND sky130_ef_sc_hd__decap_12
X_07915_ _00641_ _00652_ VGND VGND VPWR VPWR _00653_ sky130_fd_sc_hd__xor2_1
XFILLER_130_589 VPWR VGND VPWR VGND sky130_ef_sc_hd__decap_12
X_08895_ net525 net509 net126 net627 VGND VGND VPWR VPWR _01621_ sky130_fd_sc_hd__and4_1
XTAP_TAPCELL_ROW_71_1294 VGND VPWR sky130_fd_sc_hd__tapvpwrvgnd_1
XTAP_TAPCELL_ROW_71_1283 VGND VPWR sky130_fd_sc_hd__tapvpwrvgnd_1
XFILLER_56_323 VGND VGND VPWR VPWR sky130_fd_sc_hd__decap_3
X_07846_ _00582_ _00583_ VGND VGND VPWR VPWR _00584_ sky130_fd_sc_hd__xor2_1
XFILLER_110_291 VPWR VGND VPWR VGND sky130_ef_sc_hd__decap_12
XFILLER_84_665 VGND VGND VPWR VPWR sky130_fd_sc_hd__fill_1
XFILLER_83_142 VPWR VGND VPWR VGND sky130_ef_sc_hd__decap_12
XFILLER_84_687 VPWR VGND VPWR VGND sky130_ef_sc_hd__decap_12
X_07777_ _00382_ net803 _00387_ VGND VGND VPWR VPWR _00516_ sky130_fd_sc_hd__a21oi_1
X_09516_ _01950_ _02112_ _02114_ VGND VGND VPWR VPWR _02261_ sky130_fd_sc_hd__o21ai_1
X_06728_ net252 net532 _02555_ VGND VGND VPWR VPWR _02566_ sky130_fd_sc_hd__and3_1
XFILLER_17_57 VGND VGND VPWR VPWR sky130_fd_sc_hd__decap_4
X_09447_ _02174_ _02185_ VGND VGND VPWR VPWR _02187_ sky130_fd_sc_hd__xnor2_2
XTAP_TAPCELL_ROW_35_782 VGND VPWR sky130_fd_sc_hd__tapvpwrvgnd_1
XFILLER_40_713 VGND VGND VPWR VPWR sky130_fd_sc_hd__decap_4
XFILLER_40_735 VGND VGND VPWR VPWR sky130_fd_sc_hd__fill_1
X_09378_ _01781_ _01785_ VGND VGND VPWR VPWR _02111_ sky130_fd_sc_hd__or2_2
XFILLER_8_419 VGND VGND VPWR VPWR sky130_fd_sc_hd__fill_1
X_08329_ _00974_ _01062_ VGND VGND VPWR VPWR _01063_ sky130_fd_sc_hd__xnor2_1
X_11340_ _03869_ _04030_ _04245_ VGND VGND VPWR VPWR _04247_ sky130_fd_sc_hd__or3b_1
XFILLER_116_3 VPWR VGND VPWR VGND sky130_ef_sc_hd__decap_12
XFILLER_4_625 VPWR VGND VPWR VGND sky130_ef_sc_hd__decap_12
XFILLER_3_113 VPWR VGND VPWR VGND sky130_ef_sc_hd__decap_12
X_11271_ _04168_ _04169_ VGND VGND VPWR VPWR _04171_ sky130_fd_sc_hd__xor2_1
X_13010_ _05843_ _05851_ _05850_ VGND VGND VPWR VPWR _06067_ sky130_fd_sc_hd__a21bo_1
XFILLER_133_361 VPWR VGND VPWR VGND sky130_ef_sc_hd__decap_12
XFILLER_106_564 VGND VGND VPWR VPWR sky130_fd_sc_hd__decap_8
X_10222_ _03017_ _03024_ _03025_ VGND VGND VPWR VPWR _03026_ sky130_fd_sc_hd__and3_4
XFILLER_4_669 VPWR VGND VPWR VGND sky130_ef_sc_hd__decap_12
XFILLER_121_545 VGND VGND VPWR VPWR sky130_fd_sc_hd__fill_1
X_10153_ net459 net451 net578 net576 VGND VGND VPWR VPWR _02950_ sky130_fd_sc_hd__and4_1
XFILLER_59_150 VGND VGND VPWR VPWR sky130_fd_sc_hd__decap_4
X_10084_ net503 net656 VGND VGND VPWR VPWR _02874_ sky130_fd_sc_hd__nand2_1
XTAP_TAPCELL_ROW_89_1544 VGND VPWR sky130_fd_sc_hd__tapvpwrvgnd_1
XFILLER_35_529 VGND VGND VPWR VPWR sky130_fd_sc_hd__fill_1
XFILLER_90_657 VPWR VGND VPWR VGND sky130_ef_sc_hd__decap_12
XFILLER_74_85 VPWR VGND VPWR VGND sky130_ef_sc_hd__decap_12
XFILLER_62_337 VGND VGND VPWR VPWR sky130_fd_sc_hd__fill_1
XFILLER_62_326 VGND VGND VPWR VPWR sky130_fd_sc_hd__fill_1
X_10986_ _03858_ _03859_ VGND VGND VPWR VPWR _00024_ sky130_fd_sc_hd__xnor2_1
XTAP_TAPCELL_ROW_100_1700 VGND VPWR sky130_fd_sc_hd__tapvpwrvgnd_1
XFILLER_70_381 VGND VGND VPWR VPWR sky130_fd_sc_hd__fill_1
XFILLER_43_584 VPWR VGND VPWR VGND sky130_ef_sc_hd__decap_12
XFILLER_43_573 VGND VGND VPWR VPWR sky130_fd_sc_hd__decap_6
X_12725_ _05752_ _05753_ VGND VGND VPWR VPWR _05755_ sky130_fd_sc_hd__xnor2_1
X_12656_ _05677_ _05678_ VGND VGND VPWR VPWR _05679_ sky130_fd_sc_hd__nor2_1
XFILLER_31_746 VPWR VGND VPWR VGND sky130_ef_sc_hd__decap_12
X_11607_ _04535_ _04536_ VGND VGND VPWR VPWR _04538_ sky130_fd_sc_hd__xnor2_1
XTAP_TAPCELL_ROW_13_476 VGND VPWR sky130_fd_sc_hd__tapvpwrvgnd_1
X_12587_ _05602_ _05603_ VGND VGND VPWR VPWR _05605_ sky130_fd_sc_hd__and2b_1
XFILLER_30_289 VGND VGND VPWR VPWR sky130_fd_sc_hd__decap_8
XFILLER_128_133 VGND VGND VPWR VPWR sky130_fd_sc_hd__decap_6
X_11538_ _04444_ _04460_ VGND VGND VPWR VPWR _04463_ sky130_fd_sc_hd__xnor2_1
XFILLER_7_474 VGND VGND VPWR VPWR sky130_fd_sc_hd__decap_8
X_11469_ _04260_ _04263_ _04387_ VGND VGND VPWR VPWR _04388_ sky130_fd_sc_hd__a21oi_1
X_13208_ _06009_ _06137_ _05918_ VGND VGND VPWR VPWR _06283_ sky130_fd_sc_hd__o21ai_1
X_13139_ _06071_ _06073_ _06206_ VGND VGND VPWR VPWR _06208_ sky130_fd_sc_hd__or3b_1
XTAP_TAPCELL_ROW_111_1851 VGND VPWR sky130_fd_sc_hd__tapvpwrvgnd_1
X_07700_ _00326_ _00358_ _00357_ VGND VGND VPWR VPWR _00439_ sky130_fd_sc_hd__a21oi_1
XFILLER_66_610 VGND VGND VPWR VPWR sky130_fd_sc_hd__fill_2
XTAP_TAPCELL_ROW_127_2069 VGND VPWR sky130_fd_sc_hd__tapvpwrvgnd_1
X_08680_ net699 net326 VGND VGND VPWR VPWR _01408_ sky130_fd_sc_hd__nand2_1
XFILLER_66_632 VGND VGND VPWR VPWR sky130_fd_sc_hd__fill_2
XFILLER_38_334 VPWR VGND VPWR VGND sky130_ef_sc_hd__decap_12
X_07631_ _00207_ _00210_ VGND VGND VPWR VPWR _00371_ sky130_fd_sc_hd__and2_1
XFILLER_53_304 VGND VGND VPWR VPWR sky130_fd_sc_hd__decap_6
XFILLER_26_518 VPWR VGND VPWR VGND sky130_ef_sc_hd__decap_12
X_07562_ _00300_ _00301_ VGND VGND VPWR VPWR _00302_ sky130_fd_sc_hd__or2_1
XFILLER_53_337 VGND VGND VPWR VPWR sky130_fd_sc_hd__decap_4
XFILLER_53_326 VGND VGND VPWR VPWR sky130_fd_sc_hd__decap_8
XFILLER_80_156 VGND VGND VPWR VPWR sky130_fd_sc_hd__fill_2
X_09301_ net291 net60 VGND VGND VPWR VPWR _02027_ sky130_fd_sc_hd__and2_1
X_07493_ net105 _06623_ _06622_ VGND VGND VPWR VPWR _00234_ sky130_fd_sc_hd__a21o_1
X_09232_ _01943_ _01955_ VGND VGND VPWR VPWR _01956_ sky130_fd_sc_hd__xor2_2
XFILLER_21_234 VGND VGND VPWR VPWR sky130_fd_sc_hd__fill_1
XFILLER_22_757 VGND VGND VPWR VPWR sky130_fd_sc_hd__decap_3
XTAP_TAPCELL_ROW_32_741 VGND VPWR sky130_fd_sc_hd__tapvpwrvgnd_1
XFILLER_119_111 VGND VGND VPWR VPWR sky130_fd_sc_hd__fill_1
X_09163_ _01719_ _01721_ _01886_ _01887_ VGND VGND VPWR VPWR _01888_ sky130_fd_sc_hd__o211a_4
XFILLER_9_80 VGND VGND VPWR VPWR sky130_fd_sc_hd__decap_8
XFILLER_119_15 VPWR VGND VPWR VGND sky130_ef_sc_hd__decap_12
X_08114_ _00644_ _00849_ VGND VGND VPWR VPWR _00850_ sky130_fd_sc_hd__nand2_1
XFILLER_135_615 VGND VGND VPWR VPWR sky130_fd_sc_hd__fill_1
XFILLER_119_166 VGND VGND VPWR VPWR sky130_fd_sc_hd__fill_2
X_09094_ _01657_ _01660_ VGND VGND VPWR VPWR _01819_ sky130_fd_sc_hd__nand2_1
X_08045_ _00780_ _00781_ VGND VGND VPWR VPWR _00782_ sky130_fd_sc_hd__nor2_1
XFILLER_122_309 VGND VGND VPWR VPWR sky130_fd_sc_hd__decap_6
XFILLER_115_361 VPWR VGND VPWR VGND sky130_ef_sc_hd__decap_12
XTAP_TAPCELL_ROW_73_1323 VGND VPWR sky130_fd_sc_hd__tapvpwrvgnd_1
XTAP_TAPCELL_ROW_73_1312 VGND VPWR sky130_fd_sc_hd__tapvpwrvgnd_1
XFILLER_1_617 VPWR VGND VPWR VGND sky130_ef_sc_hd__decap_12
XFILLER_135_69 VPWR VGND VPWR VGND sky130_ef_sc_hd__decap_12
XFILLER_103_556 VGND VGND VPWR VPWR sky130_fd_sc_hd__decap_4
X_09996_ _02779_ VGND VGND VPWR VPWR _02780_ sky130_fd_sc_hd__inv_2
X_08947_ _01671_ _01672_ VGND VGND VPWR VPWR _01673_ sky130_fd_sc_hd__nand2b_4
XFILLER_29_301 VGND VGND VPWR VPWR sky130_fd_sc_hd__decap_8
X_08878_ _01454_ _01603_ VGND VGND VPWR VPWR _01604_ sky130_fd_sc_hd__xnor2_1
XFILLER_57_632 VGND VGND VPWR VPWR sky130_fd_sc_hd__fill_2
XFILLER_28_56 VGND VGND VPWR VPWR sky130_fd_sc_hd__decap_4
X_07829_ _00433_ _00567_ VGND VGND VPWR VPWR _00568_ sky130_fd_sc_hd__xnor2_1
XFILLER_84_451 VPWR VGND VPWR VGND sky130_ef_sc_hd__decap_12
XFILLER_72_624 VGND VGND VPWR VPWR sky130_fd_sc_hd__fill_2
X_10840_ net566 net277 net275 net590 VGND VGND VPWR VPWR _03700_ sky130_fd_sc_hd__a22o_1
XFILLER_71_167 VGND VGND VPWR VPWR sky130_fd_sc_hd__fill_1
XFILLER_25_551 VGND VGND VPWR VPWR sky130_fd_sc_hd__decap_8
XTAP_TAPCELL_ROW_84_1474 VGND VPWR sky130_fd_sc_hd__tapvpwrvgnd_1
XFILLER_44_55 VGND VGND VPWR VPWR sky130_fd_sc_hd__fill_1
XFILLER_25_573 VGND VGND VPWR VPWR sky130_fd_sc_hd__fill_1
XFILLER_25_595 VGND VGND VPWR VPWR sky130_fd_sc_hd__fill_1
X_10771_ _03450_ _03453_ VGND VGND VPWR VPWR _03625_ sky130_fd_sc_hd__nand2_1
XFILLER_80_690 VGND VGND VPWR VPWR sky130_fd_sc_hd__fill_1
XFILLER_13_757 VPWR VGND VPWR VGND sky130_ef_sc_hd__decap_12
X_12510_ net568 _05345_ _05340_ VGND VGND VPWR VPWR _05520_ sky130_fd_sc_hd__a21oi_1
X_12441_ _05443_ _05444_ VGND VGND VPWR VPWR _05445_ sky130_fd_sc_hd__and2b_1
XFILLER_40_587 VGND VGND VPWR VPWR sky130_fd_sc_hd__fill_1
XFILLER_60_54 VGND VGND VPWR VPWR sky130_fd_sc_hd__fill_1
XTAP_TAPCELL_ROW_10_435 VGND VPWR sky130_fd_sc_hd__tapvpwrvgnd_1
X_12372_ _05367_ _05368_ VGND VGND VPWR VPWR _05369_ sky130_fd_sc_hd__nand2b_1
XFILLER_125_125 VGND VGND VPWR VPWR sky130_fd_sc_hd__decap_4
XFILLER_5_27 VPWR VGND VPWR VGND sky130_ef_sc_hd__decap_12
XFILLER_4_433 VPWR VGND VPWR VGND sky130_ef_sc_hd__decap_12
X_11323_ _04215_ _04227_ VGND VGND VPWR VPWR _04228_ sky130_fd_sc_hd__xnor2_1
XFILLER_125_169 VPWR VGND VPWR VGND sky130_ef_sc_hd__decap_12
XFILLER_4_477 VPWR VGND VPWR VGND sky130_ef_sc_hd__decap_12
X_11254_ _03865_ _04006_ _04005_ VGND VGND VPWR VPWR _04153_ sky130_fd_sc_hd__a21oi_2
XFILLER_134_681 VPWR VGND VPWR VGND sky130_ef_sc_hd__decap_12
XFILLER_106_361 VGND VGND VPWR VPWR sky130_fd_sc_hd__decap_3
XFILLER_69_52 VGND VGND VPWR VPWR sky130_fd_sc_hd__fill_1
X_10205_ _02966_ _03004_ _03006_ VGND VGND VPWR VPWR _03007_ sky130_fd_sc_hd__nor3_1
X_11185_ net331 net343 VGND VGND VPWR VPWR _04077_ sky130_fd_sc_hd__nand2_1
XFILLER_121_375 VGND VGND VPWR VPWR sky130_fd_sc_hd__fill_1
XFILLER_95_749 VGND VGND VPWR VPWR sky130_fd_sc_hd__fill_2
XFILLER_95_727 VGND VGND VPWR VPWR sky130_fd_sc_hd__fill_1
XFILLER_94_215 VGND VGND VPWR VPWR sky130_fd_sc_hd__decap_3
XFILLER_94_204 VGND VGND VPWR VPWR sky130_fd_sc_hd__decap_4
XFILLER_67_429 VPWR VGND VPWR VGND sky130_ef_sc_hd__decap_12
X_10136_ net495 net654 VGND VGND VPWR VPWR _02931_ sky130_fd_sc_hd__nand2_2
XFILLER_39_109 VGND VGND VPWR VPWR sky130_fd_sc_hd__decap_3
XFILLER_94_237 VGND VGND VPWR VPWR sky130_fd_sc_hd__decap_8
XFILLER_85_40 VGND VGND VPWR VPWR sky130_fd_sc_hd__decap_8
X_10067_ _02854_ _02855_ VGND VGND VPWR VPWR _02857_ sky130_fd_sc_hd__nor2_1
XFILLER_36_805 VGND VGND VPWR VPWR sky130_fd_sc_hd__fill_2
XFILLER_35_326 VGND VGND VPWR VPWR sky130_fd_sc_hd__decap_8
XTAP_TAPCELL_ROW_18_546 VGND VPWR sky130_fd_sc_hd__tapvpwrvgnd_1
X_10969_ _03665_ _03667_ _03840_ _03841_ VGND VGND VPWR VPWR _03842_ sky130_fd_sc_hd__o211ai_2
X_12708_ _05734_ _05736_ VGND VGND VPWR VPWR _05737_ sky130_fd_sc_hd__or2_1
X_12639_ _05315_ _05493_ _05492_ VGND VGND VPWR VPWR _05661_ sky130_fd_sc_hd__a21o_1
XFILLER_117_604 VGND VGND VPWR VPWR sky130_fd_sc_hd__decap_3
XFILLER_129_497 VGND VGND VPWR VPWR sky130_fd_sc_hd__decap_6
XFILLER_7_293 VPWR VGND VPWR VGND sky130_ef_sc_hd__decap_12
XFILLER_104_309 VGND VGND VPWR VPWR sky130_fd_sc_hd__decap_6
X_09850_ _02492_ _02494_ _02624_ VGND VGND VPWR VPWR _02625_ sky130_fd_sc_hd__a21oi_1
XTAP_TAPCELL_ROW_55_1064 VGND VPWR sky130_fd_sc_hd__tapvpwrvgnd_1
X_06993_ _03718_ _03740_ _03729_ VGND VGND VPWR VPWR _05451_ sky130_fd_sc_hd__o21bai_1
XFILLER_100_526 VGND VGND VPWR VPWR sky130_fd_sc_hd__fill_1
X_09781_ _02547_ _02548_ VGND VGND VPWR VPWR _02549_ sky130_fd_sc_hd__nor2_1
XFILLER_98_587 VGND VGND VPWR VPWR sky130_fd_sc_hd__fill_1
X_08801_ net422 net555 net553 net439 VGND VGND VPWR VPWR _01528_ sky130_fd_sc_hd__a22oi_2
X_08732_ _01457_ _01458_ VGND VGND VPWR VPWR _01459_ sky130_fd_sc_hd__xnor2_1
XFILLER_79_790 VGND VGND VPWR VPWR sky130_fd_sc_hd__fill_1
X_08663_ net473 net464 net551 net549 VGND VGND VPWR VPWR _01391_ sky130_fd_sc_hd__and4_1
XFILLER_54_602 VPWR VGND VPWR VGND sky130_ef_sc_hd__decap_12
XFILLER_26_304 VGND VGND VPWR VPWR sky130_fd_sc_hd__decap_4
XFILLER_27_805 VGND VGND VPWR VPWR sky130_fd_sc_hd__decap_3
XFILLER_38_131 VGND VGND VPWR VPWR sky130_fd_sc_hd__decap_4
XFILLER_93_281 VGND VGND VPWR VPWR sky130_fd_sc_hd__decap_4
XTAP_TAPCELL_ROW_37_811 VGND VPWR sky130_fd_sc_hd__tapvpwrvgnd_1
XFILLER_38_197 VGND VGND VPWR VPWR sky130_fd_sc_hd__decap_4
XFILLER_121_27 VPWR VGND VPWR VGND sky130_ef_sc_hd__decap_12
X_07614_ _00351_ _00352_ VGND VGND VPWR VPWR _00354_ sky130_fd_sc_hd__and2b_1
X_08594_ _01318_ _01312_ _01319_ VGND VGND VPWR VPWR _01323_ sky130_fd_sc_hd__a21o_1
XFILLER_81_465 VGND VGND VPWR VPWR sky130_fd_sc_hd__fill_1
XPHY_EDGE_ROW_132_Left_269 VGND VGND VPWR VPWR sky130_fd_sc_hd__decap_3
X_07545_ _06669_ _00284_ VGND VGND VPWR VPWR _00285_ sky130_fd_sc_hd__xor2_1
X_07476_ _00214_ _00215_ _00200_ VGND VGND VPWR VPWR _00217_ sky130_fd_sc_hd__a21oi_1
X_09215_ _01769_ _01771_ _01937_ VGND VGND VPWR VPWR _01939_ sky130_fd_sc_hd__and3_1
XFILLER_22_587 VGND VGND VPWR VPWR sky130_fd_sc_hd__fill_1
XFILLER_10_749 VGND VGND VPWR VPWR sky130_fd_sc_hd__decap_6
XFILLER_108_615 VPWR VGND VPWR VGND sky130_ef_sc_hd__decap_12
X_09146_ net624 _01712_ _01711_ VGND VGND VPWR VPWR _01871_ sky130_fd_sc_hd__a21o_1
X_09077_ _01801_ _01754_ VGND VGND VPWR VPWR _01802_ sky130_fd_sc_hd__xor2_1
XFILLER_123_629 VGND VGND VPWR VPWR sky130_fd_sc_hd__decap_8
X_08028_ _00758_ _00764_ VGND VGND VPWR VPWR _00765_ sky130_fd_sc_hd__xnor2_1
XFILLER_30_57 VGND VGND VPWR VPWR sky130_fd_sc_hd__decap_6
XFILLER_1_447 VGND VGND VPWR VPWR sky130_fd_sc_hd__fill_1
XFILLER_39_22 VPWR VGND VPWR VGND sky130_ef_sc_hd__decap_12
XFILLER_131_673 VPWR VGND VPWR VGND sky130_ef_sc_hd__decap_12
X_09979_ _01950_ _02421_ VGND VGND VPWR VPWR _02764_ sky130_fd_sc_hd__xnor2_1
XFILLER_89_587 VGND VGND VPWR VPWR sky130_fd_sc_hd__decap_8
XFILLER_77_727 VGND VGND VPWR VPWR sky130_fd_sc_hd__fill_1
XFILLER_92_719 VPWR VGND VPWR VGND sky130_ef_sc_hd__decap_12
XTAP_TAPCELL_ROW_86_1503 VGND VPWR sky130_fd_sc_hd__tapvpwrvgnd_1
XFILLER_18_805 VGND VGND VPWR VPWR sky130_fd_sc_hd__decap_6
X_12990_ net541 net293 VGND VGND VPWR VPWR _06045_ sky130_fd_sc_hd__nand2_1
XFILLER_85_782 VGND VGND VPWR VPWR sky130_fd_sc_hd__fill_2
XFILLER_72_421 VGND VGND VPWR VPWR sky130_fd_sc_hd__decap_4
XFILLER_57_495 VGND VGND VPWR VPWR sky130_fd_sc_hd__decap_8
X_11941_ _04888_ _04898_ VGND VGND VPWR VPWR _04899_ sky130_fd_sc_hd__xnor2_1
XFILLER_17_337 VGND VGND VPWR VPWR sky130_fd_sc_hd__fill_1
XFILLER_72_432 VGND VGND VPWR VPWR sky130_fd_sc_hd__decap_6
X_11872_ _04820_ _04822_ _04823_ VGND VGND VPWR VPWR _04824_ sky130_fd_sc_hd__nor3_1
XPHY_EDGE_ROW_105_Right_105 VGND VGND VPWR VPWR sky130_fd_sc_hd__decap_3
X_10823_ _03679_ _03680_ _03495_ _03497_ VGND VGND VPWR VPWR _03682_ sky130_fd_sc_hd__o211a_1
XTAP_TAPCELL_ROW_15_505 VGND VPWR sky130_fd_sc_hd__tapvpwrvgnd_1
XFILLER_32_307 VGND VGND VPWR VPWR sky130_fd_sc_hd__fill_1
XFILLER_9_503 VGND VGND VPWR VPWR sky130_fd_sc_hd__fill_1
X_10754_ net433 net563 net562 net442 VGND VGND VPWR VPWR _03606_ sky130_fd_sc_hd__a22o_1
X_10685_ _03519_ _03520_ _03529_ VGND VGND VPWR VPWR _03530_ sky130_fd_sc_hd__or3_1
XFILLER_40_373 VPWR VGND VPWR VGND sky130_ef_sc_hd__decap_12
XFILLER_126_412 VGND VGND VPWR VPWR sky130_fd_sc_hd__decap_8
X_12424_ net515 net49 VGND VGND VPWR VPWR _05426_ sky130_fd_sc_hd__and2b_1
XFILLER_126_445 VPWR VGND VPWR VGND sky130_ef_sc_hd__decap_12
XTAP_TAPCELL_ROW_97_1654 VGND VPWR sky130_fd_sc_hd__tapvpwrvgnd_1
X_12355_ net529 net659 _05167_ _05165_ VGND VGND VPWR VPWR _05350_ sky130_fd_sc_hd__a31o_1
XFILLER_5_753 VPWR VGND VPWR VGND sky130_ef_sc_hd__decap_12
X_11306_ net475 net647 net636 net826 VGND VGND VPWR VPWR _04209_ sky130_fd_sc_hd__a22oi_1
XFILLER_114_629 VGND VGND VPWR VPWR sky130_fd_sc_hd__decap_8
XFILLER_107_681 VGND VGND VPWR VPWR sky130_fd_sc_hd__fill_1
XFILLER_107_670 VGND VGND VPWR VPWR sky130_fd_sc_hd__fill_2
XFILLER_99_329 VGND VGND VPWR VPWR sky130_fd_sc_hd__decap_6
XFILLER_5_797 VPWR VGND VPWR VGND sky130_ef_sc_hd__decap_12
X_12286_ _05257_ _05273_ VGND VGND VPWR VPWR _05275_ sky130_fd_sc_hd__xor2_1
XFILLER_106_191 VGND VGND VPWR VPWR sky130_fd_sc_hd__decap_4
X_11237_ _03927_ _03933_ _03932_ VGND VGND VPWR VPWR _04135_ sky130_fd_sc_hd__a21oi_1
XFILLER_96_50 VGND VGND VPWR VPWR sky130_fd_sc_hd__decap_3
X_11168_ _04055_ _04056_ VGND VGND VPWR VPWR _04059_ sky130_fd_sc_hd__and2_1
X_10119_ _02889_ _02912_ VGND VGND VPWR VPWR _02913_ sky130_fd_sc_hd__xor2_1
XFILLER_83_719 VGND VGND VPWR VPWR sky130_fd_sc_hd__decap_8
X_11099_ _03788_ _03789_ _03980_ VGND VGND VPWR VPWR _03984_ sky130_fd_sc_hd__or3_1
XTAP_TAPCELL_ROW_124_2028 VGND VPWR sky130_fd_sc_hd__tapvpwrvgnd_1
XFILLER_76_793 VPWR VGND VPWR VGND sky130_ef_sc_hd__decap_12
XFILLER_75_281 VGND VGND VPWR VPWR sky130_fd_sc_hd__decap_6
XFILLER_48_484 VPWR VGND VPWR VGND sky130_ef_sc_hd__decap_12
XFILLER_91_763 VGND VGND VPWR VPWR sky130_fd_sc_hd__fill_2
XFILLER_91_741 VGND VGND VPWR VPWR sky130_fd_sc_hd__fill_1
XFILLER_63_465 VGND VGND VPWR VPWR sky130_fd_sc_hd__fill_1
XTAP_TAPCELL_ROW_106_1772 VGND VPWR sky130_fd_sc_hd__tapvpwrvgnd_1
XFILLER_91_785 VGND VGND VPWR VPWR sky130_fd_sc_hd__fill_2
XTAP_TAPCELL_ROW_106_1783 VGND VPWR sky130_fd_sc_hd__tapvpwrvgnd_1
X_07330_ _06619_ _06620_ VGND VGND VPWR VPWR _06621_ sky130_fd_sc_hd__nor2_1
XFILLER_16_381 VGND VGND VPWR VPWR sky130_fd_sc_hd__decap_8
X_07261_ _06432_ _06450_ _06449_ VGND VGND VPWR VPWR _06552_ sky130_fd_sc_hd__o21bai_1
X_09000_ _01696_ _01725_ VGND VGND VPWR VPWR _01726_ sky130_fd_sc_hd__nand2_1
XTAP_TAPCELL_ROW_42_880 VGND VPWR sky130_fd_sc_hd__tapvpwrvgnd_1
X_07192_ _06482_ _06481_ net939 _06095_ VGND VGND VPWR VPWR _06484_ sky130_fd_sc_hd__a211o_1
XTAP_TAPCELL_ROW_135_2179 VGND VPWR sky130_fd_sc_hd__tapvpwrvgnd_1
X_09902_ _02578_ _02679_ VGND VGND VPWR VPWR _02681_ sky130_fd_sc_hd__and2_1
XFILLER_116_27 VGND VGND VPWR VPWR sky130_fd_sc_hd__fill_1
Xfanout515 net516 VGND VGND VPWR VPWR net515 sky130_fd_sc_hd__clkbuf_4
Xfanout504 net511 VGND VGND VPWR VPWR net504 sky130_fd_sc_hd__dlymetal6s2s_1
X_09833_ _02604_ _02605_ VGND VGND VPWR VPWR _02606_ sky130_fd_sc_hd__nand2_1
XFILLER_113_673 VPWR VGND VPWR VGND sky130_ef_sc_hd__decap_12
XFILLER_100_301 VGND VGND VPWR VPWR sky130_fd_sc_hd__decap_6
Xfanout537 net160 VGND VGND VPWR VPWR net537 sky130_fd_sc_hd__clkbuf_2
XFILLER_86_502 VGND VGND VPWR VPWR sky130_fd_sc_hd__fill_2
Xfanout548 net159 VGND VGND VPWR VPWR net548 sky130_fd_sc_hd__buf_2
XFILLER_59_716 VGND VGND VPWR VPWR sky130_fd_sc_hd__decap_3
Xfanout526 net528 VGND VGND VPWR VPWR net526 sky130_fd_sc_hd__buf_2
XFILLER_58_248 VGND VGND VPWR VPWR sky130_fd_sc_hd__decap_4
Xfanout559 net152 VGND VGND VPWR VPWR net559 sky130_fd_sc_hd__buf_2
XFILLER_132_15 VPWR VGND VPWR VGND sky130_ef_sc_hd__decap_12
X_06976_ _05221_ _05232_ VGND VGND VPWR VPWR _05265_ sky130_fd_sc_hd__xnor2_1
XFILLER_86_568 VGND VGND VPWR VPWR sky130_fd_sc_hd__fill_1
X_09764_ _02308_ _02528_ VGND VGND VPWR VPWR _02530_ sky130_fd_sc_hd__nand2_1
X_09695_ _02243_ _02454_ VGND VGND VPWR VPWR _02455_ sky130_fd_sc_hd__xor2_1
X_08715_ _01313_ _01316_ _01442_ net227 VGND VGND VPWR VPWR _01443_ sky130_fd_sc_hd__a211o_4
XFILLER_54_421 VGND VGND VPWR VPWR sky130_fd_sc_hd__decap_6
Xrebuffer20 _05106_ VGND VGND VPWR VPWR net720 sky130_fd_sc_hd__buf_1
X_08646_ _01371_ _01372_ _01373_ VGND VGND VPWR VPWR _01374_ sky130_fd_sc_hd__and3_1
Xrebuffer31 _01722_ VGND VGND VPWR VPWR net731 sky130_fd_sc_hd__dlymetal6s4s_1
XTAP_TAPCELL_ROW_68_1244 VGND VPWR sky130_fd_sc_hd__tapvpwrvgnd_1
Xrebuffer64 _03684_ VGND VGND VPWR VPWR net764 sky130_fd_sc_hd__dlymetal6s4s_1
Xrebuffer42 net432 VGND VGND VPWR VPWR net742 sky130_fd_sc_hd__buf_8
Xrebuffer53 net356 VGND VGND VPWR VPWR net753 sky130_fd_sc_hd__dlygate4sd1_1
XFILLER_27_657 VGND VGND VPWR VPWR sky130_fd_sc_hd__decap_3
XFILLER_82_774 VGND VGND VPWR VPWR sky130_fd_sc_hd__fill_2
Xrebuffer75 _04970_ VGND VGND VPWR VPWR net775 sky130_fd_sc_hd__buf_6
XFILLER_26_189 VGND VGND VPWR VPWR sky130_fd_sc_hd__fill_1
XFILLER_42_627 VGND VGND VPWR VPWR sky130_fd_sc_hd__fill_1
XTAP_TAPCELL_ROW_81_1433 VGND VPWR sky130_fd_sc_hd__tapvpwrvgnd_1
XTAP_TAPCELL_ROW_81_1422 VGND VPWR sky130_fd_sc_hd__tapvpwrvgnd_1
X_08577_ _01294_ _01298_ _01297_ VGND VGND VPWR VPWR _01306_ sky130_fd_sc_hd__o21ai_1
XFILLER_25_57 VGND VGND VPWR VPWR sky130_fd_sc_hd__decap_3
X_07528_ _00266_ _00265_ _06645_ _06647_ VGND VGND VPWR VPWR _00269_ sky130_fd_sc_hd__a211o_1
X_07459_ _06455_ _06614_ _06613_ VGND VGND VPWR VPWR _00200_ sky130_fd_sc_hd__a21o_1
Xrebuffer121 net921 VGND VGND VPWR VPWR net821 sky130_fd_sc_hd__dlymetal6s2s_1
X_10470_ _03138_ _03141_ _03139_ VGND VGND VPWR VPWR _03296_ sky130_fd_sc_hd__o21bai_1
XFILLER_10_568 VGND VGND VPWR VPWR sky130_fd_sc_hd__decap_8
X_09129_ _01851_ _01852_ _01838_ VGND VGND VPWR VPWR _01854_ sky130_fd_sc_hd__a21oi_1
Xrebuffer165 _03018_ VGND VGND VPWR VPWR net865 sky130_fd_sc_hd__dlymetal6s2s_1
XTAP_TAPCELL_ROW_20_574 VGND VPWR sky130_fd_sc_hd__tapvpwrvgnd_1
XFILLER_108_467 VGND VGND VPWR VPWR sky130_fd_sc_hd__fill_2
XTAP_TAPCELL_ROW_79_1395 VGND VPWR sky130_fd_sc_hd__tapvpwrvgnd_1
X_12140_ _05113_ _05114_ _04964_ _04962_ VGND VGND VPWR VPWR _05116_ sky130_fd_sc_hd__a211o_4
Xrebuffer198 net900 VGND VGND VPWR VPWR net898 sky130_fd_sc_hd__buf_6
XFILLER_2_701 VPWR VGND VPWR VGND sky130_ef_sc_hd__decap_12
X_12071_ net488 net677 _04901_ VGND VGND VPWR VPWR _05041_ sky130_fd_sc_hd__a21o_1
XFILLER_9_3 VPWR VGND VPWR VGND sky130_ef_sc_hd__decap_12
XFILLER_110_109 VPWR VGND VPWR VGND sky130_ef_sc_hd__decap_12
XTAP_TAPCELL_ROW_92_1584 VGND VPWR sky130_fd_sc_hd__tapvpwrvgnd_1
X_11022_ _03719_ _03731_ _03730_ VGND VGND VPWR VPWR _03899_ sky130_fd_sc_hd__a21oi_1
XFILLER_66_53 VGND VGND VPWR VPWR sky130_fd_sc_hd__fill_1
XFILLER_45_421 VGND VGND VPWR VPWR sky130_fd_sc_hd__fill_1
X_12973_ _06024_ _06025_ VGND VGND VPWR VPWR _06026_ sky130_fd_sc_hd__nor2_1
XFILLER_18_613 VGND VGND VPWR VPWR sky130_fd_sc_hd__decap_3
XFILLER_18_635 VGND VGND VPWR VPWR sky130_fd_sc_hd__decap_3
XFILLER_73_741 VPWR VGND VPWR VGND sky130_ef_sc_hd__decap_12
X_11924_ _04865_ _04879_ VGND VGND VPWR VPWR _04880_ sky130_fd_sc_hd__xnor2_1
XFILLER_17_145 VGND VGND VPWR VPWR sky130_fd_sc_hd__decap_4
XFILLER_82_41 VPWR VGND VPWR VGND sky130_ef_sc_hd__decap_12
XFILLER_17_167 VGND VGND VPWR VPWR sky130_fd_sc_hd__fill_1
XFILLER_33_605 VGND VGND VPWR VPWR sky130_fd_sc_hd__fill_2
X_11855_ _04795_ _04624_ _04804_ VGND VGND VPWR VPWR _04805_ sky130_fd_sc_hd__and3_1
XTAP_TAPCELL_ROW_28_685 VGND VPWR sky130_fd_sc_hd__tapvpwrvgnd_1
XFILLER_82_85 VPWR VGND VPWR VGND sky130_ef_sc_hd__decap_12
X_11786_ _04670_ _04728_ VGND VGND VPWR VPWR _04729_ sky130_fd_sc_hd__nand2b_1
XFILLER_32_159 VGND VGND VPWR VPWR sky130_fd_sc_hd__fill_1
X_10806_ _03479_ _03481_ net236 _03662_ VGND VGND VPWR VPWR _03663_ sky130_fd_sc_hd__a211o_1
XFILLER_9_333 VGND VGND VPWR VPWR sky130_fd_sc_hd__decap_3
X_10737_ _03396_ _03585_ VGND VGND VPWR VPWR _03588_ sky130_fd_sc_hd__xnor2_1
XFILLER_70_7 VGND VGND VPWR VPWR sky130_fd_sc_hd__decap_8
XFILLER_127_721 VGND VGND VPWR VPWR sky130_fd_sc_hd__decap_6
X_10668_ _03362_ _03377_ _03376_ VGND VGND VPWR VPWR _03512_ sky130_fd_sc_hd__o21ai_2
X_12407_ net454 net582 VGND VGND VPWR VPWR _05408_ sky130_fd_sc_hd__nand2_1
XFILLER_127_765 VPWR VGND VPWR VGND sky130_ef_sc_hd__decap_12
XFILLER_126_253 VGND VGND VPWR VPWR sky130_fd_sc_hd__decap_8
X_13387_ clknet_3_0__leaf_clk _00001_ _00097_ VGND VGND VPWR VPWR net201 sky130_fd_sc_hd__dfrtp_1
X_10599_ _02011_ net342 _03435_ _03436_ VGND VGND VPWR VPWR _03437_ sky130_fd_sc_hd__a22o_1
XFILLER_5_561 VPWR VGND VPWR VGND sky130_ef_sc_hd__decap_12
X_12338_ _05329_ _05331_ VGND VGND VPWR VPWR _05332_ sky130_fd_sc_hd__nand2_1
XFILLER_99_159 VGND VGND VPWR VPWR sky130_fd_sc_hd__decap_8
X_12269_ _05080_ _05256_ VGND VGND VPWR VPWR _05257_ sky130_fd_sc_hd__xnor2_1
XTAP_TAPCELL_ROW_52_1023 VGND VPWR sky130_fd_sc_hd__tapvpwrvgnd_1
XFILLER_122_492 VGND VGND VPWR VPWR sky130_fd_sc_hd__decap_3
XFILLER_110_643 VGND VGND VPWR VPWR sky130_fd_sc_hd__fill_1
XFILLER_110_632 VGND VGND VPWR VPWR sky130_fd_sc_hd__fill_2
X_06830_ _03653_ _03664_ VGND VGND VPWR VPWR _03675_ sky130_fd_sc_hd__nand2_1
XFILLER_83_505 VGND VGND VPWR VPWR sky130_fd_sc_hd__decap_6
XTAP_TAPCELL_ROW_108_1812 VGND VPWR sky130_fd_sc_hd__tapvpwrvgnd_1
XTAP_TAPCELL_ROW_108_1801 VGND VPWR sky130_fd_sc_hd__tapvpwrvgnd_1
X_06761_ net252 net521 VGND VGND VPWR VPWR _02921_ sky130_fd_sc_hd__and2_1
XFILLER_95_387 VGND VGND VPWR VPWR sky130_fd_sc_hd__fill_1
X_09480_ _02220_ _02221_ VGND VGND VPWR VPWR _02223_ sky130_fd_sc_hd__xnor2_1
X_08500_ _01168_ _01173_ _01228_ VGND VGND VPWR VPWR _01229_ sky130_fd_sc_hd__o21ai_2
X_06692_ net477 VGND VGND VPWR VPWR _02175_ sky130_fd_sc_hd__inv_4
XTAP_TAPCELL_ROW_47_950 VGND VPWR sky130_fd_sc_hd__tapvpwrvgnd_1
XFILLER_36_432 VGND VGND VPWR VPWR sky130_fd_sc_hd__fill_2
XFILLER_102_29 VGND VGND VPWR VPWR sky130_fd_sc_hd__decap_3
X_08431_ _01159_ _01160_ VGND VGND VPWR VPWR _01161_ sky130_fd_sc_hd__nor2_1
XFILLER_51_446 VGND VGND VPWR VPWR sky130_fd_sc_hd__fill_2
XFILLER_17_690 VPWR VGND VPWR VGND sky130_ef_sc_hd__decap_12
XFILLER_24_649 VGND VGND VPWR VPWR sky130_fd_sc_hd__fill_2
XFILLER_36_498 VGND VGND VPWR VPWR sky130_fd_sc_hd__decap_3
X_08362_ _01089_ _01091_ _01092_ VGND VGND VPWR VPWR _01094_ sky130_fd_sc_hd__o21ai_1
XFILLER_51_479 VGND VGND VPWR VPWR sky130_fd_sc_hd__fill_1
X_08293_ _01026_ _01027_ VGND VGND VPWR VPWR _01028_ sky130_fd_sc_hd__nand2b_1
X_07313_ _06602_ _06603_ VGND VGND VPWR VPWR _06604_ sky130_fd_sc_hd__nand2_1
XTAP_TAPCELL_ROW_63_1174 VGND VPWR sky130_fd_sc_hd__tapvpwrvgnd_1
XFILLER_32_671 VPWR VGND VPWR VGND sky130_ef_sc_hd__decap_12
X_07244_ _05385_ _06404_ VGND VGND VPWR VPWR _06535_ sky130_fd_sc_hd__nand2_1
XFILLER_31_181 VPWR VGND VPWR VGND sky130_ef_sc_hd__decap_12
XFILLER_11_15 VPWR VGND VPWR VGND sky130_ef_sc_hd__decap_12
XFILLER_127_15 VPWR VGND VPWR VGND sky130_ef_sc_hd__decap_12
XTAP_TAPCELL_ROW_119_1963 VGND VPWR sky130_fd_sc_hd__tapvpwrvgnd_1
X_07175_ _06464_ _06465_ _06466_ VGND VGND VPWR VPWR _06467_ sky130_fd_sc_hd__or3_1
XFILLER_132_212 VGND VGND VPWR VPWR sky130_fd_sc_hd__decap_4
XFILLER_117_275 VGND VGND VPWR VPWR sky130_fd_sc_hd__decap_4
Xfanout323 net66 VGND VGND VPWR VPWR net323 sky130_fd_sc_hd__clkbuf_2
Xfanout301 net74 VGND VGND VPWR VPWR net301 sky130_fd_sc_hd__buf_2
Xfanout312 net315 VGND VGND VPWR VPWR net312 sky130_fd_sc_hd__buf_4
XFILLER_86_332 VPWR VGND VPWR VGND sky130_ef_sc_hd__decap_12
Xfanout356 net5 VGND VGND VPWR VPWR net356 sky130_fd_sc_hd__buf_8
Xfanout334 net337 VGND VGND VPWR VPWR net334 sky130_fd_sc_hd__buf_2
Xfanout345 net55 VGND VGND VPWR VPWR net345 sky130_fd_sc_hd__dlymetal6s2s_1
X_09816_ _02585_ _02586_ VGND VGND VPWR VPWR _02587_ sky130_fd_sc_hd__nor2_1
XFILLER_100_131 VGND VGND VPWR VPWR sky130_fd_sc_hd__decap_8
XFILLER_86_365 VGND VGND VPWR VPWR sky130_fd_sc_hd__decap_4
Xfanout389 net35 VGND VGND VPWR VPWR net389 sky130_fd_sc_hd__buf_6
Xfanout378 net379 VGND VGND VPWR VPWR net378 sky130_fd_sc_hd__buf_8
Xfanout367 net45 VGND VGND VPWR VPWR net367 sky130_fd_sc_hd__buf_1
X_06959_ _03675_ _03696_ _03653_ VGND VGND VPWR VPWR _05079_ sky130_fd_sc_hd__o21ai_1
XFILLER_100_175 VGND VGND VPWR VPWR sky130_fd_sc_hd__decap_4
XFILLER_100_153 VGND VGND VPWR VPWR sky130_fd_sc_hd__decap_8
XFILLER_86_376 VPWR VGND VPWR VGND sky130_ef_sc_hd__decap_12
XFILLER_74_516 VGND VGND VPWR VPWR sky130_fd_sc_hd__decap_8
X_09747_ _01676_ _02388_ _02387_ VGND VGND VPWR VPWR _02512_ sky130_fd_sc_hd__a21oi_1
XFILLER_39_270 VGND VGND VPWR VPWR sky130_fd_sc_hd__decap_8
XFILLER_67_590 VGND VGND VPWR VPWR sky130_fd_sc_hd__decap_6
XFILLER_39_281 VGND VGND VPWR VPWR sky130_fd_sc_hd__decap_8
XFILLER_39_292 VPWR VGND VPWR VGND sky130_ef_sc_hd__decap_12
X_09678_ _02337_ _02344_ _02343_ VGND VGND VPWR VPWR _02437_ sky130_fd_sc_hd__a21oi_1
XFILLER_55_796 VGND VGND VPWR VPWR sky130_fd_sc_hd__decap_8
XFILLER_55_785 VGND VGND VPWR VPWR sky130_fd_sc_hd__fill_2
XFILLER_36_67 VGND VGND VPWR VPWR sky130_fd_sc_hd__fill_2
X_08629_ _01355_ _01356_ VGND VGND VPWR VPWR _01357_ sky130_fd_sc_hd__and2_1
XFILLER_70_744 VGND VGND VPWR VPWR sky130_fd_sc_hd__decap_4
XFILLER_14_126 VGND VGND VPWR VPWR sky130_fd_sc_hd__decap_6
XFILLER_70_788 VGND VGND VPWR VPWR sky130_fd_sc_hd__decap_3
X_11640_ _03055_ _02869_ VGND VGND VPWR VPWR _00012_ sky130_fd_sc_hd__xnor2_1
XTAP_TAPCELL_ROW_25_644 VGND VPWR sky130_fd_sc_hd__tapvpwrvgnd_1
XFILLER_52_66 VGND VGND VPWR VPWR sky130_fd_sc_hd__decap_4
XFILLER_52_44 VGND VGND VPWR VPWR sky130_fd_sc_hd__decap_4
X_11571_ _04497_ _04498_ VGND VGND VPWR VPWR _04499_ sky130_fd_sc_hd__and2b_1
X_13310_ net396 VGND VGND VPWR VPWR _00084_ sky130_fd_sc_hd__inv_2
XFILLER_52_88 VGND VGND VPWR VPWR sky130_fd_sc_hd__decap_6
X_10522_ _03349_ _03350_ VGND VGND VPWR VPWR _03352_ sky130_fd_sc_hd__xnor2_2
XFILLER_10_365 VPWR VGND VPWR VGND sky130_ef_sc_hd__decap_12
XFILLER_109_754 VPWR VGND VPWR VGND sky130_ef_sc_hd__decap_12
XFILLER_108_253 VGND VGND VPWR VPWR sky130_fd_sc_hd__decap_3
XTAP_TAPCELL_ROW_94_1613 VGND VPWR sky130_fd_sc_hd__tapvpwrvgnd_1
X_10453_ _03255_ _03276_ VGND VGND VPWR VPWR _03277_ sky130_fd_sc_hd__xnor2_1
X_13241_ _06090_ _06218_ _06093_ _06317_ _06215_ VGND VGND VPWR VPWR _06318_ sky130_fd_sc_hd__o311a_4
XFILLER_124_713 VPWR VGND VPWR VGND sky130_ef_sc_hd__decap_12
X_10384_ _03200_ _03201_ VGND VGND VPWR VPWR _03202_ sky130_fd_sc_hd__or2_1
X_13172_ _06241_ _06242_ VGND VGND VPWR VPWR _06243_ sky130_fd_sc_hd__nand2b_1
XFILLER_124_757 VPWR VGND VPWR VGND sky130_ef_sc_hd__decap_12
XFILLER_123_223 VGND VGND VPWR VPWR sky130_fd_sc_hd__fill_1
X_12123_ _05093_ _05094_ _05095_ VGND VGND VPWR VPWR _05097_ sky130_fd_sc_hd__a21o_1
XFILLER_2_531 VGND VGND VPWR VPWR sky130_fd_sc_hd__fill_1
XFILLER_123_256 VGND VGND VPWR VPWR sky130_fd_sc_hd__decap_3
X_12054_ _04985_ _05021_ VGND VGND VPWR VPWR _05022_ sky130_fd_sc_hd__xnor2_1
XFILLER_93_803 VGND VGND VPWR VPWR sky130_fd_sc_hd__fill_1
X_11005_ _03878_ _03879_ VGND VGND VPWR VPWR _03880_ sky130_fd_sc_hd__nor2_1
XFILLER_38_708 VPWR VGND VPWR VGND sky130_ef_sc_hd__decap_12
XFILLER_92_313 VGND VGND VPWR VPWR sky130_fd_sc_hd__fill_1
XFILLER_92_302 VGND VGND VPWR VPWR sky130_fd_sc_hd__decap_6
XFILLER_18_454 VGND VGND VPWR VPWR sky130_fd_sc_hd__decap_3
X_12956_ _05890_ _05898_ _05901_ VGND VGND VPWR VPWR _06007_ sky130_fd_sc_hd__a21bo_1
X_11907_ _04859_ _04860_ VGND VGND VPWR VPWR _04862_ sky130_fd_sc_hd__xnor2_1
X_12887_ _05930_ _05931_ VGND VGND VPWR VPWR _05933_ sky130_fd_sc_hd__nor2_1
XTAP_TAPCELL_ROW_103_1742 VGND VPWR sky130_fd_sc_hd__tapvpwrvgnd_1
XTAP_TAPCELL_ROW_103_1731 VGND VPWR sky130_fd_sc_hd__tapvpwrvgnd_1
X_11838_ _04778_ _04779_ _04786_ VGND VGND VPWR VPWR _04787_ sky130_fd_sc_hd__nand3_2
X_11769_ _04700_ _04710_ VGND VGND VPWR VPWR _04711_ sky130_fd_sc_hd__nor2_1
XFILLER_9_163 VGND VGND VPWR VPWR sky130_fd_sc_hd__decap_4
XTAP_TAPCELL_ROW_132_2149 VGND VPWR sky130_fd_sc_hd__tapvpwrvgnd_1
XTAP_TAPCELL_ROW_132_2138 VGND VPWR sky130_fd_sc_hd__tapvpwrvgnd_1
XFILLER_114_234 VGND VGND VPWR VPWR sky130_fd_sc_hd__decap_8
XFILLER_5_391 VGND VGND VPWR VPWR sky130_fd_sc_hd__fill_1
X_08980_ net291 net340 net161 VGND VGND VPWR VPWR _01706_ sky130_fd_sc_hd__a21oi_1
XFILLER_130_749 VGND VGND VPWR VPWR sky130_fd_sc_hd__decap_6
XTAP_TAPCELL_ROW_114_1893 VGND VPWR sky130_fd_sc_hd__tapvpwrvgnd_1
X_07931_ net681 _00333_ VGND VGND VPWR VPWR _00669_ sky130_fd_sc_hd__nand2_1
XFILLER_68_321 VPWR VGND VPWR VGND sky130_ef_sc_hd__decap_12
X_07862_ _00478_ _00481_ VGND VGND VPWR VPWR _00600_ sky130_fd_sc_hd__nor2_1
XFILLER_68_365 VGND VGND VPWR VPWR sky130_fd_sc_hd__decap_4
X_06813_ net688 net319 _03467_ _03445_ VGND VGND VPWR VPWR _03489_ sky130_fd_sc_hd__a31o_1
X_09601_ _02321_ _02353_ VGND VGND VPWR VPWR _02354_ sky130_fd_sc_hd__or2_1
XFILLER_96_685 VPWR VGND VPWR VGND sky130_ef_sc_hd__decap_12
XFILLER_83_324 VGND VGND VPWR VPWR sky130_fd_sc_hd__fill_1
XFILLER_68_387 VGND VGND VPWR VPWR sky130_fd_sc_hd__fill_1
XTAP_TAPCELL_ROW_3_339 VGND VPWR sky130_fd_sc_hd__tapvpwrvgnd_1
XFILLER_3_93 VPWR VGND VPWR VGND sky130_ef_sc_hd__decap_12
X_09532_ _02239_ _02277_ VGND VGND VPWR VPWR _02279_ sky130_fd_sc_hd__xnor2_2
XFILLER_113_39 VPWR VGND VPWR VGND sky130_ef_sc_hd__decap_12
XFILLER_83_335 VGND VGND VPWR VPWR sky130_fd_sc_hd__fill_1
X_07793_ _00530_ _00531_ VGND VGND VPWR VPWR _00532_ sky130_fd_sc_hd__and2b_1
XFILLER_49_590 VGND VGND VPWR VPWR sky130_fd_sc_hd__decap_8
X_06744_ net839 net514 net388 net390 VGND VGND VPWR VPWR _02739_ sky130_fd_sc_hd__and4_1
XTAP_TAPCELL_ROW_65_1203 VGND VPWR sky130_fd_sc_hd__tapvpwrvgnd_1
XFILLER_64_560 VGND VGND VPWR VPWR sky130_fd_sc_hd__fill_1
XFILLER_37_763 VPWR VGND VPWR VGND sky130_ef_sc_hd__decap_12
XFILLER_37_785 VPWR VGND VPWR VGND sky130_ef_sc_hd__decap_12
X_09463_ _02199_ _02201_ VGND VGND VPWR VPWR _02204_ sky130_fd_sc_hd__xor2_1
XFILLER_36_295 VGND VGND VPWR VPWR sky130_fd_sc_hd__decap_3
X_09394_ _01983_ _01994_ _01993_ VGND VGND VPWR VPWR _02128_ sky130_fd_sc_hd__o21ai_1
X_08414_ _01110_ _01143_ VGND VGND VPWR VPWR _01144_ sky130_fd_sc_hd__xnor2_1
XFILLER_52_755 VGND VGND VPWR VPWR sky130_fd_sc_hd__fill_1
X_08345_ _01076_ _01078_ VGND VGND VPWR VPWR _01079_ sky130_fd_sc_hd__xnor2_1
XFILLER_51_265 VGND VGND VPWR VPWR sky130_fd_sc_hd__fill_2
XTAP_TAPCELL_ROW_22_603 VGND VPWR sky130_fd_sc_hd__tapvpwrvgnd_1
X_08276_ _00998_ _01009_ _01010_ VGND VGND VPWR VPWR _01011_ sky130_fd_sc_hd__or3_1
XTAP_TAPCELL_ROW_50_989 VGND VPWR sky130_fd_sc_hd__tapvpwrvgnd_1
X_07227_ net532 net105 VGND VGND VPWR VPWR _06518_ sky130_fd_sc_hd__and2b_1
X_07158_ _06447_ _06448_ _05801_ VGND VGND VPWR VPWR _06450_ sky130_fd_sc_hd__a21oi_1
XFILLER_3_317 VPWR VGND VPWR VGND sky130_ef_sc_hd__decap_12
XFILLER_106_757 VGND VGND VPWR VPWR sky130_fd_sc_hd__fill_2
XFILLER_106_746 VGND VGND VPWR VPWR sky130_fd_sc_hd__decap_8
XFILLER_105_223 VGND VGND VPWR VPWR sky130_fd_sc_hd__fill_1
XTAP_TAPCELL_ROW_76_1365 VGND VPWR sky130_fd_sc_hd__tapvpwrvgnd_1
XTAP_TAPCELL_ROW_76_1354 VGND VPWR sky130_fd_sc_hd__tapvpwrvgnd_1
X_07089_ _06379_ _06380_ VGND VGND VPWR VPWR _06381_ sky130_fd_sc_hd__or2_1
XFILLER_87_630 VPWR VGND VPWR VGND sky130_ef_sc_hd__decap_12
XFILLER_101_462 VPWR VGND VPWR VGND sky130_ef_sc_hd__decap_12
XFILLER_86_162 VGND VGND VPWR VPWR sky130_fd_sc_hd__decap_6
XFILLER_74_302 VGND VGND VPWR VPWR sky130_fd_sc_hd__decap_6
XFILLER_19_218 VGND VGND VPWR VPWR sky130_fd_sc_hd__decap_6
XFILLER_19_229 VGND VGND VPWR VPWR sky130_fd_sc_hd__fill_1
XFILLER_86_184 VGND VGND VPWR VPWR sky130_fd_sc_hd__fill_2
X_12810_ _05689_ _05847_ VGND VGND VPWR VPWR _05848_ sky130_fd_sc_hd__nand2_1
XFILLER_27_262 VGND VGND VPWR VPWR sky130_fd_sc_hd__fill_2
XFILLER_15_424 VGND VGND VPWR VPWR sky130_fd_sc_hd__decap_8
X_12741_ _05621_ _05630_ _05629_ VGND VGND VPWR VPWR _05773_ sky130_fd_sc_hd__a21oi_1
X_12672_ _05686_ _05696_ VGND VGND VPWR VPWR _05697_ sky130_fd_sc_hd__xnor2_1
X_11623_ _04300_ _04427_ _04298_ VGND VGND VPWR VPWR _04555_ sky130_fd_sc_hd__o21a_1
XFILLER_30_405 VGND VGND VPWR VPWR sky130_fd_sc_hd__decap_3
XFILLER_8_27 VGND VGND VPWR VPWR sky130_fd_sc_hd__fill_1
XFILLER_30_449 VGND VGND VPWR VPWR sky130_fd_sc_hd__decap_4
X_11554_ _04366_ _04479_ VGND VGND VPWR VPWR _04480_ sky130_fd_sc_hd__xnor2_1
X_10505_ _03065_ _03199_ _03332_ VGND VGND VPWR VPWR _03333_ sky130_fd_sc_hd__or3_1
XFILLER_10_195 VGND VGND VPWR VPWR sky130_fd_sc_hd__fill_1
X_11485_ _04402_ _04403_ VGND VGND VPWR VPWR _04405_ sky130_fd_sc_hd__xnor2_1
XFILLER_136_370 VGND VGND VPWR VPWR sky130_fd_sc_hd__decap_8
X_10436_ net450 net564 net562 net458 VGND VGND VPWR VPWR _03258_ sky130_fd_sc_hd__a22o_1
X_13224_ _06269_ _06299_ VGND VGND VPWR VPWR _06300_ sky130_fd_sc_hd__xnor2_1
XFILLER_6_177 VPWR VGND VPWR VGND sky130_ef_sc_hd__decap_12
XFILLER_124_521 VGND VGND VPWR VPWR sky130_fd_sc_hd__decap_8
X_10367_ _02940_ _03081_ _03083_ VGND VGND VPWR VPWR _03184_ sky130_fd_sc_hd__a21o_1
X_13155_ _06099_ _06223_ VGND VGND VPWR VPWR _06224_ sky130_fd_sc_hd__nor2_1
X_10298_ _02962_ _03108_ VGND VGND VPWR VPWR _03109_ sky130_fd_sc_hd__xor2_1
X_13086_ _06147_ _06148_ VGND VGND VPWR VPWR _06149_ sky130_fd_sc_hd__nand2_1
X_12106_ net413 net601 net361 net698 VGND VGND VPWR VPWR _05078_ sky130_fd_sc_hd__a22oi_1
X_12037_ net568 net300 VGND VGND VPWR VPWR _05004_ sky130_fd_sc_hd__nand2_1
XFILLER_93_611 VGND VGND VPWR VPWR sky130_fd_sc_hd__fill_2
XFILLER_65_335 VGND VGND VPWR VPWR sky130_fd_sc_hd__fill_1
XFILLER_18_251 VGND VGND VPWR VPWR sky130_fd_sc_hd__fill_1
XFILLER_19_785 VPWR VGND VPWR VGND sky130_ef_sc_hd__decap_12
XFILLER_46_571 VGND VGND VPWR VPWR sky130_fd_sc_hd__decap_3
X_12939_ _05891_ _05897_ _05785_ VGND VGND VPWR VPWR _05989_ sky130_fd_sc_hd__a21oi_1
XFILLER_33_243 VGND VGND VPWR VPWR sky130_fd_sc_hd__decap_8
XFILLER_34_777 VPWR VGND VPWR VGND sky130_ef_sc_hd__decap_12
XFILLER_21_416 VGND VGND VPWR VPWR sky130_fd_sc_hd__fill_1
X_08130_ net483 _02153_ VGND VGND VPWR VPWR _00866_ sky130_fd_sc_hd__nor2_1
XTAP_TAPCELL_ROW_60_1133 VGND VPWR sky130_fd_sc_hd__tapvpwrvgnd_1
XFILLER_21_449 VPWR VGND VPWR VGND sky130_ef_sc_hd__decap_12
XFILLER_119_348 VGND VGND VPWR VPWR sky130_fd_sc_hd__decap_3
X_08061_ _00458_ _00797_ VGND VGND VPWR VPWR _00798_ sky130_fd_sc_hd__or2_1
XFILLER_134_307 VGND VGND VPWR VPWR sky130_fd_sc_hd__fill_1
XTAP_TAPCELL_ROW_116_1922 VGND VPWR sky130_fd_sc_hd__tapvpwrvgnd_1
X_07012_ _05637_ _05648_ VGND VGND VPWR VPWR _05659_ sky130_fd_sc_hd__or2_1
XTAP_TAPCELL_ROW_8_409 VGND VPWR sky130_fd_sc_hd__tapvpwrvgnd_1
XFILLER_0_309 VPWR VGND VPWR VGND sky130_ef_sc_hd__decap_12
XFILLER_130_513 VPWR VGND VPWR VGND sky130_ef_sc_hd__decap_12
XFILLER_102_204 VGND VGND VPWR VPWR sky130_fd_sc_hd__decap_8
X_08963_ _01686_ _01687_ _01688_ VGND VGND VPWR VPWR _01689_ sky130_fd_sc_hd__nand3_2
XFILLER_130_557 VPWR VGND VPWR VGND sky130_ef_sc_hd__decap_12
XFILLER_124_27 VGND VGND VPWR VPWR sky130_fd_sc_hd__fill_1
XFILLER_102_237 VGND VGND VPWR VPWR sky130_fd_sc_hd__fill_2
X_07914_ _00642_ _00650_ VGND VGND VPWR VPWR _00652_ sky130_fd_sc_hd__xnor2_1
X_08894_ net510 net126 net627 net525 VGND VGND VPWR VPWR _01620_ sky130_fd_sc_hd__a22oi_1
XTAP_TAPCELL_ROW_71_1295 VGND VPWR sky130_fd_sc_hd__tapvpwrvgnd_1
XTAP_TAPCELL_ROW_71_1284 VGND VPWR sky130_fd_sc_hd__tapvpwrvgnd_1
XFILLER_29_505 VPWR VGND VPWR VGND sky130_ef_sc_hd__decap_12
X_07845_ net305 net570 VGND VGND VPWR VPWR _00583_ sky130_fd_sc_hd__nand2_1
XFILLER_72_806 VGND VGND VPWR VPWR sky130_fd_sc_hd__fill_1
XFILLER_68_195 VGND VGND VPWR VPWR sky130_fd_sc_hd__fill_1
XFILLER_84_699 VGND VGND VPWR VPWR sky130_fd_sc_hd__fill_1
XFILLER_83_154 VPWR VGND VPWR VGND sky130_ef_sc_hd__decap_12
X_07776_ _00513_ _00514_ VGND VGND VPWR VPWR _00515_ sky130_fd_sc_hd__and2_1
X_09515_ _02099_ _02259_ VGND VGND VPWR VPWR _02260_ sky130_fd_sc_hd__xnor2_1
X_06727_ net527 net251 VGND VGND VPWR VPWR _02555_ sky130_fd_sc_hd__and2_1
XFILLER_17_69 VGND VGND VPWR VPWR sky130_fd_sc_hd__fill_1
X_09446_ _02176_ _02184_ VGND VGND VPWR VPWR _02185_ sky130_fd_sc_hd__xnor2_2
XTAP_TAPCELL_ROW_35_783 VGND VPWR sky130_fd_sc_hd__tapvpwrvgnd_1
X_09377_ _01781_ _01785_ VGND VGND VPWR VPWR _02110_ sky130_fd_sc_hd__nor2_2
XFILLER_24_298 VGND VGND VPWR VPWR sky130_fd_sc_hd__decap_8
XFILLER_33_57 VGND VGND VPWR VPWR sky130_fd_sc_hd__decap_8
X_08328_ _00187_ _00971_ _00970_ VGND VGND VPWR VPWR _01062_ sky130_fd_sc_hd__o21ai_1
XFILLER_33_79 VPWR VGND VPWR VGND sky130_ef_sc_hd__decap_12
X_08259_ _00785_ _00896_ _00993_ VGND VGND VPWR VPWR _00994_ sky130_fd_sc_hd__a21oi_1
XFILLER_118_370 VGND VGND VPWR VPWR sky130_fd_sc_hd__fill_2
XFILLER_109_3 VPWR VGND VPWR VGND sky130_ef_sc_hd__decap_12
XFILLER_4_637 VGND VGND VPWR VPWR sky130_fd_sc_hd__decap_6
XFILLER_3_125 VPWR VGND VPWR VGND sky130_ef_sc_hd__decap_12
X_11270_ _04169_ _04168_ VGND VGND VPWR VPWR _04170_ sky130_fd_sc_hd__and2b_1
XFILLER_79_416 VPWR VGND VPWR VGND sky130_ef_sc_hd__decap_12
X_10221_ _03012_ _03016_ _03015_ VGND VGND VPWR VPWR _03025_ sky130_fd_sc_hd__o21ai_1
XFILLER_3_169 VPWR VGND VPWR VGND sky130_ef_sc_hd__decap_12
XPHY_EDGE_ROW_18_Left_155 VGND VGND VPWR VPWR sky130_fd_sc_hd__decap_3
XFILLER_133_373 VPWR VGND VPWR VGND sky130_ef_sc_hd__decap_12
XFILLER_79_449 VGND VGND VPWR VPWR sky130_fd_sc_hd__decap_8
X_10152_ _02945_ _02948_ VGND VGND VPWR VPWR _02949_ sky130_fd_sc_hd__xnor2_1
XFILLER_94_408 VGND VGND VPWR VPWR sky130_fd_sc_hd__fill_2
X_10083_ _02871_ _02872_ VGND VGND VPWR VPWR _02873_ sky130_fd_sc_hd__or2_1
XFILLER_94_419 VGND VGND VPWR VPWR sky130_fd_sc_hd__fill_1
XFILLER_102_793 VPWR VGND VPWR VGND sky130_ef_sc_hd__decap_12
XTAP_TAPCELL_ROW_89_1545 VGND VPWR sky130_fd_sc_hd__tapvpwrvgnd_1
XTAP_TAPCELL_ROW_89_1534 VGND VPWR sky130_fd_sc_hd__tapvpwrvgnd_1
XFILLER_74_121 VGND VGND VPWR VPWR sky130_fd_sc_hd__decap_4
XFILLER_47_335 VGND VGND VPWR VPWR sky130_fd_sc_hd__fill_1
XFILLER_74_42 VGND VGND VPWR VPWR sky130_fd_sc_hd__decap_4
XPHY_EDGE_ROW_27_Left_164 VGND VGND VPWR VPWR sky130_fd_sc_hd__decap_3
XFILLER_28_593 VGND VGND VPWR VPWR sky130_fd_sc_hd__fill_1
XFILLER_90_669 VGND VGND VPWR VPWR sky130_fd_sc_hd__decap_6
XFILLER_74_97 VGND VGND VPWR VPWR sky130_fd_sc_hd__decap_6
X_10985_ _03690_ _03689_ _03687_ VGND VGND VPWR VPWR _03859_ sky130_fd_sc_hd__o21bai_1
XFILLER_43_541 VPWR VGND VPWR VGND sky130_ef_sc_hd__decap_12
XFILLER_15_243 VPWR VGND VPWR VGND sky130_ef_sc_hd__decap_12
X_12724_ _05752_ _05753_ VGND VGND VPWR VPWR _05754_ sky130_fd_sc_hd__nand2_1
XFILLER_31_703 VPWR VGND VPWR VGND sky130_ef_sc_hd__decap_12
XTAP_TAPCELL_ROW_100_1701 VGND VPWR sky130_fd_sc_hd__tapvpwrvgnd_1
XFILLER_43_596 VGND VGND VPWR VPWR sky130_fd_sc_hd__decap_4
XFILLER_31_736 VGND VGND VPWR VPWR sky130_fd_sc_hd__decap_6
XFILLER_30_235 VPWR VGND VPWR VGND sky130_ef_sc_hd__decap_12
XFILLER_31_758 VPWR VGND VPWR VGND sky130_ef_sc_hd__decap_12
X_12655_ net617 net284 _02273_ net640 VGND VGND VPWR VPWR _05678_ sky130_fd_sc_hd__o2bb2a_1
XFILLER_90_85 VPWR VGND VPWR VGND sky130_ef_sc_hd__decap_12
X_11606_ _04473_ _04474_ _04246_ VGND VGND VPWR VPWR _04536_ sky130_fd_sc_hd__mux2_1
X_12586_ net312 net366 net364 net334 VGND VGND VPWR VPWR _05603_ sky130_fd_sc_hd__a22o_1
X_11537_ _04444_ _04460_ VGND VGND VPWR VPWR _04462_ sky130_fd_sc_hd__and2b_1
XTAP_TAPCELL_ROW_13_477 VGND VPWR sky130_fd_sc_hd__tapvpwrvgnd_1
XFILLER_109_381 VGND VGND VPWR VPWR sky130_fd_sc_hd__fill_1
X_11468_ _04377_ _04384_ VGND VGND VPWR VPWR _04387_ sky130_fd_sc_hd__xor2_1
XPHY_EDGE_ROW_36_Left_173 VGND VGND VPWR VPWR sky130_fd_sc_hd__decap_3
XFILLER_124_351 VPWR VGND VPWR VGND sky130_ef_sc_hd__decap_12
XFILLER_98_714 VGND VGND VPWR VPWR sky130_fd_sc_hd__decap_8
X_10419_ _03229_ _03239_ VGND VGND VPWR VPWR _03240_ sky130_fd_sc_hd__xor2_1
X_11399_ _04300_ _04310_ VGND VGND VPWR VPWR _04311_ sky130_fd_sc_hd__xnor2_1
X_13207_ _05525_ _06180_ _06182_ VGND VGND VPWR VPWR _06282_ sky130_fd_sc_hd__o21ai_1
X_13138_ _06071_ _06073_ _06206_ VGND VGND VPWR VPWR _06207_ sky130_fd_sc_hd__o21ba_1
XTAP_TAPCELL_ROW_111_1852 VGND VPWR sky130_fd_sc_hd__tapvpwrvgnd_1
XFILLER_97_279 VGND VGND VPWR VPWR sky130_fd_sc_hd__fill_1
X_13069_ _06015_ _06027_ _06026_ VGND VGND VPWR VPWR _06131_ sky130_fd_sc_hd__a21o_1
XPHY_EDGE_ROW_119_Right_119 VGND VGND VPWR VPWR sky130_fd_sc_hd__decap_3
XFILLER_38_346 VGND VGND VPWR VPWR sky130_fd_sc_hd__decap_3
X_07630_ _00368_ _00369_ VGND VGND VPWR VPWR _00370_ sky130_fd_sc_hd__xor2_1
XFILLER_66_666 VGND VGND VPWR VPWR sky130_fd_sc_hd__decap_8
XPHY_EDGE_ROW_45_Left_182 VGND VGND VPWR VPWR sky130_fd_sc_hd__decap_3
XFILLER_38_368 VGND VGND VPWR VPWR sky130_fd_sc_hd__decap_4
X_07561_ _00131_ _00133_ _00299_ VGND VGND VPWR VPWR _00301_ sky130_fd_sc_hd__and3_1
XFILLER_80_135 VGND VGND VPWR VPWR sky130_fd_sc_hd__decap_4
X_09300_ _01867_ _01868_ _01866_ VGND VGND VPWR VPWR _02026_ sky130_fd_sc_hd__a21boi_1
XFILLER_110_29 VGND VGND VPWR VPWR sky130_fd_sc_hd__decap_6
XFILLER_80_179 VGND VGND VPWR VPWR sky130_fd_sc_hd__decap_8
X_07492_ _02033_ _02109_ _00229_ _00230_ VGND VGND VPWR VPWR _00233_ sky130_fd_sc_hd__or4_4
XFILLER_22_714 VPWR VGND VPWR VGND sky130_ef_sc_hd__decap_12
X_09231_ _01944_ _01953_ VGND VGND VPWR VPWR _01955_ sky130_fd_sc_hd__xor2_2
XFILLER_61_393 VPWR VGND VPWR VGND sky130_ef_sc_hd__decap_12
XTAP_TAPCELL_ROW_32_742 VGND VPWR sky130_fd_sc_hd__tapvpwrvgnd_1
X_09162_ _01882_ _01884_ _01865_ VGND VGND VPWR VPWR _01887_ sky130_fd_sc_hd__a21o_1
XFILLER_21_279 VGND VGND VPWR VPWR sky130_fd_sc_hd__fill_1
XFILLER_119_27 VPWR VGND VPWR VGND sky130_ef_sc_hd__decap_12
X_08113_ _00737_ _00848_ VGND VGND VPWR VPWR _00849_ sky130_fd_sc_hd__or2_1
X_09093_ _01809_ _01817_ VGND VGND VPWR VPWR _01818_ sky130_fd_sc_hd__xnor2_1
XPHY_EDGE_ROW_54_Left_191 VGND VGND VPWR VPWR sky130_fd_sc_hd__decap_3
X_08044_ net570 net303 _02131_ net594 VGND VGND VPWR VPWR _00781_ sky130_fd_sc_hd__o2bb2a_1
XTAP_TAPCELL_ROW_73_1313 VGND VPWR sky130_fd_sc_hd__tapvpwrvgnd_1
XFILLER_135_15 VPWR VGND VPWR VGND sky130_ef_sc_hd__decap_12
XFILLER_115_373 VGND VGND VPWR VPWR sky130_fd_sc_hd__decap_8
XFILLER_103_502 VGND VGND VPWR VPWR sky130_fd_sc_hd__fill_2
XFILLER_89_747 VPWR VGND VPWR VGND sky130_ef_sc_hd__decap_12
XFILLER_1_629 VPWR VGND VPWR VGND sky130_ef_sc_hd__decap_12
X_09995_ net694 net352 net579 net467 VGND VGND VPWR VPWR _02779_ sky130_fd_sc_hd__a22o_1
X_08946_ _01669_ _01670_ _01640_ VGND VGND VPWR VPWR _01672_ sky130_fd_sc_hd__a21o_1
XFILLER_88_268 VGND VGND VPWR VPWR sky130_fd_sc_hd__fill_1
X_08877_ _01601_ _01602_ VGND VGND VPWR VPWR _01603_ sky130_fd_sc_hd__and2b_1
XFILLER_29_335 VGND VGND VPWR VPWR sky130_fd_sc_hd__fill_1
X_07828_ _00564_ _00565_ VGND VGND VPWR VPWR _00567_ sky130_fd_sc_hd__xor2_1
XFILLER_84_463 VPWR VGND VPWR VGND sky130_ef_sc_hd__decap_12
X_07759_ _00494_ _00497_ VGND VGND VPWR VPWR _00498_ sky130_fd_sc_hd__and2b_1
XTAP_TAPCELL_ROW_84_1475 VGND VPWR sky130_fd_sc_hd__tapvpwrvgnd_1
XTAP_TAPCELL_ROW_84_1464 VGND VPWR sky130_fd_sc_hd__tapvpwrvgnd_1
X_10770_ _03621_ _03622_ _03440_ _03442_ VGND VGND VPWR VPWR _03624_ sky130_fd_sc_hd__o211a_1
X_09429_ net291 net329 net327 VGND VGND VPWR VPWR _02167_ sky130_fd_sc_hd__and3_1
XFILLER_13_769 VPWR VGND VPWR VGND sky130_ef_sc_hd__decap_12
XFILLER_40_533 VGND VGND VPWR VPWR sky130_fd_sc_hd__decap_4
XFILLER_9_729 VPWR VGND VPWR VGND sky130_ef_sc_hd__decap_12
X_12440_ net337 net366 net364 net359 VGND VGND VPWR VPWR _05444_ sky130_fd_sc_hd__a22o_1
XTAP_TAPCELL_ROW_10_436 VGND VPWR sky130_fd_sc_hd__tapvpwrvgnd_1
X_12371_ net507 net661 net659 net524 VGND VGND VPWR VPWR _05368_ sky130_fd_sc_hd__a22o_1
XFILLER_4_401 VPWR VGND VPWR VGND sky130_ef_sc_hd__decap_12
X_11322_ _04224_ _04225_ VGND VGND VPWR VPWR _04227_ sky130_fd_sc_hd__xor2_1
XFILLER_69_31 VGND VGND VPWR VPWR sky130_fd_sc_hd__fill_2
XFILLER_5_39 VPWR VGND VPWR VGND sky130_ef_sc_hd__decap_12
XFILLER_4_445 VPWR VGND VPWR VGND sky130_ef_sc_hd__decap_12
X_11253_ _04023_ _04151_ VGND VGND VPWR VPWR _04152_ sky130_fd_sc_hd__xnor2_2
XFILLER_134_693 VGND VGND VPWR VPWR sky130_fd_sc_hd__decap_6
X_10204_ _02995_ net904 _03003_ VGND VGND VPWR VPWR _03006_ sky130_fd_sc_hd__a21oi_2
XFILLER_4_489 VPWR VGND VPWR VGND sky130_ef_sc_hd__decap_12
XFILLER_133_181 VGND VGND VPWR VPWR sky130_fd_sc_hd__decap_6
X_11184_ net331 net344 _03947_ _03946_ net308 VGND VGND VPWR VPWR _04076_ sky130_fd_sc_hd__a32o_1
XFILLER_121_365 VGND VGND VPWR VPWR sky130_fd_sc_hd__decap_6
XFILLER_121_354 VGND VGND VPWR VPWR sky130_fd_sc_hd__fill_1
XFILLER_88_780 VGND VGND VPWR VPWR sky130_fd_sc_hd__fill_1
XFILLER_79_279 VGND VGND VPWR VPWR sky130_fd_sc_hd__fill_1
X_10135_ net495 net656 net654 net504 VGND VGND VPWR VPWR _02930_ sky130_fd_sc_hd__a22o_1
XFILLER_0_673 VPWR VGND VPWR VGND sky130_ef_sc_hd__decap_12
XFILLER_125_81 VPWR VGND VPWR VGND sky130_ef_sc_hd__decap_12
XFILLER_87_290 VGND VGND VPWR VPWR sky130_fd_sc_hd__fill_2
X_10066_ net663 net282 net280 net686 VGND VGND VPWR VPWR _02855_ sky130_fd_sc_hd__a22oi_1
XFILLER_48_688 VGND VGND VPWR VPWR sky130_fd_sc_hd__fill_2
XFILLER_47_165 VGND VGND VPWR VPWR sky130_fd_sc_hd__decap_3
XFILLER_63_669 VGND VGND VPWR VPWR sky130_fd_sc_hd__decap_3
XFILLER_16_530 VGND VGND VPWR VPWR sky130_fd_sc_hd__fill_2
XFILLER_16_541 VGND VGND VPWR VPWR sky130_fd_sc_hd__decap_8
XTAP_TAPCELL_ROW_18_547 VGND VPWR sky130_fd_sc_hd__tapvpwrvgnd_1
XFILLER_71_680 VGND VGND VPWR VPWR sky130_fd_sc_hd__decap_4
X_10968_ _03837_ _03838_ _03779_ VGND VGND VPWR VPWR _03841_ sky130_fd_sc_hd__a21o_1
XFILLER_43_393 VPWR VGND VPWR VGND sky130_ef_sc_hd__decap_12
XFILLER_31_522 VGND VGND VPWR VPWR sky130_fd_sc_hd__fill_1
X_12707_ _05563_ _05569_ _05568_ VGND VGND VPWR VPWR _05736_ sky130_fd_sc_hd__a21oi_1
X_12638_ _05660_ _05658_ VGND VGND VPWR VPWR _00037_ sky130_fd_sc_hd__xnor2_1
X_10899_ net450 net153 VGND VGND VPWR VPWR _03765_ sky130_fd_sc_hd__and2b_1
X_12569_ net420 net585 net583 net437 VGND VGND VPWR VPWR _05585_ sky130_fd_sc_hd__a22oi_1
XFILLER_116_115 VPWR VGND VPWR VGND sky130_ef_sc_hd__decap_12
XFILLER_7_261 VPWR VGND VPWR VGND sky130_ef_sc_hd__decap_12
XFILLER_125_660 VPWR VGND VPWR VGND sky130_ef_sc_hd__decap_12
XFILLER_98_533 VPWR VGND VPWR VGND sky130_ef_sc_hd__decap_12
XFILLER_124_181 VPWR VGND VPWR VGND sky130_ef_sc_hd__decap_12
XFILLER_112_343 VGND VGND VPWR VPWR sky130_fd_sc_hd__fill_1
XFILLER_112_321 VGND VGND VPWR VPWR sky130_fd_sc_hd__fill_1
X_08800_ net439 net422 net555 net553 VGND VGND VPWR VPWR _01527_ sky130_fd_sc_hd__and4_1
XTAP_TAPCELL_ROW_55_1065 VGND VPWR sky130_fd_sc_hd__tapvpwrvgnd_1
XFILLER_112_365 VPWR VGND VPWR VGND sky130_ef_sc_hd__decap_12
XFILLER_105_18 VGND VGND VPWR VPWR sky130_fd_sc_hd__decap_8
X_06992_ _05407_ _05418_ _05396_ VGND VGND VPWR VPWR _05440_ sky130_fd_sc_hd__o21ai_1
XFILLER_100_516 VGND VGND VPWR VPWR sky130_fd_sc_hd__decap_3
X_09780_ _02120_ net624 _02546_ VGND VGND VPWR VPWR _02548_ sky130_fd_sc_hd__a21oi_1
XPHY_EDGE_ROW_7_Right_7 VGND VGND VPWR VPWR sky130_fd_sc_hd__decap_3
X_08731_ net693 net255 VGND VGND VPWR VPWR _01458_ sky130_fd_sc_hd__nand2_1
X_08662_ net464 net551 net548 net473 VGND VGND VPWR VPWR _01390_ sky130_fd_sc_hd__a22oi_1
XFILLER_38_154 VGND VGND VPWR VPWR sky130_fd_sc_hd__fill_2
XFILLER_39_677 VPWR VGND VPWR VGND sky130_ef_sc_hd__decap_12
X_07613_ _00352_ _00351_ VGND VGND VPWR VPWR _00353_ sky130_fd_sc_hd__nand2b_1
XFILLER_54_614 VPWR VGND VPWR VGND sky130_ef_sc_hd__decap_12
XFILLER_53_113 VPWR VGND VPWR VGND sky130_ef_sc_hd__decap_12
XTAP_TAPCELL_ROW_37_812 VGND VPWR sky130_fd_sc_hd__tapvpwrvgnd_1
XFILLER_121_39 VPWR VGND VPWR VGND sky130_ef_sc_hd__decap_12
X_08593_ _01209_ _01321_ VGND VGND VPWR VPWR _01322_ sky130_fd_sc_hd__and2_1
X_07544_ _00281_ _00282_ VGND VGND VPWR VPWR _00284_ sky130_fd_sc_hd__xor2_1
XFILLER_34_360 VGND VGND VPWR VPWR sky130_fd_sc_hd__decap_4
X_07475_ _00200_ _00214_ _00215_ VGND VGND VPWR VPWR _00216_ sky130_fd_sc_hd__and3_1
XFILLER_14_15 VPWR VGND VPWR VGND sky130_ef_sc_hd__decap_12
XFILLER_22_511 VPWR VGND VPWR VGND sky130_ef_sc_hd__decap_12
XFILLER_22_544 VGND VGND VPWR VPWR sky130_fd_sc_hd__fill_1
X_09214_ _01769_ _01771_ _01937_ VGND VGND VPWR VPWR _01938_ sky130_fd_sc_hd__a21oi_1
XFILLER_22_566 VGND VGND VPWR VPWR sky130_fd_sc_hd__decap_3
XFILLER_108_627 VGND VGND VPWR VPWR sky130_fd_sc_hd__fill_1
X_09145_ _01866_ _01867_ _01868_ VGND VGND VPWR VPWR _01870_ sky130_fd_sc_hd__nand3_1
X_09076_ _01755_ _01799_ VGND VGND VPWR VPWR _01801_ sky130_fd_sc_hd__xnor2_1
XFILLER_100_7 VPWR VGND VPWR VGND sky130_ef_sc_hd__decap_12
X_08027_ _00759_ _00762_ VGND VGND VPWR VPWR _00764_ sky130_fd_sc_hd__xnor2_1
XFILLER_116_660 VPWR VGND VPWR VGND sky130_ef_sc_hd__decap_12
XFILLER_131_641 VPWR VGND VPWR VGND sky130_ef_sc_hd__decap_12
XFILLER_115_181 VGND VGND VPWR VPWR sky130_fd_sc_hd__fill_1
XFILLER_103_343 VGND VGND VPWR VPWR sky130_fd_sc_hd__decap_6
XFILLER_39_12 VGND VGND VPWR VPWR sky130_fd_sc_hd__fill_1
XFILLER_131_685 VPWR VGND VPWR VGND sky130_ef_sc_hd__decap_12
X_09978_ _02419_ _02651_ _02333_ VGND VGND VPWR VPWR _02763_ sky130_fd_sc_hd__a21oi_1
XFILLER_76_205 VGND VGND VPWR VPWR sky130_fd_sc_hd__fill_2
XFILLER_39_34 VGND VGND VPWR VPWR sky130_fd_sc_hd__fill_1
XFILLER_130_195 VGND VGND VPWR VPWR sky130_fd_sc_hd__fill_1
XFILLER_103_387 VGND VGND VPWR VPWR sky130_fd_sc_hd__decap_4
X_08929_ _01644_ _01654_ VGND VGND VPWR VPWR _01655_ sky130_fd_sc_hd__xnor2_1
XFILLER_76_249 VGND VGND VPWR VPWR sky130_fd_sc_hd__decap_3
XFILLER_29_110 VGND VGND VPWR VPWR sky130_fd_sc_hd__fill_2
XTAP_TAPCELL_ROW_86_1504 VGND VPWR sky130_fd_sc_hd__tapvpwrvgnd_1
XFILLER_57_441 VGND VGND VPWR VPWR sky130_fd_sc_hd__decap_6
X_11940_ _04896_ _04897_ VGND VGND VPWR VPWR _04898_ sky130_fd_sc_hd__and2b_1
XFILLER_45_614 VGND VGND VPWR VPWR sky130_fd_sc_hd__fill_2
X_11871_ _04811_ _04819_ _04817_ VGND VGND VPWR VPWR _04823_ sky130_fd_sc_hd__a21oi_1
XFILLER_45_647 VPWR VGND VPWR VGND sky130_ef_sc_hd__decap_12
X_10822_ _03497_ _03495_ _03679_ _03680_ VGND VGND VPWR VPWR _03681_ sky130_fd_sc_hd__a211oi_4
XTAP_TAPCELL_ROW_15_506 VGND VPWR sky130_fd_sc_hd__tapvpwrvgnd_1
XFILLER_25_360 VGND VGND VPWR VPWR sky130_fd_sc_hd__decap_3
XFILLER_25_393 VGND VGND VPWR VPWR sky130_fd_sc_hd__decap_3
X_10753_ net433 net442 net563 net562 VGND VGND VPWR VPWR _03605_ sky130_fd_sc_hd__and4_1
XFILLER_9_537 VGND VGND VPWR VPWR sky130_fd_sc_hd__decap_4
XFILLER_40_385 VGND VGND VPWR VPWR sky130_fd_sc_hd__decap_6
X_10684_ _03526_ _03527_ VGND VGND VPWR VPWR _03529_ sky130_fd_sc_hd__xnor2_1
X_12423_ _05259_ _05261_ VGND VGND VPWR VPWR _05425_ sky130_fd_sc_hd__or2_1
XTAP_TAPCELL_ROW_97_1655 VGND VPWR sky130_fd_sc_hd__tapvpwrvgnd_1
X_12354_ _05339_ _05346_ VGND VGND VPWR VPWR _05349_ sky130_fd_sc_hd__xor2_1
XFILLER_5_721 VGND VGND VPWR VPWR sky130_fd_sc_hd__decap_6
XFILLER_126_457 VPWR VGND VPWR VGND sky130_ef_sc_hd__decap_12
XFILLER_5_765 VPWR VGND VPWR VGND sky130_ef_sc_hd__decap_12
X_11305_ _03916_ _04117_ _04119_ VGND VGND VPWR VPWR _04208_ sky130_fd_sc_hd__a21o_2
XFILLER_4_253 VPWR VGND VPWR VGND sky130_ef_sc_hd__decap_12
X_12285_ _05257_ _05273_ VGND VGND VPWR VPWR _05274_ sky130_fd_sc_hd__nor2_1
X_11236_ _04126_ _04132_ VGND VGND VPWR VPWR _04133_ sky130_fd_sc_hd__xnor2_1
XFILLER_68_717 VGND VGND VPWR VPWR sky130_fd_sc_hd__fill_1
X_11167_ _04055_ _04056_ VGND VGND VPWR VPWR _04058_ sky130_fd_sc_hd__nor2_1
XFILLER_96_73 VGND VGND VPWR VPWR sky130_fd_sc_hd__decap_4
XFILLER_95_536 VGND VGND VPWR VPWR sky130_fd_sc_hd__decap_8
X_10118_ _02896_ _02911_ _02906_ VGND VGND VPWR VPWR _02912_ sky130_fd_sc_hd__o21ba_1
X_11098_ _03788_ _03789_ _03980_ VGND VGND VPWR VPWR _03983_ sky130_fd_sc_hd__o21ai_2
XTAP_TAPCELL_ROW_124_2029 VGND VPWR sky130_fd_sc_hd__tapvpwrvgnd_1
X_10049_ _02832_ _02836_ VGND VGND VPWR VPWR _02837_ sky130_fd_sc_hd__xnor2_1
XFILLER_90_230 VGND VGND VPWR VPWR sky130_fd_sc_hd__fill_2
XFILLER_75_293 VGND VGND VPWR VPWR sky130_fd_sc_hd__decap_4
XFILLER_63_444 VGND VGND VPWR VPWR sky130_fd_sc_hd__decap_4
XTAP_TAPCELL_ROW_106_1773 VGND VPWR sky130_fd_sc_hd__tapvpwrvgnd_1
XFILLER_91_797 VGND VGND VPWR VPWR sky130_fd_sc_hd__decap_8
XFILLER_63_488 VGND VGND VPWR VPWR sky130_fd_sc_hd__decap_3
XFILLER_51_617 VPWR VGND VPWR VGND sky130_ef_sc_hd__decap_12
XTAP_TAPCELL_ROW_106_1784 VGND VPWR sky130_fd_sc_hd__tapvpwrvgnd_1
XFILLER_43_190 VPWR VGND VPWR VGND sky130_ef_sc_hd__decap_12
X_07260_ _03270_ _03817_ _05527_ _06423_ _06426_ VGND VGND VPWR VPWR _06551_ sky130_fd_sc_hd__o41a_1
XFILLER_31_363 VGND VGND VPWR VPWR sky130_fd_sc_hd__decap_8
XTAP_TAPCELL_ROW_42_881 VGND VPWR sky130_fd_sc_hd__tapvpwrvgnd_1
X_07191_ net939 _06095_ _06481_ _06482_ VGND VGND VPWR VPWR _06483_ sky130_fd_sc_hd__o211ai_2
XFILLER_129_295 VGND VGND VPWR VPWR sky130_fd_sc_hd__fill_2
XFILLER_8_570 VGND VGND VPWR VPWR sky130_fd_sc_hd__fill_1
X_09901_ _02578_ _02679_ VGND VGND VPWR VPWR _02680_ sky130_fd_sc_hd__nor2_1
XFILLER_104_107 VGND VGND VPWR VPWR sky130_fd_sc_hd__decap_8
Xfanout505 net511 VGND VGND VPWR VPWR net505 sky130_fd_sc_hd__buf_2
X_09832_ _02589_ _02603_ VGND VGND VPWR VPWR _02605_ sky130_fd_sc_hd__nand2_1
XFILLER_113_685 VGND VGND VPWR VPWR sky130_fd_sc_hd__decap_6
XFILLER_113_663 VGND VGND VPWR VPWR sky130_fd_sc_hd__fill_1
Xfanout527 net528 VGND VGND VPWR VPWR net527 sky130_fd_sc_hd__clkbuf_4
Xfanout538 net160 VGND VGND VPWR VPWR net538 sky130_fd_sc_hd__clkbuf_2
Xfanout516 net519 VGND VGND VPWR VPWR net516 sky130_fd_sc_hd__buf_4
XFILLER_58_205 VGND VGND VPWR VPWR sky130_fd_sc_hd__fill_2
XFILLER_112_195 VGND VGND VPWR VPWR sky130_fd_sc_hd__fill_1
Xfanout549 net159 VGND VGND VPWR VPWR net549 sky130_fd_sc_hd__buf_1
X_09763_ _02308_ _02528_ VGND VGND VPWR VPWR _02529_ sky130_fd_sc_hd__nor2_1
XFILLER_132_27 VGND VGND VPWR VPWR sky130_fd_sc_hd__fill_1
X_06975_ _05221_ _05243_ VGND VGND VPWR VPWR _05254_ sky130_fd_sc_hd__nand2_1
X_08714_ _01364_ _01365_ _01439_ _01440_ VGND VGND VPWR VPWR _01442_ sky130_fd_sc_hd__o22a_1
XFILLER_74_709 VGND VGND VPWR VPWR sky130_fd_sc_hd__fill_1
Xrebuffer21 _00574_ VGND VGND VPWR VPWR net721 sky130_fd_sc_hd__dlymetal6s4s_1
X_09694_ net545 net255 VGND VGND VPWR VPWR _02454_ sky130_fd_sc_hd__nand2_1
XFILLER_66_271 VPWR VGND VPWR VGND sky130_ef_sc_hd__decap_12
Xrebuffer10 _03307_ VGND VGND VPWR VPWR net710 sky130_fd_sc_hd__dlymetal6s4s_1
XFILLER_27_603 VGND VGND VPWR VPWR sky130_fd_sc_hd__decap_3
X_08645_ _01211_ _01213_ _01212_ VGND VGND VPWR VPWR _01373_ sky130_fd_sc_hd__o21bai_1
XFILLER_82_753 VGND VGND VPWR VPWR sky130_fd_sc_hd__decap_3
Xrebuffer32 net885 VGND VGND VPWR VPWR net732 sky130_fd_sc_hd__dlygate4sd1_1
Xrebuffer43 net742 VGND VGND VPWR VPWR net743 sky130_fd_sc_hd__dlygate4sd1_1
XTAP_TAPCELL_ROW_68_1245 VGND VPWR sky130_fd_sc_hd__tapvpwrvgnd_1
Xrebuffer54 net753 VGND VGND VPWR VPWR net754 sky130_fd_sc_hd__dlygate4sd1_1
X_08576_ _01098_ _01132_ _01133_ _01136_ VGND VGND VPWR VPWR _01305_ sky130_fd_sc_hd__o2bb2ai_1
Xrebuffer87 net849 VGND VGND VPWR VPWR net787 sky130_fd_sc_hd__dlygate4sd1_1
Xrebuffer76 _04965_ VGND VGND VPWR VPWR net776 sky130_fd_sc_hd__buf_6
Xrebuffer65 net773 VGND VGND VPWR VPWR net765 sky130_fd_sc_hd__dlymetal6s2s_1
X_07527_ _00267_ VGND VGND VPWR VPWR _00268_ sky130_fd_sc_hd__inv_2
XTAP_TAPCELL_ROW_81_1434 VGND VPWR sky130_fd_sc_hd__tapvpwrvgnd_1
XTAP_TAPCELL_ROW_81_1423 VGND VPWR sky130_fd_sc_hd__tapvpwrvgnd_1
X_07458_ _00165_ _00198_ VGND VGND VPWR VPWR _00199_ sky130_fd_sc_hd__xor2_1
XFILLER_10_514 VGND VGND VPWR VPWR sky130_fd_sc_hd__fill_2
X_07389_ net320 net571 _06520_ _06519_ VGND VGND VPWR VPWR _00130_ sky130_fd_sc_hd__a31o_1
Xrebuffer100 _06479_ VGND VGND VPWR VPWR net800 sky130_fd_sc_hd__dlymetal6s2s_1
Xrebuffer122 net354 VGND VGND VPWR VPWR net822 sky130_fd_sc_hd__buf_4
X_09128_ _01838_ _01851_ _01852_ VGND VGND VPWR VPWR _01853_ sky130_fd_sc_hd__and3_1
Xrebuffer133 _05114_ VGND VGND VPWR VPWR net833 sky130_fd_sc_hd__buf_1
XTAP_TAPCELL_ROW_20_575 VGND VPWR sky130_fd_sc_hd__tapvpwrvgnd_1
XFILLER_136_755 VGND VGND VPWR VPWR sky130_fd_sc_hd__fill_1
Xrebuffer199 _03170_ VGND VGND VPWR VPWR net899 sky130_fd_sc_hd__buf_6
Xrebuffer166 _03161_ VGND VGND VPWR VPWR net866 sky130_fd_sc_hd__clkbuf_1
X_09059_ net544 _01782_ _01783_ net260 net572 VGND VGND VPWR VPWR _01784_ sky130_fd_sc_hd__a32o_1
XTAP_TAPCELL_ROW_79_1396 VGND VPWR sky130_fd_sc_hd__tapvpwrvgnd_1
XFILLER_2_713 VPWR VGND VPWR VGND sky130_ef_sc_hd__decap_12
XFILLER_104_630 VPWR VGND VPWR VGND sky130_ef_sc_hd__decap_12
XFILLER_89_330 VGND VGND VPWR VPWR sky130_fd_sc_hd__decap_6
X_12070_ _05029_ _05039_ VGND VGND VPWR VPWR _05040_ sky130_fd_sc_hd__xor2_1
XFILLER_1_223 VGND VGND VPWR VPWR sky130_fd_sc_hd__fill_1
XFILLER_2_757 VPWR VGND VPWR VGND sky130_ef_sc_hd__decap_12
XTAP_TAPCELL_ROW_92_1585 VGND VPWR sky130_fd_sc_hd__tapvpwrvgnd_1
X_11021_ _03887_ _03897_ VGND VGND VPWR VPWR _03898_ sky130_fd_sc_hd__xnor2_1
XFILLER_49_216 VGND VGND VPWR VPWR sky130_fd_sc_hd__fill_1
XFILLER_2_29 VPWR VGND VPWR VGND sky130_ef_sc_hd__decap_12
XFILLER_77_558 VGND VGND VPWR VPWR sky130_fd_sc_hd__fill_2
XFILLER_92_539 VGND VGND VPWR VPWR sky130_fd_sc_hd__fill_1
XFILLER_17_102 VGND VGND VPWR VPWR sky130_fd_sc_hd__decap_8
X_12972_ _05923_ _05929_ _05928_ VGND VGND VPWR VPWR _06025_ sky130_fd_sc_hd__a21oi_1
XFILLER_73_753 VPWR VGND VPWR VGND sky130_ef_sc_hd__decap_12
X_11923_ _04877_ _04878_ VGND VGND VPWR VPWR _04879_ sky130_fd_sc_hd__and2_1
XFILLER_45_444 VGND VGND VPWR VPWR sky130_fd_sc_hd__decap_4
XFILLER_17_113 VGND VGND VPWR VPWR sky130_fd_sc_hd__fill_1
XFILLER_82_20 VGND VGND VPWR VPWR sky130_fd_sc_hd__decap_8
X_11854_ _04794_ _04792_ _04793_ VGND VGND VPWR VPWR _04804_ sky130_fd_sc_hd__a21o_1
XFILLER_82_53 VGND VGND VPWR VPWR sky130_fd_sc_hd__decap_3
XTAP_TAPCELL_ROW_28_686 VGND VPWR sky130_fd_sc_hd__tapvpwrvgnd_1
X_10805_ _03623_ _03624_ _03659_ _03660_ VGND VGND VPWR VPWR _03662_ sky130_fd_sc_hd__o22a_1
XFILLER_82_97 VGND VGND VPWR VPWR sky130_fd_sc_hd__fill_2
X_11785_ _04594_ _04636_ _04670_ VGND VGND VPWR VPWR _04728_ sky130_fd_sc_hd__or3_1
XFILLER_9_301 VPWR VGND VPWR VGND sky130_ef_sc_hd__decap_12
X_10736_ _02251_ _03396_ VGND VGND VPWR VPWR _03586_ sky130_fd_sc_hd__or2_2
X_10667_ _03508_ _03509_ VGND VGND VPWR VPWR _03511_ sky130_fd_sc_hd__nor2_1
X_12406_ _05404_ _05405_ VGND VGND VPWR VPWR _05406_ sky130_fd_sc_hd__and2b_1
XFILLER_127_777 VGND VGND VPWR VPWR sky130_fd_sc_hd__decap_6
XFILLER_126_221 VGND VGND VPWR VPWR sky130_fd_sc_hd__decap_8
X_13386_ clknet_3_0__leaf_clk _00000_ _00096_ VGND VGND VPWR VPWR net194 sky130_fd_sc_hd__dfrtp_1
X_10598_ net425 net345 net56 net512 VGND VGND VPWR VPWR _03436_ sky130_fd_sc_hd__a22o_1
XFILLER_5_573 VPWR VGND VPWR VGND sky130_ef_sc_hd__decap_12
X_12337_ _05318_ _05320_ _05328_ VGND VGND VPWR VPWR _05331_ sky130_fd_sc_hd__o21ai_1
X_12268_ _05253_ _05255_ VGND VGND VPWR VPWR _05256_ sky130_fd_sc_hd__and2b_1
XFILLER_68_514 VGND VGND VPWR VPWR sky130_fd_sc_hd__decap_8
XTAP_TAPCELL_ROW_52_1024 VGND VPWR sky130_fd_sc_hd__tapvpwrvgnd_1
X_11219_ _04113_ _04114_ VGND VGND VPWR VPWR _04115_ sky130_fd_sc_hd__xnor2_1
XFILLER_122_471 VGND VGND VPWR VPWR sky130_fd_sc_hd__decap_4
XFILLER_95_311 VGND VGND VPWR VPWR sky130_fd_sc_hd__fill_2
X_12199_ _05136_ _05179_ VGND VGND VPWR VPWR _05180_ sky130_fd_sc_hd__nand2b_1
XTAP_TAPCELL_ROW_108_1813 VGND VPWR sky130_fd_sc_hd__tapvpwrvgnd_1
XTAP_TAPCELL_ROW_108_1802 VGND VPWR sky130_fd_sc_hd__tapvpwrvgnd_1
X_06760_ _02877_ _02888_ VGND VGND VPWR VPWR _02910_ sky130_fd_sc_hd__xor2_1
XFILLER_83_539 VPWR VGND VPWR VGND sky130_ef_sc_hd__decap_12
XFILLER_102_19 VGND VGND VPWR VPWR sky130_fd_sc_hd__decap_8
X_06691_ net137 VGND VGND VPWR VPWR _02164_ sky130_fd_sc_hd__inv_2
X_08430_ _01090_ _01115_ _01116_ _01119_ VGND VGND VPWR VPWR _01160_ sky130_fd_sc_hd__o22a_1
XFILLER_64_775 VGND VGND VPWR VPWR sky130_fd_sc_hd__decap_4
XFILLER_63_241 VGND VGND VPWR VPWR sky130_fd_sc_hd__fill_1
XTAP_TAPCELL_ROW_47_951 VGND VPWR sky130_fd_sc_hd__tapvpwrvgnd_1
XFILLER_36_477 VGND VGND VPWR VPWR sky130_fd_sc_hd__decap_3
XFILLER_63_296 VGND VGND VPWR VPWR sky130_fd_sc_hd__fill_1
XFILLER_51_436 VGND VGND VPWR VPWR sky130_fd_sc_hd__decap_4
XFILLER_17_680 VGND VGND VPWR VPWR sky130_fd_sc_hd__fill_2
X_08361_ _01089_ _01091_ _01092_ VGND VGND VPWR VPWR _01093_ sky130_fd_sc_hd__or3_1
X_08292_ _00927_ _00931_ _00926_ VGND VGND VPWR VPWR _01027_ sky130_fd_sc_hd__a21bo_1
X_07312_ _06600_ _06601_ _06592_ VGND VGND VPWR VPWR _06603_ sky130_fd_sc_hd__a21o_1
XTAP_TAPCELL_ROW_63_1175 VGND VPWR sky130_fd_sc_hd__tapvpwrvgnd_1
XFILLER_32_683 VGND VGND VPWR VPWR sky130_fd_sc_hd__fill_1
X_07243_ _06532_ _06533_ VGND VGND VPWR VPWR _06534_ sky130_fd_sc_hd__or2_1
XFILLER_31_193 VGND VGND VPWR VPWR sky130_fd_sc_hd__decap_3
XTAP_TAPCELL_ROW_119_1964 VGND VPWR sky130_fd_sc_hd__tapvpwrvgnd_1
X_07174_ net388 net920 net310 net390 VGND VGND VPWR VPWR _06466_ sky130_fd_sc_hd__a22oi_2
XFILLER_11_27 VPWR VGND VPWR VGND sky130_ef_sc_hd__decap_12
XFILLER_127_27 VPWR VGND VPWR VGND sky130_ef_sc_hd__decap_12
XFILLER_132_246 VGND VGND VPWR VPWR sky130_fd_sc_hd__decap_6
XFILLER_105_449 VGND VGND VPWR VPWR sky130_fd_sc_hd__decap_8
XFILLER_120_419 VGND VGND VPWR VPWR sky130_fd_sc_hd__fill_1
XFILLER_99_661 VGND VGND VPWR VPWR sky130_fd_sc_hd__decap_3
Xfanout313 net314 VGND VGND VPWR VPWR net313 sky130_fd_sc_hd__buf_6
XFILLER_59_503 VGND VGND VPWR VPWR sky130_fd_sc_hd__fill_1
Xfanout302 net74 VGND VGND VPWR VPWR net302 sky130_fd_sc_hd__clkbuf_2
X_09815_ _02584_ _02583_ VGND VGND VPWR VPWR _02586_ sky130_fd_sc_hd__and2b_1
XFILLER_113_482 VGND VGND VPWR VPWR sky130_fd_sc_hd__fill_1
XFILLER_99_694 VGND VGND VPWR VPWR sky130_fd_sc_hd__fill_1
XFILLER_100_110 VGND VGND VPWR VPWR sky130_fd_sc_hd__fill_2
Xfanout324 net65 VGND VGND VPWR VPWR net324 sky130_fd_sc_hd__buf_2
Xfanout357 net358 VGND VGND VPWR VPWR net357 sky130_fd_sc_hd__buf_8
Xfanout335 net336 VGND VGND VPWR VPWR net335 sky130_fd_sc_hd__buf_6
Xfanout346 net54 VGND VGND VPWR VPWR net346 sky130_fd_sc_hd__buf_2
XFILLER_86_355 VGND VGND VPWR VPWR sky130_fd_sc_hd__decap_8
XFILLER_86_344 VGND VGND VPWR VPWR sky130_fd_sc_hd__fill_1
Xfanout368 net369 VGND VGND VPWR VPWR net368 sky130_fd_sc_hd__buf_4
Xfanout379 net380 VGND VGND VPWR VPWR net379 sky130_fd_sc_hd__buf_12
X_06958_ _05047_ _05058_ VGND VGND VPWR VPWR _00045_ sky130_fd_sc_hd__and2_1
XFILLER_86_388 VGND VGND VPWR VPWR sky130_fd_sc_hd__decap_8
X_09746_ _02508_ _02509_ VGND VGND VPWR VPWR _02510_ sky130_fd_sc_hd__nand2_1
X_09677_ _02428_ _02433_ VGND VGND VPWR VPWR _02436_ sky130_fd_sc_hd__xor2_1
X_08628_ _01353_ _01354_ VGND VGND VPWR VPWR _01356_ sky130_fd_sc_hd__or2_1
X_06889_ _04232_ _04243_ _04297_ VGND VGND VPWR VPWR _04319_ sky130_fd_sc_hd__a21o_1
XFILLER_70_701 VGND VGND VPWR VPWR sky130_fd_sc_hd__decap_3
XFILLER_15_617 VPWR VGND VPWR VGND sky130_ef_sc_hd__decap_12
XFILLER_82_594 VPWR VGND VPWR VGND sky130_ef_sc_hd__decap_12
X_08559_ _01287_ VGND VGND VPWR VPWR _01288_ sky130_fd_sc_hd__inv_2
XTAP_TAPCELL_ROW_25_645 VGND VPWR sky130_fd_sc_hd__tapvpwrvgnd_1
X_11570_ _04354_ _04356_ _04496_ VGND VGND VPWR VPWR _04498_ sky130_fd_sc_hd__or3b_1
XFILLER_10_300 VGND VGND VPWR VPWR sky130_fd_sc_hd__decap_8
XFILLER_50_491 VGND VGND VPWR VPWR sky130_fd_sc_hd__decap_6
X_10521_ net539 net283 _03350_ VGND VGND VPWR VPWR _03351_ sky130_fd_sc_hd__and3_1
XFILLER_10_377 VPWR VGND VPWR VGND sky130_ef_sc_hd__decap_12
X_13240_ _06088_ _06217_ VGND VGND VPWR VPWR _06317_ sky130_fd_sc_hd__nand2_1
XFILLER_109_766 VPWR VGND VPWR VGND sky130_ef_sc_hd__decap_12
XTAP_TAPCELL_ROW_94_1614 VGND VPWR sky130_fd_sc_hd__tapvpwrvgnd_1
X_10452_ _03274_ _03275_ VGND VGND VPWR VPWR _03276_ sky130_fd_sc_hd__nor2_1
XFILLER_136_574 VGND VGND VPWR VPWR sky130_fd_sc_hd__decap_8
XFILLER_124_725 VPWR VGND VPWR VGND sky130_ef_sc_hd__decap_12
XFILLER_123_202 VGND VGND VPWR VPWR sky130_fd_sc_hd__decap_8
X_10383_ _03065_ _03199_ VGND VGND VPWR VPWR _03201_ sky130_fd_sc_hd__and2_1
X_13171_ _06113_ _06125_ _06111_ VGND VGND VPWR VPWR _06242_ sky130_fd_sc_hd__a21o_1
XFILLER_124_769 VPWR VGND VPWR VGND sky130_ef_sc_hd__decap_12
X_12122_ _05093_ _05094_ _05095_ VGND VGND VPWR VPWR _05096_ sky130_fd_sc_hd__nand3_1
X_12053_ _05001_ _05020_ VGND VGND VPWR VPWR _05021_ sky130_fd_sc_hd__xor2_1
XFILLER_89_160 VGND VGND VPWR VPWR sky130_fd_sc_hd__fill_1
XFILLER_2_587 VGND VGND VPWR VPWR sky130_fd_sc_hd__fill_1
X_11004_ net615 net272 _02230_ net638 VGND VGND VPWR VPWR _03879_ sky130_fd_sc_hd__o2bb2a_1
XFILLER_77_355 VGND VGND VPWR VPWR sky130_fd_sc_hd__decap_4
XTAP_TAPCELL_ROW_5_370 VGND VPWR sky130_fd_sc_hd__tapvpwrvgnd_1
XFILLER_133_81 VPWR VGND VPWR VGND sky130_ef_sc_hd__decap_12
X_12955_ _05922_ _05934_ _05933_ VGND VGND VPWR VPWR _06006_ sky130_fd_sc_hd__a21o_1
XFILLER_93_74 VPWR VGND VPWR VGND sky130_ef_sc_hd__decap_12
XFILLER_73_561 VGND VGND VPWR VPWR sky130_fd_sc_hd__decap_4
XFILLER_61_701 VGND VGND VPWR VPWR sky130_fd_sc_hd__decap_3
X_11906_ net269 net293 VGND VGND VPWR VPWR _04860_ sky130_fd_sc_hd__nand2_1
XFILLER_46_775 VGND VGND VPWR VPWR sky130_fd_sc_hd__decap_4
XFILLER_46_764 VGND VGND VPWR VPWR sky130_fd_sc_hd__decap_6
XFILLER_61_745 VGND VGND VPWR VPWR sky130_fd_sc_hd__fill_1
XTAP_TAPCELL_ROW_44_910 VGND VPWR sky130_fd_sc_hd__tapvpwrvgnd_1
X_12886_ _05727_ _05733_ _05732_ VGND VGND VPWR VPWR _05931_ sky130_fd_sc_hd__a21oi_1
XTAP_TAPCELL_ROW_103_1743 VGND VPWR sky130_fd_sc_hd__tapvpwrvgnd_1
XTAP_TAPCELL_ROW_103_1732 VGND VPWR sky130_fd_sc_hd__tapvpwrvgnd_1
X_11837_ _04760_ _04783_ _04782_ VGND VGND VPWR VPWR _04786_ sky130_fd_sc_hd__o21bai_1
XFILLER_33_447 VGND VGND VPWR VPWR sky130_fd_sc_hd__fill_1
X_11768_ _04655_ _04699_ VGND VGND VPWR VPWR _04710_ sky130_fd_sc_hd__nor2_1
X_10719_ net520 net503 net648 net637 VGND VGND VPWR VPWR _03568_ sky130_fd_sc_hd__and4_1
X_11699_ _02044_ _02262_ VGND VGND VPWR VPWR _04635_ sky130_fd_sc_hd__nor2_1
Xrebuffer1 _01300_ VGND VGND VPWR VPWR net701 sky130_fd_sc_hd__clkbuf_2
X_13369_ clknet_3_2__leaf_clk _00044_ _00079_ VGND VGND VPWR VPWR net168 sky130_fd_sc_hd__dfrtp_1
XTAP_TAPCELL_ROW_132_2139 VGND VPWR sky130_fd_sc_hd__tapvpwrvgnd_1
XFILLER_114_202 VPWR VGND VPWR VGND sky130_ef_sc_hd__decap_12
XFILLER_54_3 VGND VGND VPWR VPWR sky130_fd_sc_hd__fill_2
X_07930_ net681 _00333_ VGND VGND VPWR VPWR _00668_ sky130_fd_sc_hd__and2_1
XFILLER_87_108 VGND VGND VPWR VPWR sky130_fd_sc_hd__fill_1
XTAP_TAPCELL_ROW_114_1894 VGND VPWR sky130_fd_sc_hd__tapvpwrvgnd_1
XFILLER_68_300 VGND VGND VPWR VPWR sky130_fd_sc_hd__decap_8
X_07861_ _00482_ _00491_ _00490_ VGND VGND VPWR VPWR _00599_ sky130_fd_sc_hd__a21oi_1
XFILLER_96_642 VGND VGND VPWR VPWR sky130_fd_sc_hd__fill_2
XFILLER_68_333 VPWR VGND VPWR VGND sky130_ef_sc_hd__decap_12
XFILLER_29_709 VGND VGND VPWR VPWR sky130_fd_sc_hd__fill_1
X_06812_ _03445_ _03467_ VGND VGND VPWR VPWR _03478_ sky130_fd_sc_hd__and2b_1
XFILLER_110_463 VPWR VGND VPWR VGND sky130_ef_sc_hd__decap_12
XFILLER_96_697 VGND VGND VPWR VPWR sky130_fd_sc_hd__decap_3
X_09600_ _02322_ _02352_ VGND VGND VPWR VPWR _02353_ sky130_fd_sc_hd__xnor2_1
XFILLER_83_303 VGND VGND VPWR VPWR sky130_fd_sc_hd__decap_3
X_07792_ _00394_ _00404_ _00393_ VGND VGND VPWR VPWR _00531_ sky130_fd_sc_hd__a21bo_1
X_09531_ _02239_ _02277_ VGND VGND VPWR VPWR _02278_ sky130_fd_sc_hd__and2b_1
X_06743_ net696 net387 VGND VGND VPWR VPWR _02729_ sky130_fd_sc_hd__nand2_1
XTAP_TAPCELL_ROW_65_1204 VGND VPWR sky130_fd_sc_hd__tapvpwrvgnd_1
XFILLER_64_550 VGND VGND VPWR VPWR sky130_fd_sc_hd__decap_3
XFILLER_52_701 VPWR VGND VPWR VGND sky130_ef_sc_hd__decap_12
XFILLER_37_775 VGND VGND VPWR VPWR sky130_fd_sc_hd__fill_2
X_09462_ _02199_ _02201_ VGND VGND VPWR VPWR _02203_ sky130_fd_sc_hd__or2_1
XFILLER_64_583 VGND VGND VPWR VPWR sky130_fd_sc_hd__decap_4
XFILLER_51_211 VPWR VGND VPWR VGND sky130_ef_sc_hd__decap_12
XFILLER_24_414 VGND VGND VPWR VPWR sky130_fd_sc_hd__decap_6
XFILLER_37_797 VGND VGND VPWR VPWR sky130_fd_sc_hd__decap_8
X_09393_ _02086_ _02125_ VGND VGND VPWR VPWR _02127_ sky130_fd_sc_hd__xnor2_1
X_08413_ _01108_ _01141_ _01142_ _01106_ VGND VGND VPWR VPWR _01143_ sky130_fd_sc_hd__o22a_1
XFILLER_51_233 VPWR VGND VPWR VGND sky130_ef_sc_hd__decap_12
X_08344_ _01071_ _01077_ VGND VGND VPWR VPWR _01078_ sky130_fd_sc_hd__xnor2_1
XTAP_TAPCELL_ROW_22_604 VGND VPWR sky130_fd_sc_hd__tapvpwrvgnd_1
XFILLER_20_620 VGND VGND VPWR VPWR sky130_fd_sc_hd__fill_1
X_08275_ _00910_ _00912_ _01008_ VGND VGND VPWR VPWR _01010_ sky130_fd_sc_hd__nor3_1
X_07226_ net322 net543 VGND VGND VPWR VPWR _06517_ sky130_fd_sc_hd__nand2_1
XFILLER_118_552 VGND VGND VPWR VPWR sky130_fd_sc_hd__fill_1
X_07157_ _05801_ _06447_ _06448_ VGND VGND VPWR VPWR _06449_ sky130_fd_sc_hd__and3_1
XFILLER_105_235 VGND VGND VPWR VPWR sky130_fd_sc_hd__decap_6
XTAP_TAPCELL_ROW_76_1355 VGND VPWR sky130_fd_sc_hd__tapvpwrvgnd_1
XFILLER_3_329 VGND VGND VPWR VPWR sky130_fd_sc_hd__decap_6
X_07088_ _05144_ _06378_ VGND VGND VPWR VPWR _06380_ sky130_fd_sc_hd__and2_1
XFILLER_105_279 VGND VGND VPWR VPWR sky130_fd_sc_hd__fill_1
XFILLER_59_300 VPWR VGND VPWR VGND sky130_ef_sc_hd__decap_12
XFILLER_87_642 VGND VGND VPWR VPWR sky130_fd_sc_hd__decap_8
XFILLER_86_141 VGND VGND VPWR VPWR sky130_fd_sc_hd__fill_1
XFILLER_101_474 VGND VGND VPWR VPWR sky130_fd_sc_hd__decap_8
XFILLER_47_34 VGND VGND VPWR VPWR sky130_fd_sc_hd__fill_1
X_09729_ _02489_ _02491_ VGND VGND VPWR VPWR _02493_ sky130_fd_sc_hd__xor2_1
XFILLER_28_742 VPWR VGND VPWR VGND sky130_ef_sc_hd__decap_12
XFILLER_103_51 VGND VGND VPWR VPWR sky130_fd_sc_hd__decap_4
XFILLER_27_230 VPWR VGND VPWR VGND sky130_ef_sc_hd__decap_12
X_12740_ _05588_ _05597_ _05596_ VGND VGND VPWR VPWR _05772_ sky130_fd_sc_hd__o21ai_1
XFILLER_70_531 VGND VGND VPWR VPWR sky130_fd_sc_hd__fill_1
XFILLER_63_55 VGND VGND VPWR VPWR sky130_fd_sc_hd__fill_1
X_12671_ _05687_ _05694_ VGND VGND VPWR VPWR _05696_ sky130_fd_sc_hd__xor2_1
XFILLER_42_233 VGND VGND VPWR VPWR sky130_fd_sc_hd__decap_3
XFILLER_70_597 VGND VGND VPWR VPWR sky130_fd_sc_hd__fill_1
X_11622_ _04544_ _04553_ VGND VGND VPWR VPWR _04554_ sky130_fd_sc_hd__xnor2_1
XFILLER_11_631 VPWR VGND VPWR VGND sky130_ef_sc_hd__decap_12
XFILLER_11_664 VGND VGND VPWR VPWR sky130_fd_sc_hd__decap_8
XFILLER_10_141 VGND VGND VPWR VPWR sky130_fd_sc_hd__fill_1
X_11553_ _04477_ _04478_ VGND VGND VPWR VPWR _04479_ sky130_fd_sc_hd__nor2_1
XFILLER_128_349 VPWR VGND VPWR VGND sky130_ef_sc_hd__decap_12
X_10504_ _03186_ _03222_ _03224_ VGND VGND VPWR VPWR _03332_ sky130_fd_sc_hd__a21oi_1
X_11484_ _04402_ _04403_ VGND VGND VPWR VPWR _04404_ sky130_fd_sc_hd__nor2_1
XFILLER_124_500 VGND VGND VPWR VPWR sky130_fd_sc_hd__fill_2
X_10435_ net458 net450 net564 net561 VGND VGND VPWR VPWR _03257_ sky130_fd_sc_hd__and4_1
X_13223_ _06271_ _06297_ VGND VGND VPWR VPWR _06299_ sky130_fd_sc_hd__xnor2_1
XFILLER_136_393 VGND VGND VPWR VPWR sky130_fd_sc_hd__fill_2
XFILLER_124_533 VGND VGND VPWR VPWR sky130_fd_sc_hd__decap_8
X_13154_ _05225_ _06221_ VGND VGND VPWR VPWR _06223_ sky130_fd_sc_hd__nor2_1
XFILLER_6_189 VGND VGND VPWR VPWR sky130_fd_sc_hd__decap_6
X_10366_ _03181_ _03182_ VGND VGND VPWR VPWR _00020_ sky130_fd_sc_hd__and2b_1
X_12105_ _04933_ _04935_ _04934_ VGND VGND VPWR VPWR _05077_ sky130_fd_sc_hd__o21ba_1
XFILLER_105_780 VGND VGND VPWR VPWR sky130_fd_sc_hd__decap_4
XFILLER_88_85 VGND VGND VPWR VPWR sky130_fd_sc_hd__decap_6
XFILLER_69_119 VGND VGND VPWR VPWR sky130_fd_sc_hd__fill_1
X_10297_ _03099_ _03106_ VGND VGND VPWR VPWR _03108_ sky130_fd_sc_hd__xnor2_1
X_13085_ _06140_ _06146_ VGND VGND VPWR VPWR _06148_ sky130_fd_sc_hd__or2_1
XFILLER_78_631 VGND VGND VPWR VPWR sky130_fd_sc_hd__fill_2
X_12036_ net534 net661 _04897_ _04896_ VGND VGND VPWR VPWR _05002_ sky130_fd_sc_hd__a31o_1
XFILLER_93_689 VPWR VGND VPWR VGND sky130_ef_sc_hd__decap_12
X_12938_ _05984_ _05985_ VGND VGND VPWR VPWR _05988_ sky130_fd_sc_hd__xnor2_1
XFILLER_19_797 VGND VGND VPWR VPWR sky130_fd_sc_hd__decap_8
X_12869_ _05911_ _05912_ VGND VGND VPWR VPWR _05913_ sky130_fd_sc_hd__and2b_1
XFILLER_33_288 VPWR VGND VPWR VGND sky130_ef_sc_hd__decap_12
XFILLER_34_789 VPWR VGND VPWR VGND sky130_ef_sc_hd__decap_12
XTAP_TAPCELL_ROW_60_1134 VGND VPWR sky130_fd_sc_hd__tapvpwrvgnd_1
XFILLER_135_809 VGND VGND VPWR VPWR sky130_fd_sc_hd__fill_2
X_08060_ _00795_ _00796_ VGND VGND VPWR VPWR _00797_ sky130_fd_sc_hd__nand2_1
XTAP_TAPCELL_ROW_116_1923 VGND VPWR sky130_fd_sc_hd__tapvpwrvgnd_1
XTAP_TAPCELL_ROW_116_1912 VGND VPWR sky130_fd_sc_hd__tapvpwrvgnd_1
X_07011_ net469 net460 net606 net603 VGND VGND VPWR VPWR _05648_ sky130_fd_sc_hd__and4_1
XFILLER_108_29 VPWR VGND VPWR VGND sky130_ef_sc_hd__decap_12
XFILLER_130_525 VGND VGND VPWR VPWR sky130_fd_sc_hd__decap_6
X_08962_ _01525_ _01528_ _01527_ VGND VGND VPWR VPWR _01688_ sky130_fd_sc_hd__o21bai_1
XFILLER_130_569 VPWR VGND VPWR VGND sky130_ef_sc_hd__decap_12
X_08893_ net622 net260 _01472_ _01471_ VGND VGND VPWR VPWR _01619_ sky130_fd_sc_hd__a31oi_1
X_07913_ _00642_ _00650_ VGND VGND VPWR VPWR _00651_ sky130_fd_sc_hd__nand2b_1
X_07844_ _00440_ _00581_ VGND VGND VPWR VPWR _00582_ sky130_fd_sc_hd__nor2_1
XFILLER_111_783 VGND VGND VPWR VPWR sky130_fd_sc_hd__fill_1
XFILLER_84_623 VGND VGND VPWR VPWR sky130_fd_sc_hd__decap_3
XFILLER_84_601 VGND VGND VPWR VPWR sky130_fd_sc_hd__decap_4
XTAP_TAPCELL_ROW_71_1285 VGND VPWR sky130_fd_sc_hd__tapvpwrvgnd_1
XFILLER_68_141 VPWR VGND VPWR VGND sky130_ef_sc_hd__decap_12
XFILLER_29_517 VGND VGND VPWR VPWR sky130_fd_sc_hd__decap_8
XFILLER_84_645 VGND VGND VPWR VPWR sky130_fd_sc_hd__decap_6
XFILLER_83_111 VGND VGND VPWR VPWR sky130_fd_sc_hd__fill_1
XFILLER_68_174 VGND VGND VPWR VPWR sky130_fd_sc_hd__decap_8
XFILLER_56_347 VGND VGND VPWR VPWR sky130_fd_sc_hd__fill_2
XFILLER_83_166 VGND VGND VPWR VPWR sky130_fd_sc_hd__fill_2
X_07775_ _00511_ _00512_ _00508_ VGND VGND VPWR VPWR _00514_ sky130_fd_sc_hd__o21ai_1
XFILLER_44_509 VGND VGND VPWR VPWR sky130_fd_sc_hd__fill_2
XFILLER_37_561 VPWR VGND VPWR VGND sky130_ef_sc_hd__decap_12
X_09514_ _02256_ _02257_ VGND VGND VPWR VPWR _02259_ sky130_fd_sc_hd__xnor2_1
X_06726_ net532 net251 VGND VGND VPWR VPWR _02544_ sky130_fd_sc_hd__nand2_1
X_09445_ _02177_ _02182_ VGND VGND VPWR VPWR _02184_ sky130_fd_sc_hd__xor2_2
XFILLER_24_244 VGND VGND VPWR VPWR sky130_fd_sc_hd__fill_1
XFILLER_25_767 VGND VGND VPWR VPWR sky130_fd_sc_hd__fill_1
XTAP_TAPCELL_ROW_35_784 VGND VPWR sky130_fd_sc_hd__tapvpwrvgnd_1
X_09376_ _01972_ _01981_ _01980_ VGND VGND VPWR VPWR _02108_ sky130_fd_sc_hd__a21o_1
X_08327_ _00849_ _00850_ _00546_ VGND VGND VPWR VPWR _01061_ sky130_fd_sc_hd__mux2_1
X_08258_ _00991_ _00992_ VGND VGND VPWR VPWR _00993_ sky130_fd_sc_hd__or2_1
X_07209_ _06281_ _05047_ _06292_ _06259_ _04992_ VGND VGND VPWR VPWR _06501_ sky130_fd_sc_hd__o32ai_4
XFILLER_118_393 VPWR VGND VPWR VGND sky130_ef_sc_hd__decap_12
X_08189_ _00777_ _00811_ _00776_ VGND VGND VPWR VPWR _00925_ sky130_fd_sc_hd__o21ba_1
XFILLER_106_533 VPWR VGND VPWR VGND sky130_ef_sc_hd__decap_12
XFILLER_106_522 VGND VGND VPWR VPWR sky130_fd_sc_hd__fill_1
X_10220_ _02793_ _02831_ _02832_ _02836_ VGND VGND VPWR VPWR _03024_ sky130_fd_sc_hd__o2bb2ai_1
XFILLER_3_137 VPWR VGND VPWR VGND sky130_ef_sc_hd__decap_12
XFILLER_133_385 VGND VGND VPWR VPWR sky130_fd_sc_hd__decap_4
XFILLER_79_428 VPWR VGND VPWR VGND sky130_ef_sc_hd__decap_12
X_10151_ _02946_ _02947_ VGND VGND VPWR VPWR _02948_ sky130_fd_sc_hd__and2b_1
X_10082_ net533 net526 net652 net650 VGND VGND VPWR VPWR _02872_ sky130_fd_sc_hd__and4_1
XTAP_TAPCELL_ROW_89_1546 VGND VPWR sky130_fd_sc_hd__tapvpwrvgnd_1
XTAP_TAPCELL_ROW_89_1535 VGND VPWR sky130_fd_sc_hd__tapvpwrvgnd_1
XFILLER_114_83 VGND VGND VPWR VPWR sky130_fd_sc_hd__fill_1
XFILLER_90_615 VGND VGND VPWR VPWR sky130_fd_sc_hd__decap_8
XFILLER_75_689 VGND VGND VPWR VPWR sky130_fd_sc_hd__fill_1
XFILLER_62_306 VGND VGND VPWR VPWR sky130_fd_sc_hd__fill_2
XFILLER_16_701 VGND VGND VPWR VPWR sky130_fd_sc_hd__fill_1
X_10984_ _03855_ _03856_ VGND VGND VPWR VPWR _03858_ sky130_fd_sc_hd__or2_1
XFILLER_43_553 VGND VGND VPWR VPWR sky130_fd_sc_hd__decap_6
XFILLER_16_745 VGND VGND VPWR VPWR sky130_fd_sc_hd__decap_8
X_12723_ _05607_ _05614_ _05612_ VGND VGND VPWR VPWR _05753_ sky130_fd_sc_hd__a21o_1
XFILLER_70_361 VGND VGND VPWR VPWR sky130_fd_sc_hd__decap_3
XFILLER_15_255 VGND VGND VPWR VPWR sky130_fd_sc_hd__fill_1
XFILLER_31_715 VPWR VGND VPWR VGND sky130_ef_sc_hd__decap_12
X_12654_ net617 _02077_ net284 net81 VGND VGND VPWR VPWR _05677_ sky130_fd_sc_hd__and4_1
XFILLER_90_97 VGND VGND VPWR VPWR sky130_fd_sc_hd__decap_8
X_11605_ _04532_ _04534_ VGND VGND VPWR VPWR _04535_ sky130_fd_sc_hd__xnor2_1
X_12585_ net334 net312 net366 net364 VGND VGND VPWR VPWR _05602_ sky130_fd_sc_hd__and4_1
XFILLER_30_247 VGND VGND VPWR VPWR sky130_fd_sc_hd__decap_4
XFILLER_117_809 VGND VGND VPWR VPWR sky130_fd_sc_hd__fill_2
X_11536_ _04446_ _04459_ VGND VGND VPWR VPWR _04460_ sky130_fd_sc_hd__xnor2_1
XFILLER_7_421 VGND VGND VPWR VPWR sky130_fd_sc_hd__fill_1
XTAP_TAPCELL_ROW_13_478 VGND VPWR sky130_fd_sc_hd__tapvpwrvgnd_1
XFILLER_116_319 VGND VGND VPWR VPWR sky130_fd_sc_hd__decap_8
XFILLER_7_443 VGND VGND VPWR VPWR sky130_fd_sc_hd__decap_4
XFILLER_109_393 VPWR VGND VPWR VGND sky130_ef_sc_hd__decap_12
XFILLER_109_371 VGND VGND VPWR VPWR sky130_fd_sc_hd__fill_1
XFILLER_7_487 VGND VGND VPWR VPWR sky130_fd_sc_hd__fill_1
X_13206_ _06167_ _06279_ VGND VGND VPWR VPWR _06280_ sky130_fd_sc_hd__xnor2_1
X_11467_ _04384_ _04377_ VGND VGND VPWR VPWR _04386_ sky130_fd_sc_hd__and2b_1
X_10418_ _03236_ _03238_ VGND VGND VPWR VPWR _03239_ sky130_fd_sc_hd__xnor2_1
X_11398_ _04301_ _04307_ VGND VGND VPWR VPWR _04310_ sky130_fd_sc_hd__xnor2_1
XFILLER_124_363 VGND VGND VPWR VPWR sky130_fd_sc_hd__fill_1
X_10349_ _03112_ net866 _03163_ VGND VGND VPWR VPWR _03165_ sky130_fd_sc_hd__or3_4
XFILLER_3_671 VGND VGND VPWR VPWR sky130_fd_sc_hd__fill_1
X_13137_ _05834_ _06054_ _06051_ VGND VGND VPWR VPWR _06206_ sky130_fd_sc_hd__o21a_1
XTAP_TAPCELL_ROW_111_1853 VGND VPWR sky130_fd_sc_hd__tapvpwrvgnd_1
XTAP_TAPCELL_ROW_111_1842 VGND VPWR sky130_fd_sc_hd__tapvpwrvgnd_1
XFILLER_100_709 VGND VGND VPWR VPWR sky130_fd_sc_hd__fill_1
X_13068_ _06126_ _06127_ VGND VGND VPWR VPWR _06130_ sky130_fd_sc_hd__xor2_1
XFILLER_66_601 VGND VGND VPWR VPWR sky130_fd_sc_hd__fill_2
X_12019_ _04863_ _04864_ _04879_ _04876_ _04698_ VGND VGND VPWR VPWR _04984_ sky130_fd_sc_hd__a32o_1
XFILLER_93_431 VGND VGND VPWR VPWR sky130_fd_sc_hd__decap_3
XFILLER_66_645 VGND VGND VPWR VPWR sky130_fd_sc_hd__decap_8
XFILLER_65_111 VGND VGND VPWR VPWR sky130_fd_sc_hd__fill_1
XFILLER_65_100 VGND VGND VPWR VPWR sky130_fd_sc_hd__decap_4
XFILLER_17_3 VGND VGND VPWR VPWR sky130_fd_sc_hd__decap_4
XFILLER_38_314 VGND VGND VPWR VPWR sky130_fd_sc_hd__decap_4
X_07560_ _00131_ _00133_ _00299_ VGND VGND VPWR VPWR _00300_ sky130_fd_sc_hd__a21oi_1
XFILLER_65_199 VGND VGND VPWR VPWR sky130_fd_sc_hd__fill_1
XFILLER_65_177 VGND VGND VPWR VPWR sky130_fd_sc_hd__fill_1
XFILLER_34_553 VGND VGND VPWR VPWR sky130_fd_sc_hd__fill_2
X_09230_ _01944_ _01953_ VGND VGND VPWR VPWR _01954_ sky130_fd_sc_hd__nor2_1
X_07491_ net707 _00230_ net387 net310 VGND VGND VPWR VPWR _00232_ sky130_fd_sc_hd__a2bb2o_1
XFILLER_22_726 VGND VGND VPWR VPWR sky130_fd_sc_hd__decap_8
X_09161_ _01865_ _01882_ _01884_ VGND VGND VPWR VPWR _01886_ sky130_fd_sc_hd__nand3_1
XTAP_TAPCELL_ROW_32_743 VGND VPWR sky130_fd_sc_hd__tapvpwrvgnd_1
XFILLER_119_113 VPWR VGND VPWR VGND sky130_ef_sc_hd__decap_12
X_09092_ _01814_ _01815_ VGND VGND VPWR VPWR _01817_ sky130_fd_sc_hd__xor2_1
X_08112_ net602 net402 _00735_ VGND VGND VPWR VPWR _00848_ sky130_fd_sc_hd__a21oi_1
XFILLER_135_617 VPWR VGND VPWR VGND sky130_ef_sc_hd__decap_12
X_08043_ _02098_ net570 net303 net73 VGND VGND VPWR VPWR _00780_ sky130_fd_sc_hd__and4_1
XFILLER_119_39 VPWR VGND VPWR VGND sky130_ef_sc_hd__decap_12
XFILLER_127_190 VGND VGND VPWR VPWR sky130_fd_sc_hd__decap_3
XTAP_TAPCELL_ROW_73_1314 VGND VPWR sky130_fd_sc_hd__tapvpwrvgnd_1
XFILLER_135_27 VPWR VGND VPWR VGND sky130_ef_sc_hd__decap_12
X_09994_ _01164_ _01336_ VGND VGND VPWR VPWR _00051_ sky130_fd_sc_hd__xnor2_1
XFILLER_89_759 VPWR VGND VPWR VGND sky130_ef_sc_hd__decap_12
XFILLER_88_236 VGND VGND VPWR VPWR sky130_fd_sc_hd__decap_8
XFILLER_97_781 VGND VGND VPWR VPWR sky130_fd_sc_hd__decap_3
X_08945_ _01640_ _01669_ _01670_ VGND VGND VPWR VPWR _01671_ sky130_fd_sc_hd__and3_1
X_08876_ net597 net260 net259 net622 VGND VGND VPWR VPWR _01602_ sky130_fd_sc_hd__a22o_1
X_07827_ _00564_ _00565_ VGND VGND VPWR VPWR _00566_ sky130_fd_sc_hd__nor2_1
XFILLER_29_347 VPWR VGND VPWR VGND sky130_ef_sc_hd__decap_12
X_07758_ _00187_ _00496_ VGND VGND VPWR VPWR _00497_ sky130_fd_sc_hd__xnor2_1
XFILLER_84_475 VGND VGND VPWR VPWR sky130_fd_sc_hd__fill_1
XFILLER_56_177 VGND VGND VPWR VPWR sky130_fd_sc_hd__fill_1
X_06709_ net252 net532 _02327_ _02338_ VGND VGND VPWR VPWR _02360_ sky130_fd_sc_hd__o2bb2a_1
X_07689_ _00272_ _00274_ _00426_ _00427_ VGND VGND VPWR VPWR _00429_ sky130_fd_sc_hd__o211a_1
XTAP_TAPCELL_ROW_84_1476 VGND VPWR sky130_fd_sc_hd__tapvpwrvgnd_1
XTAP_TAPCELL_ROW_84_1465 VGND VPWR sky130_fd_sc_hd__tapvpwrvgnd_1
XFILLER_71_169 VGND VGND VPWR VPWR sky130_fd_sc_hd__fill_1
XFILLER_40_501 VPWR VGND VPWR VGND sky130_ef_sc_hd__decap_12
X_09428_ net291 net329 net327 net313 VGND VGND VPWR VPWR _02166_ sky130_fd_sc_hd__a22oi_1
XFILLER_9_708 VPWR VGND VPWR VGND sky130_ef_sc_hd__decap_12
X_09359_ net544 net258 net256 VGND VGND VPWR VPWR _02090_ sky130_fd_sc_hd__and3_1
XFILLER_100_85 VPWR VGND VPWR VGND sky130_ef_sc_hd__decap_12
X_12370_ net524 net507 net661 net659 VGND VGND VPWR VPWR _05367_ sky130_fd_sc_hd__and4_1
XFILLER_40_589 VPWR VGND VPWR VGND sky130_ef_sc_hd__decap_12
XFILLER_121_3 VPWR VGND VPWR VGND sky130_ef_sc_hd__decap_12
XFILLER_60_67 VPWR VGND VPWR VGND sky130_ef_sc_hd__decap_12
XTAP_TAPCELL_ROW_10_437 VGND VPWR sky130_fd_sc_hd__tapvpwrvgnd_1
X_11321_ _04224_ _04225_ VGND VGND VPWR VPWR _04226_ sky130_fd_sc_hd__nor2_1
XFILLER_125_138 VGND VGND VPWR VPWR sky130_fd_sc_hd__decap_4
XFILLER_125_105 VGND VGND VPWR VPWR sky130_fd_sc_hd__decap_6
XFILLER_4_413 VGND VGND VPWR VPWR sky130_fd_sc_hd__decap_6
XFILLER_106_341 VGND VGND VPWR VPWR sky130_fd_sc_hd__fill_2
XFILLER_4_457 VPWR VGND VPWR VGND sky130_ef_sc_hd__decap_12
X_11252_ _04148_ _04149_ VGND VGND VPWR VPWR _04151_ sky130_fd_sc_hd__xor2_2
X_10203_ net867 VGND VGND VPWR VPWR _03005_ sky130_fd_sc_hd__inv_2
X_11183_ _03427_ _03961_ _03960_ VGND VGND VPWR VPWR _04075_ sky130_fd_sc_hd__o21bai_1
X_10134_ _02927_ _02928_ VGND VGND VPWR VPWR _02929_ sky130_fd_sc_hd__or2_1
XFILLER_95_729 VGND VGND VPWR VPWR sky130_fd_sc_hd__fill_2
XFILLER_0_641 VGND VGND VPWR VPWR sky130_fd_sc_hd__decap_3
XFILLER_125_93 VPWR VGND VPWR VGND sky130_ef_sc_hd__decap_12
X_10065_ net686 net663 net282 net280 VGND VGND VPWR VPWR _02854_ sky130_fd_sc_hd__and4_1
XFILLER_47_122 VGND VGND VPWR VPWR sky130_fd_sc_hd__decap_8
XFILLER_47_111 VGND VGND VPWR VPWR sky130_fd_sc_hd__fill_1
XFILLER_0_685 VPWR VGND VPWR VGND sky130_ef_sc_hd__decap_12
XFILLER_85_64 VGND VGND VPWR VPWR sky130_fd_sc_hd__decap_4
XTAP_TAPCELL_ROW_126_2060 VGND VPWR sky130_fd_sc_hd__tapvpwrvgnd_1
XFILLER_63_637 VPWR VGND VPWR VGND sky130_ef_sc_hd__decap_12
XFILLER_63_615 VGND VGND VPWR VPWR sky130_fd_sc_hd__fill_1
XFILLER_35_306 VGND VGND VPWR VPWR sky130_fd_sc_hd__fill_2
XTAP_TAPCELL_ROW_18_548 VGND VPWR sky130_fd_sc_hd__tapvpwrvgnd_1
XFILLER_50_309 VGND VGND VPWR VPWR sky130_fd_sc_hd__decap_6
X_10967_ _03779_ _03837_ _03838_ VGND VGND VPWR VPWR _03840_ sky130_fd_sc_hd__nand3_1
X_12706_ _05727_ _05733_ VGND VGND VPWR VPWR _05734_ sky130_fd_sc_hd__xnor2_1
X_10898_ net450 net560 _03606_ _03605_ VGND VGND VPWR VPWR _03764_ sky130_fd_sc_hd__a31o_1
X_12637_ _05300_ _05485_ _05488_ VGND VGND VPWR VPWR _05660_ sky130_fd_sc_hd__o21ai_2
XFILLER_12_781 VPWR VGND VPWR VGND sky130_ef_sc_hd__decap_12
X_12568_ net437 net420 net585 net583 VGND VGND VPWR VPWR _05584_ sky130_fd_sc_hd__and4_1
XFILLER_116_127 VPWR VGND VPWR VGND sky130_ef_sc_hd__decap_12
X_11519_ _04440_ _04441_ VGND VGND VPWR VPWR _04442_ sky130_fd_sc_hd__xnor2_1
XFILLER_7_273 VGND VGND VPWR VPWR sky130_fd_sc_hd__decap_6
X_12499_ net640 net285 _02273_ net665 VGND VGND VPWR VPWR _05508_ sky130_fd_sc_hd__o2bb2a_1
XFILLER_124_193 VGND VGND VPWR VPWR sky130_fd_sc_hd__decap_3
XFILLER_98_545 VGND VGND VPWR VPWR sky130_fd_sc_hd__fill_1
XTAP_TAPCELL_ROW_55_1066 VGND VPWR sky130_fd_sc_hd__tapvpwrvgnd_1
XFILLER_112_377 VGND VGND VPWR VPWR sky130_fd_sc_hd__decap_6
X_06991_ _05396_ _05407_ _05418_ VGND VGND VPWR VPWR _05429_ sky130_fd_sc_hd__or3_1
XFILLER_98_589 VPWR VGND VPWR VGND sky130_ef_sc_hd__decap_12
X_08730_ _01455_ _01456_ VGND VGND VPWR VPWR _01457_ sky130_fd_sc_hd__nor2_1
XPHY_EDGE_ROW_0_Left_137 VGND VGND VPWR VPWR sky130_fd_sc_hd__decap_3
XFILLER_39_634 VPWR VGND VPWR VGND sky130_ef_sc_hd__decap_12
X_08661_ _01387_ _01388_ VGND VGND VPWR VPWR _01389_ sky130_fd_sc_hd__or2_4
XFILLER_66_453 VGND VGND VPWR VPWR sky130_fd_sc_hd__fill_1
X_07612_ _00181_ _00190_ _00189_ VGND VGND VPWR VPWR _00352_ sky130_fd_sc_hd__a21oi_1
XFILLER_81_401 VGND VGND VPWR VPWR sky130_fd_sc_hd__fill_1
XFILLER_54_626 VGND VGND VPWR VPWR sky130_fd_sc_hd__decap_3
XTAP_TAPCELL_ROW_37_813 VGND VPWR sky130_fd_sc_hd__tapvpwrvgnd_1
XFILLER_39_689 VGND VGND VPWR VPWR sky130_fd_sc_hd__decap_4
X_08592_ _01177_ _01208_ VGND VGND VPWR VPWR _01321_ sky130_fd_sc_hd__nand2_1
X_07543_ _00281_ _00282_ VGND VGND VPWR VPWR _00283_ sky130_fd_sc_hd__nor2_1
Xclkbuf_3_5__f_clk clknet_0_clk VGND VGND VPWR VPWR clknet_3_5__leaf_clk sky130_fd_sc_hd__clkbuf_16
XFILLER_50_810 VGND VGND VPWR VPWR sky130_fd_sc_hd__fill_1
X_07474_ _00212_ _00213_ _00205_ VGND VGND VPWR VPWR _00215_ sky130_fd_sc_hd__a21o_1
XFILLER_14_27 VGND VGND VPWR VPWR sky130_fd_sc_hd__fill_1
XFILLER_22_523 VGND VGND VPWR VPWR sky130_fd_sc_hd__fill_1
XFILLER_34_372 VGND VGND VPWR VPWR sky130_fd_sc_hd__decap_8
X_09213_ _01932_ _01935_ VGND VGND VPWR VPWR _01937_ sky130_fd_sc_hd__xnor2_1
X_09144_ _01866_ _01867_ _01868_ VGND VGND VPWR VPWR _01869_ sky130_fd_sc_hd__a21o_1
XFILLER_22_589 VPWR VGND VPWR VGND sky130_ef_sc_hd__decap_12
X_09075_ _01755_ _01799_ VGND VGND VPWR VPWR _01800_ sky130_fd_sc_hd__and2b_1
XFILLER_30_26 VGND VGND VPWR VPWR sky130_fd_sc_hd__fill_2
XFILLER_135_447 VGND VGND VPWR VPWR sky130_fd_sc_hd__fill_1
X_08026_ _00759_ _00762_ VGND VGND VPWR VPWR _00763_ sky130_fd_sc_hd__and2b_1
XFILLER_122_119 VGND VGND VPWR VPWR sky130_fd_sc_hd__decap_6
XFILLER_116_672 VPWR VGND VPWR VGND sky130_ef_sc_hd__decap_12
XFILLER_1_405 VPWR VGND VPWR VGND sky130_ef_sc_hd__decap_12
XFILLER_89_545 VPWR VGND VPWR VGND sky130_ef_sc_hd__decap_12
XFILLER_1_449 VPWR VGND VPWR VGND sky130_ef_sc_hd__decap_12
XFILLER_131_653 VPWR VGND VPWR VGND sky130_ef_sc_hd__decap_12
XFILLER_130_141 VPWR VGND VPWR VGND sky130_ef_sc_hd__decap_12
X_09977_ _02758_ _02760_ VGND VGND VPWR VPWR _02762_ sky130_fd_sc_hd__xnor2_1
XFILLER_77_729 VGND VGND VPWR VPWR sky130_fd_sc_hd__decap_4
XFILLER_77_718 VGND VGND VPWR VPWR sky130_fd_sc_hd__fill_1
XFILLER_49_409 VPWR VGND VPWR VGND sky130_ef_sc_hd__decap_12
XFILLER_131_697 VPWR VGND VPWR VGND sky130_ef_sc_hd__decap_12
X_08928_ _01650_ _01651_ VGND VGND VPWR VPWR _01654_ sky130_fd_sc_hd__xnor2_1
XFILLER_76_239 VGND VGND VPWR VPWR sky130_fd_sc_hd__fill_2
XFILLER_39_68 VGND VGND VPWR VPWR sky130_fd_sc_hd__fill_1
XFILLER_85_751 VGND VGND VPWR VPWR sky130_fd_sc_hd__decap_6
X_08859_ net723 _01447_ _01584_ _01583_ VGND VGND VPWR VPWR _01586_ sky130_fd_sc_hd__a22o_1
XFILLER_85_795 VGND VGND VPWR VPWR sky130_fd_sc_hd__decap_4
XTAP_TAPCELL_ROW_86_1505 VGND VPWR sky130_fd_sc_hd__tapvpwrvgnd_1
XFILLER_72_401 VPWR VGND VPWR VGND sky130_ef_sc_hd__decap_12
XFILLER_17_328 VGND VGND VPWR VPWR sky130_fd_sc_hd__fill_1
X_11870_ _04676_ _04821_ VGND VGND VPWR VPWR _04822_ sky130_fd_sc_hd__or2_1
XFILLER_45_659 VPWR VGND VPWR VGND sky130_ef_sc_hd__decap_12
X_10821_ _03676_ _03678_ _03511_ VGND VGND VPWR VPWR _03680_ sky130_fd_sc_hd__a21oi_2
XFILLER_44_158 VGND VGND VPWR VPWR sky130_fd_sc_hd__decap_3
XTAP_TAPCELL_ROW_15_507 VGND VPWR sky130_fd_sc_hd__tapvpwrvgnd_1
XFILLER_32_309 VGND VGND VPWR VPWR sky130_fd_sc_hd__decap_4
X_10752_ _03280_ _03455_ _03454_ VGND VGND VPWR VPWR _03604_ sky130_fd_sc_hd__a21o_1
XFILLER_9_505 VGND VGND VPWR VPWR sky130_fd_sc_hd__decap_8
XFILLER_13_567 VGND VGND VPWR VPWR sky130_fd_sc_hd__fill_1
XFILLER_40_331 VPWR VGND VPWR VGND sky130_ef_sc_hd__decap_12
XFILLER_71_88 VPWR VGND VPWR VGND sky130_ef_sc_hd__decap_12
XFILLER_9_549 VGND VGND VPWR VPWR sky130_fd_sc_hd__decap_8
X_12422_ _05249_ _05252_ VGND VGND VPWR VPWR _05424_ sky130_fd_sc_hd__nand2_1
X_10683_ _03526_ _03527_ VGND VGND VPWR VPWR _03528_ sky130_fd_sc_hd__nand2_1
XTAP_TAPCELL_ROW_97_1656 VGND VPWR sky130_fd_sc_hd__tapvpwrvgnd_1
X_12353_ _05339_ _05346_ VGND VGND VPWR VPWR _05348_ sky130_fd_sc_hd__nand2b_1
XFILLER_126_469 VGND VGND VPWR VPWR sky130_fd_sc_hd__decap_6
XFILLER_4_221 VPWR VGND VPWR VGND sky130_ef_sc_hd__decap_12
X_11304_ _04092_ _04100_ _04103_ VGND VGND VPWR VPWR _04207_ sky130_fd_sc_hd__a21bo_1
X_12284_ _05270_ _05271_ VGND VGND VPWR VPWR _05273_ sky130_fd_sc_hd__xnor2_1
XFILLER_5_777 VGND VGND VPWR VPWR sky130_fd_sc_hd__decap_6
XFILLER_4_265 VPWR VGND VPWR VGND sky130_ef_sc_hd__decap_12
X_11235_ _04127_ _04130_ VGND VGND VPWR VPWR _04132_ sky130_fd_sc_hd__xnor2_1
XFILLER_20_92 VPWR VGND VPWR VGND sky130_ef_sc_hd__decap_12
XFILLER_136_81 VGND VGND VPWR VPWR sky130_fd_sc_hd__decap_3
X_11166_ _03887_ _03897_ _03896_ VGND VGND VPWR VPWR _04056_ sky130_fd_sc_hd__a21oi_1
XFILLER_121_163 VGND VGND VPWR VPWR sky130_fd_sc_hd__decap_4
XFILLER_96_85 VGND VGND VPWR VPWR sky130_fd_sc_hd__fill_1
XFILLER_96_63 VGND VGND VPWR VPWR sky130_fd_sc_hd__decap_3
X_10117_ _02905_ _02908_ VGND VGND VPWR VPWR _02911_ sky130_fd_sc_hd__xor2_1
XFILLER_0_482 VGND VGND VPWR VPWR sky130_fd_sc_hd__decap_3
X_11097_ net400 net574 VGND VGND VPWR VPWR _03982_ sky130_fd_sc_hd__nand2_1
X_10048_ _02833_ _02835_ VGND VGND VPWR VPWR _02836_ sky130_fd_sc_hd__or2_1
XFILLER_90_220 VGND VGND VPWR VPWR sky130_fd_sc_hd__decap_6
XFILLER_36_659 VGND VGND VPWR VPWR sky130_fd_sc_hd__decap_8
XFILLER_90_253 VGND VGND VPWR VPWR sky130_fd_sc_hd__decap_6
XFILLER_51_629 VPWR VGND VPWR VGND sky130_ef_sc_hd__decap_12
XTAP_TAPCELL_ROW_106_1785 VGND VPWR sky130_fd_sc_hd__tapvpwrvgnd_1
XTAP_TAPCELL_ROW_106_1774 VGND VPWR sky130_fd_sc_hd__tapvpwrvgnd_1
X_11999_ net234 _04961_ _04799_ _04802_ VGND VGND VPWR VPWR _04963_ sky130_fd_sc_hd__o211a_4
XFILLER_50_139 VGND VGND VPWR VPWR sky130_fd_sc_hd__fill_1
XFILLER_31_320 VPWR VGND VPWR VGND sky130_ef_sc_hd__decap_12
XFILLER_31_375 VPWR VGND VPWR VGND sky130_ef_sc_hd__decap_12
XTAP_TAPCELL_ROW_42_882 VGND VPWR sky130_fd_sc_hd__tapvpwrvgnd_1
XFILLER_129_241 VGND VGND VPWR VPWR sky130_fd_sc_hd__fill_1
X_07190_ _06479_ _06480_ _06452_ VGND VGND VPWR VPWR _06482_ sky130_fd_sc_hd__a21o_1
X_09900_ net97 net253 net545 VGND VGND VPWR VPWR _02679_ sky130_fd_sc_hd__mux2_1
XFILLER_6_83 VGND VGND VPWR VPWR sky130_fd_sc_hd__fill_1
XFILLER_116_29 VPWR VGND VPWR VGND sky130_ef_sc_hd__decap_12
Xfanout506 net511 VGND VGND VPWR VPWR net506 sky130_fd_sc_hd__clkbuf_2
X_09831_ _02589_ _02603_ VGND VGND VPWR VPWR _02604_ sky130_fd_sc_hd__or2_1
Xfanout517 net518 VGND VGND VPWR VPWR net517 sky130_fd_sc_hd__buf_2
Xfanout528 net18 VGND VGND VPWR VPWR net528 sky130_fd_sc_hd__buf_2
Xfanout539 net547 VGND VGND VPWR VPWR net539 sky130_fd_sc_hd__buf_2
XFILLER_113_697 VGND VGND VPWR VPWR sky130_fd_sc_hd__fill_2
XFILLER_112_163 VPWR VGND VPWR VGND sky130_ef_sc_hd__decap_12
X_06974_ _03390_ _03412_ VGND VGND VPWR VPWR _05243_ sky130_fd_sc_hd__or2_1
X_09762_ _02405_ _02527_ VGND VGND VPWR VPWR _02528_ sky130_fd_sc_hd__nor2_1
X_08713_ _01364_ _01439_ _01365_ _01440_ VGND VGND VPWR VPWR _01441_ sky130_fd_sc_hd__nor4_4
XFILLER_39_453 VGND VGND VPWR VPWR sky130_fd_sc_hd__fill_1
X_09693_ _02451_ _02452_ VGND VGND VPWR VPWR _02453_ sky130_fd_sc_hd__or2_1
Xrebuffer11 _03146_ VGND VGND VPWR VPWR net711 sky130_fd_sc_hd__dlymetal6s2s_1
X_08644_ _01369_ _01370_ _01368_ VGND VGND VPWR VPWR _01372_ sky130_fd_sc_hd__o21ai_1
Xrebuffer22 _01435_ VGND VGND VPWR VPWR net722 sky130_fd_sc_hd__dlymetal6s2s_1
XTAP_TAPCELL_ROW_68_1246 VGND VPWR sky130_fd_sc_hd__tapvpwrvgnd_1
XFILLER_66_294 VPWR VGND VPWR VGND sky130_ef_sc_hd__decap_12
XFILLER_66_283 VGND VGND VPWR VPWR sky130_fd_sc_hd__decap_8
Xrebuffer33 _05247_ VGND VGND VPWR VPWR net733 sky130_fd_sc_hd__buf_1
Xrebuffer44 _04520_ VGND VGND VPWR VPWR net744 sky130_fd_sc_hd__clkbuf_1
Xrebuffer55 net754 VGND VGND VPWR VPWR net755 sky130_fd_sc_hd__dlymetal6s4s_1
XFILLER_26_125 VPWR VGND VPWR VGND sky130_ef_sc_hd__decap_12
X_08575_ net701 _01301_ _01231_ VGND VGND VPWR VPWR _01304_ sky130_fd_sc_hd__o21ai_2
Xrebuffer77 _04972_ VGND VGND VPWR VPWR net777 sky130_fd_sc_hd__dlymetal6s2s_1
Xrebuffer88 net431 VGND VGND VPWR VPWR net788 sky130_fd_sc_hd__dlygate4sd1_1
XFILLER_14_309 VPWR VGND VPWR VGND sky130_ef_sc_hd__decap_12
XFILLER_26_147 VGND VGND VPWR VPWR sky130_fd_sc_hd__fill_1
Xrebuffer66 net5 VGND VGND VPWR VPWR net766 sky130_fd_sc_hd__dlygate4sd1_1
X_07526_ _06645_ _06647_ _00265_ _00266_ VGND VGND VPWR VPWR _00267_ sky130_fd_sc_hd__o211ai_2
Xrebuffer99 _00412_ VGND VGND VPWR VPWR net799 sky130_fd_sc_hd__buf_1
XTAP_TAPCELL_ROW_81_1424 VGND VPWR sky130_fd_sc_hd__tapvpwrvgnd_1
XTAP_TAPCELL_ROW_81_1435 VGND VPWR sky130_fd_sc_hd__tapvpwrvgnd_1
XFILLER_34_180 VPWR VGND VPWR VGND sky130_ef_sc_hd__decap_12
X_07457_ _00166_ _00196_ VGND VGND VPWR VPWR _00198_ sky130_fd_sc_hd__xnor2_1
X_07388_ _06676_ _00128_ VGND VGND VPWR VPWR _00129_ sky130_fd_sc_hd__xnor2_1
Xrebuffer101 _00252_ VGND VGND VPWR VPWR net801 sky130_fd_sc_hd__buf_1
X_09127_ _01849_ _01850_ _01843_ VGND VGND VPWR VPWR _01852_ sky130_fd_sc_hd__a21o_1
Xrebuffer123 _01265_ VGND VGND VPWR VPWR net823 sky130_fd_sc_hd__dlymetal6s2s_1
XFILLER_108_447 VPWR VGND VPWR VGND sky130_ef_sc_hd__decap_12
X_09058_ net264 net262 VGND VGND VPWR VPWR _01783_ sky130_fd_sc_hd__or2_1
Xrebuffer167 net897 VGND VGND VPWR VPWR net867 sky130_fd_sc_hd__dlymetal6s2s_1
XTAP_TAPCELL_ROW_20_576 VGND VPWR sky130_fd_sc_hd__tapvpwrvgnd_1
X_08009_ _00745_ _00744_ VGND VGND VPWR VPWR _00746_ sky130_fd_sc_hd__nand2b_1
XTAP_TAPCELL_ROW_79_1397 VGND VPWR sky130_fd_sc_hd__tapvpwrvgnd_1
XFILLER_104_642 VGND VGND VPWR VPWR sky130_fd_sc_hd__fill_2
XFILLER_2_725 VPWR VGND VPWR VGND sky130_ef_sc_hd__decap_12
XTAP_TAPCELL_ROW_92_1586 VGND VPWR sky130_fd_sc_hd__tapvpwrvgnd_1
XFILLER_2_769 VPWR VGND VPWR VGND sky130_ef_sc_hd__decap_12
X_11020_ _03888_ _03895_ VGND VGND VPWR VPWR _03897_ sky130_fd_sc_hd__xor2_1
XFILLER_131_461 VPWR VGND VPWR VGND sky130_ef_sc_hd__decap_12
XFILLER_106_51 VGND VGND VPWR VPWR sky130_fd_sc_hd__decap_8
XFILLER_77_537 VGND VGND VPWR VPWR sky130_fd_sc_hd__decap_3
XFILLER_1_279 VGND VGND VPWR VPWR sky130_fd_sc_hd__fill_1
XFILLER_92_507 VPWR VGND VPWR VGND sky130_ef_sc_hd__decap_12
XFILLER_57_250 VPWR VGND VPWR VGND sky130_ef_sc_hd__decap_12
X_12971_ _06016_ _06022_ VGND VGND VPWR VPWR _06024_ sky130_fd_sc_hd__xor2_1
X_11922_ _04695_ _04698_ _04876_ VGND VGND VPWR VPWR _04878_ sky130_fd_sc_hd__o21ai_1
XFILLER_57_294 VGND VGND VPWR VPWR sky130_fd_sc_hd__decap_3
XFILLER_17_125 VGND VGND VPWR VPWR sky130_fd_sc_hd__fill_1
XFILLER_73_765 VPWR VGND VPWR VGND sky130_ef_sc_hd__decap_12
XFILLER_72_242 VGND VGND VPWR VPWR sky130_fd_sc_hd__decap_3
XPHY_EDGE_ROW_72_Left_209 VGND VGND VPWR VPWR sky130_fd_sc_hd__decap_3
X_11853_ _04798_ _04800_ _04759_ VGND VGND VPWR VPWR _04803_ sky130_fd_sc_hd__o21a_1
XFILLER_17_169 VPWR VGND VPWR VGND sky130_ef_sc_hd__decap_12
XTAP_TAPCELL_ROW_0_290 VGND VPWR sky130_fd_sc_hd__tapvpwrvgnd_1
XFILLER_26_681 VPWR VGND VPWR VGND sky130_ef_sc_hd__decap_12
XTAP_TAPCELL_ROW_28_687 VGND VPWR sky130_fd_sc_hd__tapvpwrvgnd_1
X_10804_ _03623_ _03624_ _03659_ _03660_ VGND VGND VPWR VPWR _03661_ sky130_fd_sc_hd__nor4_4
XFILLER_60_448 VGND VGND VPWR VPWR sky130_fd_sc_hd__fill_2
X_11784_ _04669_ _04724_ _04723_ VGND VGND VPWR VPWR _04727_ sky130_fd_sc_hd__o21ai_2
XFILLER_32_139 VGND VGND VPWR VPWR sky130_fd_sc_hd__fill_1
XFILLER_9_313 VPWR VGND VPWR VGND sky130_ef_sc_hd__decap_12
X_10735_ net458 net153 VGND VGND VPWR VPWR _03585_ sky130_fd_sc_hd__and2b_1
XFILLER_41_662 VGND VGND VPWR VPWR sky130_fd_sc_hd__decap_8
XFILLER_41_673 VGND VGND VPWR VPWR sky130_fd_sc_hd__fill_2
X_10666_ _03381_ _03383_ _03507_ VGND VGND VPWR VPWR _03509_ sky130_fd_sc_hd__and3_1
X_13385_ clknet_3_5__leaf_clk _00031_ _00095_ VGND VGND VPWR VPWR net184 sky130_fd_sc_hd__dfrtp_1
X_12405_ net437 net586 net584 net446 VGND VGND VPWR VPWR _05405_ sky130_fd_sc_hd__a22o_1
XTAP_TAPCELL_ROW_134_2170 VGND VPWR sky130_fd_sc_hd__tapvpwrvgnd_1
XFILLER_5_541 VPWR VGND VPWR VGND sky130_ef_sc_hd__decap_12
X_10597_ net512 net425 net345 net56 VGND VGND VPWR VPWR _03435_ sky130_fd_sc_hd__nand4_1
XFILLER_126_266 VGND VGND VPWR VPWR sky130_fd_sc_hd__decap_8
XPHY_EDGE_ROW_81_Left_218 VGND VGND VPWR VPWR sky130_fd_sc_hd__decap_3
X_12336_ _05318_ _05320_ _05328_ VGND VGND VPWR VPWR _05329_ sky130_fd_sc_hd__or3_1
XFILLER_5_585 VPWR VGND VPWR VGND sky130_ef_sc_hd__decap_12
X_12267_ _05251_ _05252_ _05248_ VGND VGND VPWR VPWR _05255_ sky130_fd_sc_hd__a21o_1
X_12198_ _05161_ _05178_ VGND VGND VPWR VPWR _05179_ sky130_fd_sc_hd__xnor2_1
X_11218_ net496 net635 VGND VGND VPWR VPWR _04114_ sky130_fd_sc_hd__and2b_1
XTAP_TAPCELL_ROW_52_1025 VGND VPWR sky130_fd_sc_hd__tapvpwrvgnd_1
X_11149_ net590 net272 _02230_ net615 VGND VGND VPWR VPWR _04038_ sky130_fd_sc_hd__o2bb2a_1
XTAP_TAPCELL_ROW_108_1803 VGND VPWR sky130_fd_sc_hd__tapvpwrvgnd_1
XFILLER_49_762 VGND VGND VPWR VPWR sky130_fd_sc_hd__decap_8
X_06690_ net105 VGND VGND VPWR VPWR _02153_ sky130_fd_sc_hd__inv_2
XPHY_EDGE_ROW_90_Left_227 VGND VGND VPWR VPWR sky130_fd_sc_hd__decap_3
XFILLER_76_581 VGND VGND VPWR VPWR sky130_fd_sc_hd__decap_6
XFILLER_64_787 VGND VGND VPWR VPWR sky130_fd_sc_hd__decap_8
XTAP_TAPCELL_ROW_47_952 VGND VPWR sky130_fd_sc_hd__tapvpwrvgnd_1
X_08360_ net270 net264 VGND VGND VPWR VPWR _01092_ sky130_fd_sc_hd__nand2_1
X_07311_ _06592_ _06600_ _06601_ VGND VGND VPWR VPWR _06602_ sky130_fd_sc_hd__nand3_1
XFILLER_32_640 VGND VGND VPWR VPWR sky130_fd_sc_hd__decap_4
X_08291_ _01020_ _01024_ VGND VGND VPWR VPWR _01026_ sky130_fd_sc_hd__xor2_1
XTAP_TAPCELL_ROW_63_1176 VGND VPWR sky130_fd_sc_hd__tapvpwrvgnd_1
X_07242_ net521 net505 net102 net680 VGND VGND VPWR VPWR _06533_ sky130_fd_sc_hd__and4_1
XFILLER_118_723 VGND VGND VPWR VPWR sky130_fd_sc_hd__decap_3
XFILLER_118_701 VGND VGND VPWR VPWR sky130_fd_sc_hd__fill_2
X_07173_ net390 net388 net818 net310 VGND VGND VPWR VPWR _06465_ sky130_fd_sc_hd__and4_1
XFILLER_118_745 VGND VGND VPWR VPWR sky130_fd_sc_hd__fill_1
XTAP_TAPCELL_ROW_119_1965 VGND VPWR sky130_fd_sc_hd__tapvpwrvgnd_1
XTAP_TAPCELL_ROW_119_1954 VGND VPWR sky130_fd_sc_hd__tapvpwrvgnd_1
XFILLER_117_222 VGND VGND VPWR VPWR sky130_fd_sc_hd__fill_2
XFILLER_11_39 VPWR VGND VPWR VGND sky130_ef_sc_hd__decap_12
XFILLER_127_39 VPWR VGND VPWR VGND sky130_ef_sc_hd__decap_12
XFILLER_117_288 VPWR VGND VPWR VGND sky130_ef_sc_hd__decap_12
XFILLER_105_428 VGND VGND VPWR VPWR sky130_fd_sc_hd__decap_3
Xfanout303 net72 VGND VGND VPWR VPWR net303 sky130_fd_sc_hd__clkbuf_2
XFILLER_99_673 VGND VGND VPWR VPWR sky130_fd_sc_hd__decap_8
Xfanout314 net315 VGND VGND VPWR VPWR net314 sky130_fd_sc_hd__clkbuf_4
X_09814_ _02583_ _02584_ VGND VGND VPWR VPWR _02585_ sky130_fd_sc_hd__and2b_1
XFILLER_113_461 VGND VGND VPWR VPWR sky130_fd_sc_hd__decap_6
XFILLER_101_601 VGND VGND VPWR VPWR sky130_fd_sc_hd__decap_8
Xfanout325 net64 VGND VGND VPWR VPWR net325 sky130_fd_sc_hd__buf_2
Xfanout336 net337 VGND VGND VPWR VPWR net336 sky130_fd_sc_hd__buf_6
Xfanout347 net54 VGND VGND VPWR VPWR net347 sky130_fd_sc_hd__buf_1
Xfanout358 net359 VGND VGND VPWR VPWR net358 sky130_fd_sc_hd__buf_8
Xfanout369 net43 VGND VGND VPWR VPWR net369 sky130_fd_sc_hd__buf_2
XPHY_EDGE_ROW_129_Left_266 VGND VGND VPWR VPWR sky130_fd_sc_hd__decap_3
X_06957_ _04992_ _05003_ _05036_ VGND VGND VPWR VPWR _05058_ sky130_fd_sc_hd__a21o_1
X_09745_ net248 _02165_ _02378_ VGND VGND VPWR VPWR _02509_ sky130_fd_sc_hd__or3_1
X_09676_ _02428_ _02433_ VGND VGND VPWR VPWR _02434_ sky130_fd_sc_hd__and2b_1
X_06888_ _04232_ _04243_ _04297_ VGND VGND VPWR VPWR _04308_ sky130_fd_sc_hd__nand3_1
XFILLER_55_721 VGND VGND VPWR VPWR sky130_fd_sc_hd__fill_1
XFILLER_27_434 VGND VGND VPWR VPWR sky130_fd_sc_hd__decap_8
X_08627_ _01353_ _01354_ VGND VGND VPWR VPWR _01355_ sky130_fd_sc_hd__nand2_1
XFILLER_54_253 VGND VGND VPWR VPWR sky130_fd_sc_hd__fill_2
XFILLER_42_404 VPWR VGND VPWR VGND sky130_ef_sc_hd__decap_12
XFILLER_14_106 VPWR VGND VPWR VGND sky130_ef_sc_hd__decap_12
X_08558_ _01279_ _01280_ _01286_ VGND VGND VPWR VPWR _01287_ sky130_fd_sc_hd__and3_4
XTAP_TAPCELL_ROW_25_646 VGND VPWR sky130_fd_sc_hd__tapvpwrvgnd_1
X_08489_ _01216_ _01217_ VGND VGND VPWR VPWR _01218_ sky130_fd_sc_hd__or2_1
X_07509_ _00247_ _00245_ _00228_ VGND VGND VPWR VPWR _00250_ sky130_fd_sc_hd__a21o_1
XFILLER_23_673 VPWR VGND VPWR VGND sky130_ef_sc_hd__decap_12
XFILLER_22_194 VGND VGND VPWR VPWR sky130_fd_sc_hd__fill_2
X_10520_ net531 net635 VGND VGND VPWR VPWR _03350_ sky130_fd_sc_hd__and2b_1
X_10451_ _03272_ _03273_ _03130_ VGND VGND VPWR VPWR _03275_ sky130_fd_sc_hd__a21oi_1
XTAP_TAPCELL_ROW_94_1615 VGND VPWR sky130_fd_sc_hd__tapvpwrvgnd_1
XTAP_TAPCELL_ROW_94_1604 VGND VPWR sky130_fd_sc_hd__tapvpwrvgnd_1
XFILLER_10_389 VPWR VGND VPWR VGND sky130_ef_sc_hd__decap_12
XFILLER_136_553 VGND VGND VPWR VPWR sky130_fd_sc_hd__decap_3
XFILLER_109_778 VGND VGND VPWR VPWR sky130_fd_sc_hd__decap_6
XFILLER_108_277 VGND VGND VPWR VPWR sky130_fd_sc_hd__decap_4
X_10382_ _03065_ _03199_ VGND VGND VPWR VPWR _03200_ sky130_fd_sc_hd__nor2_1
X_13170_ _06233_ _06240_ VGND VGND VPWR VPWR _06241_ sky130_fd_sc_hd__xnor2_1
XFILLER_136_597 VGND VGND VPWR VPWR sky130_fd_sc_hd__decap_8
XFILLER_124_737 VPWR VGND VPWR VGND sky130_ef_sc_hd__decap_12
XFILLER_123_225 VPWR VGND VPWR VGND sky130_ef_sc_hd__decap_12
X_12121_ _04939_ _04941_ _04940_ VGND VGND VPWR VPWR _05095_ sky130_fd_sc_hd__o21bai_1
XFILLER_2_533 VPWR VGND VPWR VGND sky130_ef_sc_hd__decap_12
X_12052_ _05018_ _05019_ VGND VGND VPWR VPWR _05020_ sky130_fd_sc_hd__or2_1
XFILLER_132_781 VPWR VGND VPWR VGND sky130_ef_sc_hd__decap_12
XFILLER_104_483 VGND VGND VPWR VPWR sky130_fd_sc_hd__fill_1
XFILLER_77_54 VGND VGND VPWR VPWR sky130_fd_sc_hd__fill_2
X_11003_ net615 _02077_ net272 net89 VGND VGND VPWR VPWR _03878_ sky130_fd_sc_hd__and4_1
XFILLER_77_334 VGND VGND VPWR VPWR sky130_fd_sc_hd__fill_2
XFILLER_77_87 VGND VGND VPWR VPWR sky130_fd_sc_hd__fill_1
XTAP_TAPCELL_ROW_5_371 VGND VPWR sky130_fd_sc_hd__tapvpwrvgnd_1
XTAP_TAPCELL_ROW_5_360 VGND VPWR sky130_fd_sc_hd__tapvpwrvgnd_1
XFILLER_133_93 VPWR VGND VPWR VGND sky130_ef_sc_hd__decap_12
X_12954_ _06002_ _06003_ VGND VGND VPWR VPWR _06005_ sky130_fd_sc_hd__xnor2_1
XFILLER_93_64 VGND VGND VPWR VPWR sky130_fd_sc_hd__decap_3
XFILLER_93_53 VGND VGND VPWR VPWR sky130_fd_sc_hd__decap_3
X_11905_ _04857_ _04858_ VGND VGND VPWR VPWR _04859_ sky130_fd_sc_hd__nor2_1
XFILLER_46_754 VGND VGND VPWR VPWR sky130_fd_sc_hd__fill_2
XFILLER_18_467 VGND VGND VPWR VPWR sky130_fd_sc_hd__decap_8
XFILLER_93_86 VGND VGND VPWR VPWR sky130_fd_sc_hd__decap_8
XTAP_TAPCELL_ROW_44_911 VGND VPWR sky130_fd_sc_hd__tapvpwrvgnd_1
X_12885_ _05923_ _05929_ VGND VGND VPWR VPWR _05930_ sky130_fd_sc_hd__xnor2_1
XTAP_TAPCELL_ROW_103_1733 VGND VPWR sky130_fd_sc_hd__tapvpwrvgnd_1
XFILLER_61_779 VGND VGND VPWR VPWR sky130_fd_sc_hd__fill_2
X_11836_ _04782_ _04760_ _04783_ VGND VGND VPWR VPWR _04784_ sky130_fd_sc_hd__or3_4
XFILLER_26_91 VGND VGND VPWR VPWR sky130_fd_sc_hd__fill_1
X_11767_ _04706_ _04707_ VGND VGND VPWR VPWR _04709_ sky130_fd_sc_hd__nand2_1
XTAP_TAPCELL_ROW_136_2210 VGND VPWR sky130_fd_sc_hd__tapvpwrvgnd_1
X_10718_ _03425_ _03447_ _03446_ VGND VGND VPWR VPWR _03567_ sky130_fd_sc_hd__a21oi_1
X_11698_ _04630_ _04631_ VGND VGND VPWR VPWR _04634_ sky130_fd_sc_hd__xor2_1
Xrebuffer2 net701 VGND VGND VPWR VPWR net702 sky130_fd_sc_hd__buf_1
X_10649_ _03384_ _03491_ VGND VGND VPWR VPWR _03492_ sky130_fd_sc_hd__nor2_1
XFILLER_42_90 VGND VGND VPWR VPWR sky130_fd_sc_hd__decap_6
X_13368_ clknet_3_2__leaf_clk _00043_ _00078_ VGND VGND VPWR VPWR net167 sky130_fd_sc_hd__dfrtp_1
X_12319_ _05161_ _05176_ _05175_ VGND VGND VPWR VPWR _05311_ sky130_fd_sc_hd__o21ai_1
X_13299_ net394 VGND VGND VPWR VPWR _00073_ sky130_fd_sc_hd__inv_2
XFILLER_102_409 VGND VGND VPWR VPWR sky130_fd_sc_hd__decap_8
XFILLER_47_3 VGND VGND VPWR VPWR sky130_fd_sc_hd__fill_2
XFILLER_5_393 VPWR VGND VPWR VGND sky130_ef_sc_hd__decap_12
XFILLER_123_781 VGND VGND VPWR VPWR sky130_fd_sc_hd__decap_3
XTAP_TAPCELL_ROW_114_1895 VGND VPWR sky130_fd_sc_hd__tapvpwrvgnd_1
XTAP_TAPCELL_ROW_114_1884 VGND VPWR sky130_fd_sc_hd__tapvpwrvgnd_1
X_07860_ _00458_ _00462_ _00461_ VGND VGND VPWR VPWR _00598_ sky130_fd_sc_hd__o21ai_1
XFILLER_68_345 VGND VGND VPWR VPWR sky130_fd_sc_hd__decap_8
XFILLER_3_51 VGND VGND VPWR VPWR sky130_fd_sc_hd__decap_4
X_06811_ net321 net667 net642 net323 VGND VGND VPWR VPWR _03467_ sky130_fd_sc_hd__a22o_1
XFILLER_110_475 VGND VGND VPWR VPWR sky130_fd_sc_hd__fill_1
X_07791_ _00518_ _00529_ VGND VGND VPWR VPWR _00530_ sky130_fd_sc_hd__xnor2_1
XFILLER_28_209 VPWR VGND VPWR VGND sky130_ef_sc_hd__decap_12
XFILLER_37_710 VGND VGND VPWR VPWR sky130_fd_sc_hd__decap_8
X_06742_ _02697_ _02708_ VGND VGND VPWR VPWR _00007_ sky130_fd_sc_hd__and2_1
X_09530_ _02241_ _02276_ VGND VGND VPWR VPWR _02277_ sky130_fd_sc_hd__xor2_1
X_09461_ _02199_ _02201_ VGND VGND VPWR VPWR _02202_ sky130_fd_sc_hd__nor2_1
XFILLER_36_231 VPWR VGND VPWR VGND sky130_ef_sc_hd__decap_12
XTAP_TAPCELL_ROW_65_1205 VGND VPWR sky130_fd_sc_hd__tapvpwrvgnd_1
X_09392_ _02086_ _02125_ VGND VGND VPWR VPWR _02126_ sky130_fd_sc_hd__nand2b_1
X_08412_ net523 net633 VGND VGND VPWR VPWR _01142_ sky130_fd_sc_hd__nand2_1
XFILLER_52_757 VGND VGND VPWR VPWR sky130_fd_sc_hd__decap_6
XFILLER_51_223 VGND VGND VPWR VPWR sky130_fd_sc_hd__fill_1
X_08343_ _01051_ _01055_ VGND VGND VPWR VPWR _01077_ sky130_fd_sc_hd__xnor2_1
XTAP_TAPCELL_ROW_22_605 VGND VPWR sky130_fd_sc_hd__tapvpwrvgnd_1
X_08274_ _00910_ _00912_ _01008_ VGND VGND VPWR VPWR _01009_ sky130_fd_sc_hd__o21a_1
XFILLER_20_643 VGND VGND VPWR VPWR sky130_fd_sc_hd__fill_1
X_07225_ _06345_ _06515_ VGND VGND VPWR VPWR _06516_ sky130_fd_sc_hd__xnor2_1
XFILLER_20_654 VGND VGND VPWR VPWR sky130_fd_sc_hd__decap_4
XFILLER_20_698 VGND VGND VPWR VPWR sky130_fd_sc_hd__fill_2
X_07156_ _06445_ _06446_ _06437_ VGND VGND VPWR VPWR _06448_ sky130_fd_sc_hd__a21o_1
X_07087_ _05144_ _06378_ VGND VGND VPWR VPWR _06379_ sky130_fd_sc_hd__nor2_1
XTAP_TAPCELL_ROW_76_1356 VGND VPWR sky130_fd_sc_hd__tapvpwrvgnd_1
XFILLER_121_729 VPWR VGND VPWR VGND sky130_ef_sc_hd__decap_12
XFILLER_114_781 VPWR VGND VPWR VGND sky130_ef_sc_hd__decap_12
XFILLER_87_621 VGND VGND VPWR VPWR sky130_fd_sc_hd__fill_1
XFILLER_87_610 VGND VGND VPWR VPWR sky130_fd_sc_hd__decap_6
XFILLER_59_312 VGND VGND VPWR VPWR sky130_fd_sc_hd__decap_4
XFILLER_101_431 VGND VGND VPWR VPWR sky130_fd_sc_hd__fill_1
XFILLER_75_805 VGND VGND VPWR VPWR sky130_fd_sc_hd__decap_3
XFILLER_74_315 VGND VGND VPWR VPWR sky130_fd_sc_hd__fill_1
XFILLER_47_46 VGND VGND VPWR VPWR sky130_fd_sc_hd__decap_6
X_09728_ _02489_ _02491_ VGND VGND VPWR VPWR _02492_ sky130_fd_sc_hd__or2_1
X_07989_ _00717_ _00724_ VGND VGND VPWR VPWR _00726_ sky130_fd_sc_hd__xnor2_1
XFILLER_74_326 VGND VGND VPWR VPWR sky130_fd_sc_hd__decap_8
XPHY_EDGE_ROW_29_Right_29 VGND VGND VPWR VPWR sky130_fd_sc_hd__decap_3
XFILLER_27_242 VPWR VGND VPWR VGND sky130_ef_sc_hd__decap_12
XFILLER_28_754 VGND VGND VPWR VPWR sky130_fd_sc_hd__fill_2
XFILLER_82_381 VGND VGND VPWR VPWR sky130_fd_sc_hd__fill_1
X_09659_ _02412_ _02414_ VGND VGND VPWR VPWR _02416_ sky130_fd_sc_hd__xnor2_1
X_12670_ _05687_ _05694_ VGND VGND VPWR VPWR _05695_ sky130_fd_sc_hd__and2_1
XFILLER_70_587 VGND VGND VPWR VPWR sky130_fd_sc_hd__fill_1
X_11621_ _04549_ _04552_ VGND VGND VPWR VPWR _04553_ sky130_fd_sc_hd__xnor2_1
XFILLER_8_29 VPWR VGND VPWR VGND sky130_ef_sc_hd__decap_12
XFILLER_11_643 VGND VGND VPWR VPWR sky130_fd_sc_hd__decap_6
X_11552_ _04246_ _04369_ _04476_ VGND VGND VPWR VPWR _04478_ sky130_fd_sc_hd__and3_1
XPHY_EDGE_ROW_38_Right_38 VGND VGND VPWR VPWR sky130_fd_sc_hd__decap_3
XFILLER_109_542 VGND VGND VPWR VPWR sky130_fd_sc_hd__fill_1
X_10503_ _03329_ _03331_ VGND VGND VPWR VPWR _00021_ sky130_fd_sc_hd__xnor2_1
XFILLER_6_113 VPWR VGND VPWR VGND sky130_ef_sc_hd__decap_12
X_11483_ _04037_ _04252_ _04250_ VGND VGND VPWR VPWR _04403_ sky130_fd_sc_hd__o21a_1
XFILLER_109_575 VGND VGND VPWR VPWR sky130_fd_sc_hd__fill_1
X_10434_ net467 net559 VGND VGND VPWR VPWR _03256_ sky130_fd_sc_hd__nand2_1
X_13222_ _06271_ _06297_ VGND VGND VPWR VPWR _06298_ sky130_fd_sc_hd__and2b_1
X_10365_ _03050_ _03056_ _03180_ _03179_ VGND VGND VPWR VPWR _03182_ sky130_fd_sc_hd__a22o_1
X_13153_ _05225_ _06221_ VGND VGND VPWR VPWR _06222_ sky130_fd_sc_hd__nand2_1
X_12104_ _05055_ _05075_ VGND VGND VPWR VPWR _05076_ sky130_fd_sc_hd__xnor2_1
X_10296_ _03102_ _03103_ VGND VGND VPWR VPWR _03106_ sky130_fd_sc_hd__xnor2_1
XFILLER_2_363 VGND VGND VPWR VPWR sky130_fd_sc_hd__fill_1
X_13084_ _06140_ _06146_ VGND VGND VPWR VPWR _06147_ sky130_fd_sc_hd__nand2_1
XFILLER_78_643 VGND VGND VPWR VPWR sky130_fd_sc_hd__fill_1
X_12035_ _04999_ _05000_ VGND VGND VPWR VPWR _05001_ sky130_fd_sc_hd__or2_1
XFILLER_78_698 VGND VGND VPWR VPWR sky130_fd_sc_hd__fill_2
XPHY_EDGE_ROW_47_Right_47 VGND VGND VPWR VPWR sky130_fd_sc_hd__decap_3
XFILLER_92_123 VGND VGND VPWR VPWR sky130_fd_sc_hd__fill_2
XFILLER_65_337 VPWR VGND VPWR VGND sky130_ef_sc_hd__decap_12
XFILLER_19_732 VPWR VGND VPWR VGND sky130_ef_sc_hd__decap_12
XFILLER_92_167 VGND VGND VPWR VPWR sky130_fd_sc_hd__decap_8
XFILLER_46_540 VPWR VGND VPWR VGND sky130_ef_sc_hd__decap_12
X_12937_ _05982_ _05983_ _05985_ VGND VGND VPWR VPWR _05987_ sky130_fd_sc_hd__or3_1
XFILLER_18_253 VGND VGND VPWR VPWR sky130_fd_sc_hd__decap_4
XFILLER_18_275 VPWR VGND VPWR VGND sky130_ef_sc_hd__decap_12
XFILLER_34_713 VPWR VGND VPWR VGND sky130_ef_sc_hd__decap_12
XFILLER_73_381 VGND VGND VPWR VPWR sky130_fd_sc_hd__decap_8
X_12868_ net499 net657 VGND VGND VPWR VPWR _05912_ sky130_fd_sc_hd__and2b_1
XFILLER_34_757 VGND VGND VPWR VPWR sky130_fd_sc_hd__fill_2
X_11819_ net378 net357 net370 net368 VGND VGND VPWR VPWR _04766_ sky130_fd_sc_hd__and4_1
XTAP_TAPCELL_ROW_60_1135 VGND VPWR sky130_fd_sc_hd__tapvpwrvgnd_1
XPHY_EDGE_ROW_56_Right_56 VGND VGND VPWR VPWR sky130_fd_sc_hd__decap_3
X_12799_ _05831_ _05832_ _05835_ VGND VGND VPWR VPWR _05836_ sky130_fd_sc_hd__or3_1
XFILLER_134_309 VPWR VGND VPWR VGND sky130_ef_sc_hd__decap_12
XTAP_TAPCELL_ROW_116_1924 VGND VPWR sky130_fd_sc_hd__tapvpwrvgnd_1
XTAP_TAPCELL_ROW_116_1913 VGND VPWR sky130_fd_sc_hd__tapvpwrvgnd_1
X_07010_ net460 net606 net603 net469 VGND VGND VPWR VPWR _05637_ sky130_fd_sc_hd__a22oi_1
XFILLER_115_523 VPWR VGND VPWR VGND sky130_ef_sc_hd__decap_12
XFILLER_103_729 VGND VGND VPWR VPWR sky130_fd_sc_hd__decap_8
XFILLER_69_610 VGND VGND VPWR VPWR sky130_fd_sc_hd__decap_6
X_08961_ net698 _02208_ _01683_ _01685_ VGND VGND VPWR VPWR _01687_ sky130_fd_sc_hd__or4b_4
XPHY_EDGE_ROW_65_Right_65 VGND VGND VPWR VPWR sky130_fd_sc_hd__decap_3
XFILLER_124_29 VPWR VGND VPWR VGND sky130_ef_sc_hd__decap_12
X_08892_ _01494_ _01503_ _01502_ VGND VGND VPWR VPWR _01618_ sky130_fd_sc_hd__a21o_1
X_07912_ _00644_ _00649_ VGND VGND VPWR VPWR _00650_ sky130_fd_sc_hd__xnor2_1
XFILLER_69_643 VGND VGND VPWR VPWR sky130_fd_sc_hd__fill_2
X_07843_ net316 net306 net543 VGND VGND VPWR VPWR _00581_ sky130_fd_sc_hd__o21ai_1
XFILLER_96_462 VPWR VGND VPWR VGND sky130_ef_sc_hd__decap_12
XTAP_TAPCELL_ROW_71_1286 VGND VPWR sky130_fd_sc_hd__tapvpwrvgnd_1
XFILLER_68_153 VPWR VGND VPWR VGND sky130_ef_sc_hd__decap_12
XFILLER_56_304 VGND VGND VPWR VPWR sky130_fd_sc_hd__decap_4
XFILLER_68_197 VPWR VGND VPWR VGND sky130_ef_sc_hd__decap_12
XFILLER_56_315 VGND VGND VPWR VPWR sky130_fd_sc_hd__decap_8
X_07774_ _00508_ _00511_ _00512_ VGND VGND VPWR VPWR _00513_ sky130_fd_sc_hd__or3_1
XFILLER_56_359 VGND VGND VPWR VPWR sky130_fd_sc_hd__decap_4
XFILLER_17_27 VGND VGND VPWR VPWR sky130_fd_sc_hd__decap_4
XFILLER_37_540 VGND VGND VPWR VPWR sky130_fd_sc_hd__fill_2
X_09513_ _02257_ _02256_ VGND VGND VPWR VPWR _02258_ sky130_fd_sc_hd__and2b_1
X_06725_ net252 net527 VGND VGND VPWR VPWR _02533_ sky130_fd_sc_hd__nand2_1
XFILLER_37_573 VGND VGND VPWR VPWR sky130_fd_sc_hd__decap_3
X_09444_ _02177_ _02182_ VGND VGND VPWR VPWR _02183_ sky130_fd_sc_hd__and2_1
XFILLER_52_554 VGND VGND VPWR VPWR sky130_fd_sc_hd__decap_3
XFILLER_52_521 VGND VGND VPWR VPWR sky130_fd_sc_hd__fill_1
XFILLER_24_234 VGND VGND VPWR VPWR sky130_fd_sc_hd__fill_1
XPHY_EDGE_ROW_74_Right_74 VGND VGND VPWR VPWR sky130_fd_sc_hd__decap_3
X_09375_ _01946_ _01949_ _01952_ VGND VGND VPWR VPWR _02107_ sky130_fd_sc_hd__a21o_1
XTAP_TAPCELL_ROW_35_785 VGND VPWR sky130_fd_sc_hd__tapvpwrvgnd_1
X_08326_ _01057_ _01059_ VGND VGND VPWR VPWR _01060_ sky130_fd_sc_hd__xnor2_1
XFILLER_20_451 VGND VGND VPWR VPWR sky130_fd_sc_hd__fill_1
X_08257_ _00893_ _00990_ VGND VGND VPWR VPWR _00992_ sky130_fd_sc_hd__and2_1
X_07208_ _06498_ _06499_ VGND VGND VPWR VPWR _06500_ sky130_fd_sc_hd__and2b_1
X_08188_ _00890_ _00923_ VGND VGND VPWR VPWR _00924_ sky130_fd_sc_hd__xnor2_1
X_07139_ _06403_ _06430_ VGND VGND VPWR VPWR _06431_ sky130_fd_sc_hd__xor2_1
XFILLER_3_105 VGND VGND VPWR VPWR sky130_fd_sc_hd__decap_6
XFILLER_106_545 VPWR VGND VPWR VGND sky130_ef_sc_hd__decap_12
XPHY_EDGE_ROW_83_Right_83 VGND VGND VPWR VPWR sky130_fd_sc_hd__decap_3
XFILLER_3_149 VPWR VGND VPWR VGND sky130_ef_sc_hd__decap_12
XFILLER_106_589 VPWR VGND VPWR VGND sky130_ef_sc_hd__decap_12
X_10150_ net442 net578 net575 net451 VGND VGND VPWR VPWR _02947_ sky130_fd_sc_hd__a22o_1
X_10081_ net526 net652 net650 net533 VGND VGND VPWR VPWR _02871_ sky130_fd_sc_hd__a22oi_1
XFILLER_102_762 VPWR VGND VPWR VGND sky130_ef_sc_hd__decap_12
XFILLER_59_142 VGND VGND VPWR VPWR sky130_fd_sc_hd__fill_1
XTAP_TAPCELL_ROW_89_1547 VGND VPWR sky130_fd_sc_hd__tapvpwrvgnd_1
XTAP_TAPCELL_ROW_89_1536 VGND VPWR sky130_fd_sc_hd__tapvpwrvgnd_1
XFILLER_87_495 VGND VGND VPWR VPWR sky130_fd_sc_hd__fill_1
XFILLER_90_627 VPWR VGND VPWR VGND sky130_ef_sc_hd__decap_12
X_10983_ _03853_ _03854_ _03681_ _03683_ VGND VGND VPWR VPWR _03857_ sky130_fd_sc_hd__a211o_1
XPHY_EDGE_ROW_92_Right_92 VGND VGND VPWR VPWR sky130_fd_sc_hd__decap_3
XFILLER_15_223 VGND VGND VPWR VPWR sky130_fd_sc_hd__fill_1
XFILLER_16_757 VPWR VGND VPWR VGND sky130_ef_sc_hd__decap_12
X_12722_ _05745_ _05751_ VGND VGND VPWR VPWR _05752_ sky130_fd_sc_hd__xor2_1
XPHY_EDGE_ROW_133_Right_133 VGND VGND VPWR VPWR sky130_fd_sc_hd__decap_3
XFILLER_15_267 VPWR VGND VPWR VGND sky130_ef_sc_hd__decap_12
XFILLER_31_727 VGND VGND VPWR VPWR sky130_fd_sc_hd__fill_1
XFILLER_130_83 VGND VGND VPWR VPWR sky130_fd_sc_hd__fill_1
X_12653_ _05673_ _05674_ VGND VGND VPWR VPWR _05676_ sky130_fd_sc_hd__xor2_1
X_11604_ _04211_ _04533_ VGND VGND VPWR VPWR _04534_ sky130_fd_sc_hd__xnor2_1
XFILLER_30_259 VPWR VGND VPWR VGND sky130_ef_sc_hd__decap_12
X_12584_ _05581_ _05600_ VGND VGND VPWR VPWR _05601_ sky130_fd_sc_hd__xor2_1
XFILLER_11_484 VGND VGND VPWR VPWR sky130_fd_sc_hd__fill_1
XFILLER_11_462 VGND VGND VPWR VPWR sky130_fd_sc_hd__decap_8
X_11535_ _04457_ _04458_ VGND VGND VPWR VPWR _04459_ sky130_fd_sc_hd__nor2_1
XTAP_TAPCELL_ROW_13_479 VGND VPWR sky130_fd_sc_hd__tapvpwrvgnd_1
XFILLER_128_169 VPWR VGND VPWR VGND sky130_ef_sc_hd__decap_12
XFILLER_109_361 VGND VGND VPWR VPWR sky130_fd_sc_hd__fill_1
XFILLER_99_63 VPWR VGND VPWR VGND sky130_ef_sc_hd__decap_12
X_13205_ _06277_ _06278_ VGND VGND VPWR VPWR _06279_ sky130_fd_sc_hd__nor2_1
X_11466_ _04378_ _04382_ VGND VGND VPWR VPWR _04384_ sky130_fd_sc_hd__xor2_1
X_10417_ _03090_ _03092_ VGND VGND VPWR VPWR _03238_ sky130_fd_sc_hd__nand2_1
X_11397_ _04301_ _04307_ VGND VGND VPWR VPWR _04309_ sky130_fd_sc_hd__nand2b_1
X_10348_ _03161_ _03112_ _03163_ VGND VGND VPWR VPWR _03164_ sky130_fd_sc_hd__nor3_2
X_13136_ _06200_ _06201_ VGND VGND VPWR VPWR _06204_ sky130_fd_sc_hd__xnor2_1
XTAP_TAPCELL_ROW_111_1854 VGND VPWR sky130_fd_sc_hd__tapvpwrvgnd_1
XTAP_TAPCELL_ROW_111_1843 VGND VPWR sky130_fd_sc_hd__tapvpwrvgnd_1
X_10279_ net531 net647 VGND VGND VPWR VPWR _03088_ sky130_fd_sc_hd__nand2_1
X_13067_ _06126_ _06127_ VGND VGND VPWR VPWR _06129_ sky130_fd_sc_hd__and2b_1
XFILLER_78_451 VGND VGND VPWR VPWR sky130_fd_sc_hd__decap_8
X_12018_ _04981_ _04983_ VGND VGND VPWR VPWR _00033_ sky130_fd_sc_hd__and2b_1
XFILLER_66_624 VGND VGND VPWR VPWR sky130_fd_sc_hd__fill_2
Xclone221 net333 VGND VGND VPWR VPWR net921 sky130_fd_sc_hd__clkbuf_2
X_07490_ net391 net389 net288 VGND VGND VPWR VPWR _00231_ sky130_fd_sc_hd__o21a_1
XFILLER_0_85 VPWR VGND VPWR VGND sky130_ef_sc_hd__decap_12
XFILLER_34_565 VGND VGND VPWR VPWR sky130_fd_sc_hd__decap_4
XPHY_EDGE_ROW_100_Right_100 VGND VGND VPWR VPWR sky130_fd_sc_hd__decap_3
XFILLER_34_587 VGND VGND VPWR VPWR sky130_fd_sc_hd__fill_1
X_09160_ _01865_ _01882_ _01884_ VGND VGND VPWR VPWR _01885_ sky130_fd_sc_hd__and3_1
XFILLER_9_72 VGND VGND VPWR VPWR sky130_fd_sc_hd__fill_1
XTAP_TAPCELL_ROW_32_744 VGND VPWR sky130_fd_sc_hd__tapvpwrvgnd_1
XFILLER_119_125 VGND VGND VPWR VPWR sky130_fd_sc_hd__decap_6
X_09091_ _01814_ _01815_ VGND VGND VPWR VPWR _01816_ sky130_fd_sc_hd__and2_1
X_08111_ _00643_ _00736_ _00738_ _00545_ VGND VGND VPWR VPWR _00847_ sky130_fd_sc_hd__a31o_1
XFILLER_119_169 VGND VGND VPWR VPWR sky130_fd_sc_hd__fill_1
XFILLER_119_158 VGND VGND VPWR VPWR sky130_fd_sc_hd__decap_8
XFILLER_107_309 VGND VGND VPWR VPWR sky130_fd_sc_hd__fill_1
X_08042_ _00685_ _00687_ VGND VGND VPWR VPWR _00779_ sky130_fd_sc_hd__or2_1
XFILLER_135_629 VPWR VGND VPWR VGND sky130_ef_sc_hd__decap_12
XFILLER_128_681 VPWR VGND VPWR VGND sky130_ef_sc_hd__decap_12
XFILLER_134_139 VGND VGND VPWR VPWR sky130_fd_sc_hd__fill_1
XTAP_TAPCELL_ROW_73_1315 VGND VPWR sky130_fd_sc_hd__tapvpwrvgnd_1
X_09993_ _02778_ _02730_ VGND VGND VPWR VPWR _00057_ sky130_fd_sc_hd__xnor2_1
XFILLER_115_353 VGND VGND VPWR VPWR sky130_fd_sc_hd__fill_1
XFILLER_103_515 VPWR VGND VPWR VGND sky130_ef_sc_hd__decap_12
XFILLER_89_727 VGND VGND VPWR VPWR sky130_fd_sc_hd__fill_1
XFILLER_1_609 VGND VGND VPWR VPWR sky130_fd_sc_hd__decap_6
XFILLER_135_39 VPWR VGND VPWR VGND sky130_ef_sc_hd__decap_12
XFILLER_130_323 VPWR VGND VPWR VGND sky130_ef_sc_hd__decap_12
XFILLER_130_312 VGND VGND VPWR VPWR sky130_fd_sc_hd__fill_1
X_08944_ _01667_ _01668_ _01655_ VGND VGND VPWR VPWR _01670_ sky130_fd_sc_hd__a21o_1
X_08875_ net622 net597 net260 net259 VGND VGND VPWR VPWR _01601_ sky130_fd_sc_hd__and4_1
XFILLER_84_421 VPWR VGND VPWR VGND sky130_ef_sc_hd__decap_12
X_07826_ _00285_ _00421_ _00420_ VGND VGND VPWR VPWR _00565_ sky130_fd_sc_hd__a21boi_1
XFILLER_29_359 VGND VGND VPWR VPWR sky130_fd_sc_hd__decap_8
X_07757_ _06561_ _00495_ VGND VGND VPWR VPWR _00496_ sky130_fd_sc_hd__xnor2_1
XFILLER_72_638 VGND VGND VPWR VPWR sky130_fd_sc_hd__decap_6
X_06708_ _02338_ net532 net252 _02316_ VGND VGND VPWR VPWR _02349_ sky130_fd_sc_hd__and4b_2
XFILLER_72_649 VPWR VGND VPWR VGND sky130_ef_sc_hd__decap_12
XFILLER_25_521 VGND VGND VPWR VPWR sky130_fd_sc_hd__decap_8
X_07688_ _00427_ _00426_ _00272_ _00274_ VGND VGND VPWR VPWR _00428_ sky130_fd_sc_hd__a211o_1
XTAP_TAPCELL_ROW_84_1477 VGND VPWR sky130_fd_sc_hd__tapvpwrvgnd_1
XTAP_TAPCELL_ROW_84_1466 VGND VPWR sky130_fd_sc_hd__tapvpwrvgnd_1
XFILLER_52_362 VGND VGND VPWR VPWR sky130_fd_sc_hd__fill_2
X_09427_ _02026_ _02028_ _02029_ _02027_ _01867_ VGND VGND VPWR VPWR _02165_ sky130_fd_sc_hd__o32a_2
XFILLER_40_513 VPWR VGND VPWR VGND sky130_ef_sc_hd__decap_12
X_09358_ net544 net258 net256 net572 VGND VGND VPWR VPWR _02089_ sky130_fd_sc_hd__a22oi_1
X_08309_ _00458_ _01001_ _01002_ VGND VGND VPWR VPWR _01043_ sky130_fd_sc_hd__o21ai_1
XFILLER_60_46 VGND VGND VPWR VPWR sky130_fd_sc_hd__decap_8
XFILLER_60_24 VGND VGND VPWR VPWR sky130_fd_sc_hd__decap_4
X_09289_ _02012_ _02013_ VGND VGND VPWR VPWR _02014_ sky130_fd_sc_hd__nand2_1
XFILLER_60_79 VGND VGND VPWR VPWR sky130_fd_sc_hd__decap_4
XTAP_TAPCELL_ROW_10_438 VGND VPWR sky130_fd_sc_hd__tapvpwrvgnd_1
X_11320_ _04126_ _04132_ _04131_ VGND VGND VPWR VPWR _04225_ sky130_fd_sc_hd__a21oi_1
XFILLER_119_692 VGND VGND VPWR VPWR sky130_fd_sc_hd__decap_8
XFILLER_114_3 VPWR VGND VPWR VGND sky130_ef_sc_hd__decap_12
XFILLER_118_180 VGND VGND VPWR VPWR sky130_fd_sc_hd__fill_1
XFILLER_106_320 VGND VGND VPWR VPWR sky130_fd_sc_hd__fill_2
X_11251_ _04148_ _04149_ VGND VGND VPWR VPWR _04150_ sky130_fd_sc_hd__nor2_1
XFILLER_133_161 VGND VGND VPWR VPWR sky130_fd_sc_hd__decap_6
XFILLER_109_84 VGND VGND VPWR VPWR sky130_fd_sc_hd__fill_1
X_10202_ _02995_ _03003_ _02996_ VGND VGND VPWR VPWR _03004_ sky130_fd_sc_hd__and3_1
XFILLER_4_469 VGND VGND VPWR VPWR sky130_fd_sc_hd__decap_6
X_11182_ _04071_ _04072_ VGND VGND VPWR VPWR _04074_ sky130_fd_sc_hd__xnor2_1
X_10133_ _02872_ _02926_ VGND VGND VPWR VPWR _02928_ sky130_fd_sc_hd__nor2_1
X_10064_ _02806_ _02851_ VGND VGND VPWR VPWR _02853_ sky130_fd_sc_hd__xor2_1
XFILLER_48_624 VGND VGND VPWR VPWR sky130_fd_sc_hd__fill_1
XFILLER_0_697 VGND VGND VPWR VPWR sky130_fd_sc_hd__decap_3
XFILLER_48_668 VPWR VGND VPWR VGND sky130_ef_sc_hd__decap_12
XTAP_TAPCELL_ROW_126_2061 VGND VPWR sky130_fd_sc_hd__tapvpwrvgnd_1
XFILLER_18_70 VPWR VGND VPWR VGND sky130_ef_sc_hd__decap_12
XFILLER_90_446 VGND VGND VPWR VPWR sky130_fd_sc_hd__fill_1
XFILLER_63_649 VPWR VGND VPWR VGND sky130_ef_sc_hd__decap_12
XFILLER_62_137 VGND VGND VPWR VPWR sky130_fd_sc_hd__decap_3
XTAP_TAPCELL_ROW_18_549 VGND VPWR sky130_fd_sc_hd__tapvpwrvgnd_1
X_10966_ _03835_ _03836_ _03659_ _03661_ VGND VGND VPWR VPWR _03838_ sky130_fd_sc_hd__a211o_1
XFILLER_43_384 VGND VGND VPWR VPWR sky130_fd_sc_hd__decap_8
X_12705_ _05728_ _05731_ VGND VGND VPWR VPWR _05733_ sky130_fd_sc_hd__xnor2_1
XFILLER_31_535 VPWR VGND VPWR VGND sky130_ef_sc_hd__decap_12
X_10897_ net458 _03586_ _03588_ _03589_ VGND VGND VPWR VPWR _03763_ sky130_fd_sc_hd__a2bb2o_1
X_12636_ _05656_ _05657_ VGND VGND VPWR VPWR _05658_ sky130_fd_sc_hd__nand2_1
XFILLER_129_412 VGND VGND VPWR VPWR sky130_fd_sc_hd__decap_4
XFILLER_86_7 VPWR VGND VPWR VGND sky130_ef_sc_hd__decap_12
XFILLER_11_281 VGND VGND VPWR VPWR sky130_fd_sc_hd__decap_8
XFILLER_12_793 VPWR VGND VPWR VGND sky130_ef_sc_hd__decap_12
X_12567_ _05424_ _05432_ _05431_ VGND VGND VPWR VPWR _05583_ sky130_fd_sc_hd__a21o_1
X_11518_ _04314_ _04326_ _04312_ VGND VGND VPWR VPWR _04441_ sky130_fd_sc_hd__a21oi_1
X_12498_ _02055_ net640 net285 net81 VGND VGND VPWR VPWR _05507_ sky130_fd_sc_hd__and4_1
XFILLER_116_139 VGND VGND VPWR VPWR sky130_fd_sc_hd__fill_1
X_11449_ net565 net540 net272 net89 VGND VGND VPWR VPWR _04366_ sky130_fd_sc_hd__and4b_1
XFILLER_125_673 VPWR VGND VPWR VGND sky130_ef_sc_hd__decap_12
XTAP_TAPCELL_ROW_55_1067 VGND VPWR sky130_fd_sc_hd__tapvpwrvgnd_1
X_13119_ _06185_ _06179_ VGND VGND VPWR VPWR _06186_ sky130_fd_sc_hd__and2b_1
X_06990_ net685 net506 net683 net522 VGND VGND VPWR VPWR _05418_ sky130_fd_sc_hd__a22oi_2
XFILLER_98_579 VGND VGND VPWR VPWR sky130_fd_sc_hd__decap_8
XFILLER_79_782 VGND VGND VPWR VPWR sky130_fd_sc_hd__fill_2
X_08660_ _01366_ _01386_ VGND VGND VPWR VPWR _01388_ sky130_fd_sc_hd__and2b_1
XFILLER_39_646 VGND VGND VPWR VPWR sky130_fd_sc_hd__fill_2
XFILLER_94_785 VGND VGND VPWR VPWR sky130_fd_sc_hd__fill_2
X_07611_ _00344_ _00350_ VGND VGND VPWR VPWR _00351_ sky130_fd_sc_hd__xor2_1
XTAP_TAPCELL_ROW_37_814 VGND VPWR sky130_fd_sc_hd__tapvpwrvgnd_1
X_08591_ _01312_ _01318_ _01319_ VGND VGND VPWR VPWR _01320_ sky130_fd_sc_hd__nand3_2
XFILLER_81_446 VGND VGND VPWR VPWR sky130_fd_sc_hd__fill_2
XFILLER_19_381 VGND VGND VPWR VPWR sky130_fd_sc_hd__decap_8
X_07542_ _06671_ _00138_ _00137_ VGND VGND VPWR VPWR _00282_ sky130_fd_sc_hd__o21a_1
XFILLER_81_479 VPWR VGND VPWR VGND sky130_ef_sc_hd__decap_12
X_07473_ _00205_ _00212_ _00213_ VGND VGND VPWR VPWR _00214_ sky130_fd_sc_hd__nand3_1
XFILLER_62_682 VGND VGND VPWR VPWR sky130_fd_sc_hd__decap_4
XFILLER_22_502 VGND VGND VPWR VPWR sky130_fd_sc_hd__fill_2
X_09212_ _01932_ _01935_ VGND VGND VPWR VPWR _01936_ sky130_fd_sc_hd__nand2_1
XPHY_EDGE_ROW_101_Left_238 VGND VGND VPWR VPWR sky130_fd_sc_hd__decap_3
X_09143_ net314 net60 VGND VGND VPWR VPWR _01868_ sky130_fd_sc_hd__and2_1
X_09074_ _01777_ _01797_ VGND VGND VPWR VPWR _01799_ sky130_fd_sc_hd__xnor2_1
XFILLER_107_106 VGND VGND VPWR VPWR sky130_fd_sc_hd__decap_6
XFILLER_116_640 VGND VGND VPWR VPWR sky130_fd_sc_hd__decap_4
X_08025_ _00187_ _00761_ VGND VGND VPWR VPWR _00762_ sky130_fd_sc_hd__xnor2_1
XFILLER_1_417 VPWR VGND VPWR VGND sky130_ef_sc_hd__decap_12
XFILLER_116_695 VGND VGND VPWR VPWR sky130_fd_sc_hd__decap_4
XFILLER_89_557 VGND VGND VPWR VPWR sky130_fd_sc_hd__decap_3
XFILLER_131_665 VGND VGND VPWR VPWR sky130_fd_sc_hd__decap_6
XFILLER_130_153 VPWR VGND VPWR VGND sky130_ef_sc_hd__decap_12
X_09976_ _02111_ _02691_ _02759_ VGND VGND VPWR VPWR _02760_ sky130_fd_sc_hd__o21ai_1
XFILLER_103_367 VPWR VGND VPWR VGND sky130_ef_sc_hd__decap_12
XPHY_EDGE_ROW_110_Left_247 VGND VGND VPWR VPWR sky130_fd_sc_hd__decap_3
X_08927_ _01650_ _01651_ VGND VGND VPWR VPWR _01653_ sky130_fd_sc_hd__or2_1
XFILLER_76_229 VGND VGND VPWR VPWR sky130_fd_sc_hd__decap_3
XFILLER_130_197 VPWR VGND VPWR VGND sky130_ef_sc_hd__decap_12
XFILLER_97_590 VGND VGND VPWR VPWR sky130_fd_sc_hd__fill_1
X_08858_ net723 _01447_ _01583_ _01584_ VGND VGND VPWR VPWR _01585_ sky130_fd_sc_hd__and4_1
XFILLER_85_763 VPWR VGND VPWR VGND sky130_ef_sc_hd__decap_12
XFILLER_69_281 VGND VGND VPWR VPWR sky130_fd_sc_hd__decap_6
XFILLER_84_251 VGND VGND VPWR VPWR sky130_fd_sc_hd__fill_1
X_07809_ _00541_ _00547_ VGND VGND VPWR VPWR _00548_ sky130_fd_sc_hd__xnor2_1
XFILLER_72_413 VGND VGND VPWR VPWR sky130_fd_sc_hd__decap_6
XFILLER_44_104 VGND VGND VPWR VPWR sky130_fd_sc_hd__fill_2
X_08789_ _01403_ _01514_ VGND VGND VPWR VPWR _01516_ sky130_fd_sc_hd__or2_1
XFILLER_53_660 VGND VGND VPWR VPWR sky130_fd_sc_hd__fill_2
X_10820_ _03511_ _03676_ _03678_ VGND VGND VPWR VPWR _03679_ sky130_fd_sc_hd__and3_4
XTAP_TAPCELL_ROW_15_508 VGND VPWR sky130_fd_sc_hd__tapvpwrvgnd_1
XFILLER_111_74 VPWR VGND VPWR VGND sky130_ef_sc_hd__decap_12
X_10751_ _03566_ _03602_ VGND VGND VPWR VPWR _03603_ sky130_fd_sc_hd__xor2_1
XFILLER_52_181 VGND VGND VPWR VPWR sky130_fd_sc_hd__decap_8
XFILLER_40_343 VGND VGND VPWR VPWR sky130_fd_sc_hd__decap_8
X_10682_ net565 net281 _03352_ _03351_ VGND VGND VPWR VPWR _03527_ sky130_fd_sc_hd__a31o_1
X_12421_ _05420_ _05421_ _05239_ _05241_ VGND VGND VPWR VPWR _05423_ sky130_fd_sc_hd__o211a_1
XFILLER_40_398 VPWR VGND VPWR VGND sky130_ef_sc_hd__decap_12
XTAP_TAPCELL_ROW_97_1657 VGND VPWR sky130_fd_sc_hd__tapvpwrvgnd_1
XTAP_TAPCELL_ROW_97_1646 VGND VPWR sky130_fd_sc_hd__tapvpwrvgnd_1
X_12352_ _05346_ _05339_ VGND VGND VPWR VPWR _05347_ sky130_fd_sc_hd__and2b_1
XFILLER_4_233 VPWR VGND VPWR VGND sky130_ef_sc_hd__decap_12
X_11303_ _04125_ _04137_ _04136_ VGND VGND VPWR VPWR _04206_ sky130_fd_sc_hd__a21o_1
X_12283_ _05270_ _05271_ VGND VGND VPWR VPWR _05272_ sky130_fd_sc_hd__nor2_1
XFILLER_107_673 VGND VGND VPWR VPWR sky130_fd_sc_hd__decap_8
X_11234_ _04127_ _04130_ VGND VGND VPWR VPWR _04131_ sky130_fd_sc_hd__and2b_1
XFILLER_122_632 VGND VGND VPWR VPWR sky130_fd_sc_hd__decap_4
XFILLER_106_172 VPWR VGND VPWR VGND sky130_ef_sc_hd__decap_12
XFILLER_4_277 VPWR VGND VPWR VGND sky130_ef_sc_hd__decap_12
XFILLER_110_805 VGND VGND VPWR VPWR sky130_fd_sc_hd__decap_6
X_11165_ _04047_ _04054_ VGND VGND VPWR VPWR _04055_ sky130_fd_sc_hd__xnor2_1
X_10116_ _02860_ _02905_ _02907_ VGND VGND VPWR VPWR _02909_ sky130_fd_sc_hd__and3_1
X_11096_ net400 net574 VGND VGND VPWR VPWR _03980_ sky130_fd_sc_hd__and2_1
XFILLER_96_97 VGND VGND VPWR VPWR sky130_fd_sc_hd__fill_1
X_10047_ net467 net459 net578 net575 VGND VGND VPWR VPWR _02835_ sky130_fd_sc_hd__and4_1
XFILLER_48_432 VGND VGND VPWR VPWR sky130_fd_sc_hd__fill_1
XFILLER_63_413 VGND VGND VPWR VPWR sky130_fd_sc_hd__fill_2
XFILLER_29_91 VGND VGND VPWR VPWR sky130_fd_sc_hd__decap_4
XFILLER_36_616 VPWR VGND VPWR VGND sky130_ef_sc_hd__decap_12
XFILLER_91_755 VGND VGND VPWR VPWR sky130_fd_sc_hd__fill_2
X_11998_ _04802_ _04799_ net774 _04961_ VGND VGND VPWR VPWR _04962_ sky130_fd_sc_hd__a211oi_4
XFILLER_16_351 VGND VGND VPWR VPWR sky130_fd_sc_hd__decap_8
XTAP_TAPCELL_ROW_106_1775 VGND VPWR sky130_fd_sc_hd__tapvpwrvgnd_1
XFILLER_16_362 VGND VGND VPWR VPWR sky130_fd_sc_hd__fill_2
X_10949_ _03432_ _03627_ _03629_ VGND VGND VPWR VPWR _03820_ sky130_fd_sc_hd__o21bai_2
XFILLER_31_332 VGND VGND VPWR VPWR sky130_fd_sc_hd__decap_4
XFILLER_31_387 VGND VGND VPWR VPWR sky130_fd_sc_hd__decap_4
XTAP_TAPCELL_ROW_42_883 VGND VPWR sky130_fd_sc_hd__tapvpwrvgnd_1
XFILLER_77_3 VGND VGND VPWR VPWR sky130_fd_sc_hd__fill_2
X_12619_ _05636_ _05638_ _05458_ _05460_ VGND VGND VPWR VPWR _05640_ sky130_fd_sc_hd__a211o_1
XFILLER_8_550 VPWR VGND VPWR VGND sky130_ef_sc_hd__decap_12
XFILLER_125_481 VGND VGND VPWR VPWR sky130_fd_sc_hd__fill_1
X_09830_ _02600_ _02601_ VGND VGND VPWR VPWR _02603_ sky130_fd_sc_hd__xor2_1
XFILLER_101_805 VGND VGND VPWR VPWR sky130_fd_sc_hd__decap_3
Xfanout518 net519 VGND VGND VPWR VPWR net518 sky130_fd_sc_hd__clkbuf_2
XFILLER_59_708 VGND VGND VPWR VPWR sky130_fd_sc_hd__decap_8
Xfanout507 net511 VGND VGND VPWR VPWR net507 sky130_fd_sc_hd__buf_2
Xfanout529 net530 VGND VGND VPWR VPWR net529 sky130_fd_sc_hd__clkbuf_2
XFILLER_112_175 VPWR VGND VPWR VGND sky130_ef_sc_hd__decap_12
X_06973_ _03390_ _03412_ VGND VGND VPWR VPWR _05232_ sky130_fd_sc_hd__nor2_1
X_09761_ net406 net537 _02403_ VGND VGND VPWR VPWR _02527_ sky130_fd_sc_hd__a21oi_1
X_08712_ _01438_ _01437_ net703 _01302_ VGND VGND VPWR VPWR _01440_ sky130_fd_sc_hd__a211oi_4
XFILLER_132_29 VPWR VGND VPWR VGND sky130_ef_sc_hd__decap_12
X_09692_ net573 net253 _02197_ net596 VGND VGND VPWR VPWR _02452_ sky130_fd_sc_hd__o2bb2a_1
XFILLER_67_774 VGND VGND VPWR VPWR sky130_fd_sc_hd__decap_4
Xrebuffer12 _02983_ VGND VGND VPWR VPWR net712 sky130_fd_sc_hd__dlymetal6s2s_1
X_08643_ _01368_ _01369_ _01370_ VGND VGND VPWR VPWR _01371_ sky130_fd_sc_hd__or3_1
Xrebuffer34 _01575_ VGND VGND VPWR VPWR net734 sky130_fd_sc_hd__buf_1
Xrebuffer23 _01325_ VGND VGND VPWR VPWR net723 sky130_fd_sc_hd__dlygate4sd1_1
XTAP_TAPCELL_ROW_68_1247 VGND VPWR sky130_fd_sc_hd__tapvpwrvgnd_1
Xrebuffer45 _03682_ VGND VGND VPWR VPWR net745 sky130_fd_sc_hd__dlymetal6s4s_1
XFILLER_26_137 VGND VGND VPWR VPWR sky130_fd_sc_hd__decap_3
XFILLER_39_498 VGND VGND VPWR VPWR sky130_fd_sc_hd__decap_6
X_08574_ _01231_ _01300_ _01301_ VGND VGND VPWR VPWR _01303_ sky130_fd_sc_hd__or3_4
Xrebuffer78 _04957_ VGND VGND VPWR VPWR net778 sky130_fd_sc_hd__dlygate4sd1_1
Xrebuffer67 net377 VGND VGND VPWR VPWR net767 sky130_fd_sc_hd__buf_2
X_07525_ _00261_ _00263_ _00164_ VGND VGND VPWR VPWR _00266_ sky130_fd_sc_hd__a21o_1
XTAP_TAPCELL_ROW_81_1425 VGND VPWR sky130_fd_sc_hd__tapvpwrvgnd_1
XFILLER_41_129 VPWR VGND VPWR VGND sky130_ef_sc_hd__decap_12
XFILLER_50_641 VGND VGND VPWR VPWR sky130_fd_sc_hd__decap_3
XFILLER_34_192 VGND VGND VPWR VPWR sky130_fd_sc_hd__decap_4
X_07456_ _00166_ _00196_ VGND VGND VPWR VPWR _00197_ sky130_fd_sc_hd__and2b_1
X_07387_ net642 net71 VGND VGND VPWR VPWR _00128_ sky130_fd_sc_hd__nand2_1
Xrebuffer102 net936 VGND VGND VPWR VPWR net802 sky130_fd_sc_hd__dlygate4sd1_1
XFILLER_41_48 VGND VGND VPWR VPWR sky130_fd_sc_hd__decap_8
XFILLER_136_735 VPWR VGND VPWR VGND sky130_ef_sc_hd__decap_12
XFILLER_136_713 VGND VGND VPWR VPWR sky130_fd_sc_hd__decap_4
Xrebuffer146 _01897_ VGND VGND VPWR VPWR net846 sky130_fd_sc_hd__buf_6
Xrebuffer135 _06484_ VGND VGND VPWR VPWR net835 sky130_fd_sc_hd__buf_1
X_09126_ _01843_ _01849_ _01850_ VGND VGND VPWR VPWR _01851_ sky130_fd_sc_hd__nand3_1
Xrebuffer124 net430 VGND VGND VPWR VPWR net824 sky130_fd_sc_hd__buf_4
XFILLER_136_757 VPWR VGND VPWR VGND sky130_ef_sc_hd__decap_12
XFILLER_135_223 VGND VGND VPWR VPWR sky130_fd_sc_hd__fill_1
XFILLER_108_459 VGND VGND VPWR VPWR sky130_fd_sc_hd__decap_8
X_09057_ net544 net264 net262 VGND VGND VPWR VPWR _01782_ sky130_fd_sc_hd__nand3_1
XTAP_TAPCELL_ROW_20_577 VGND VPWR sky130_fd_sc_hd__tapvpwrvgnd_1
X_08008_ _00639_ _00653_ _00638_ VGND VGND VPWR VPWR _00745_ sky130_fd_sc_hd__a21oi_1
XTAP_TAPCELL_ROW_79_1398 VGND VPWR sky130_fd_sc_hd__tapvpwrvgnd_1
XFILLER_116_481 VGND VGND VPWR VPWR sky130_fd_sc_hd__fill_1
XFILLER_1_225 VPWR VGND VPWR VGND sky130_ef_sc_hd__decap_12
XFILLER_2_737 VPWR VGND VPWR VGND sky130_ef_sc_hd__decap_12
XFILLER_104_665 VGND VGND VPWR VPWR sky130_fd_sc_hd__fill_1
XTAP_TAPCELL_ROW_92_1587 VGND VPWR sky130_fd_sc_hd__tapvpwrvgnd_1
XTAP_TAPCELL_ROW_92_1576 VGND VPWR sky130_fd_sc_hd__tapvpwrvgnd_1
XFILLER_77_505 VPWR VGND VPWR VGND sky130_ef_sc_hd__decap_12
XFILLER_131_473 VPWR VGND VPWR VGND sky130_ef_sc_hd__decap_12
X_09959_ _01676_ _02513_ _02632_ VGND VGND VPWR VPWR _02742_ sky130_fd_sc_hd__or3_1
XFILLER_106_85 VGND VGND VPWR VPWR sky130_fd_sc_hd__decap_4
XFILLER_66_45 VGND VGND VPWR VPWR sky130_fd_sc_hd__decap_8
XFILLER_92_519 VGND VGND VPWR VPWR sky130_fd_sc_hd__fill_1
XFILLER_73_711 VPWR VGND VPWR VGND sky130_ef_sc_hd__decap_12
X_12970_ _06016_ _06022_ VGND VGND VPWR VPWR _06023_ sky130_fd_sc_hd__and2b_1
XTAP_TAPCELL_ROW_123_2020 VGND VPWR sky130_fd_sc_hd__tapvpwrvgnd_1
XFILLER_85_593 VGND VGND VPWR VPWR sky130_fd_sc_hd__decap_3
X_11921_ _04695_ _04698_ _04876_ VGND VGND VPWR VPWR _04877_ sky130_fd_sc_hd__or3_1
XFILLER_73_777 VGND VGND VPWR VPWR sky130_fd_sc_hd__decap_6
X_11852_ _04798_ _04759_ _04800_ VGND VGND VPWR VPWR _04802_ sky130_fd_sc_hd__or3_4
XFILLER_17_159 VGND VGND VPWR VPWR sky130_fd_sc_hd__decap_8
XTAP_TAPCELL_ROW_0_280 VGND VPWR sky130_fd_sc_hd__tapvpwrvgnd_1
XFILLER_26_693 VGND VGND VPWR VPWR sky130_fd_sc_hd__decap_6
XTAP_TAPCELL_ROW_28_688 VGND VPWR sky130_fd_sc_hd__tapvpwrvgnd_1
X_10803_ _03657_ _03658_ _03473_ _03475_ VGND VGND VPWR VPWR _03660_ sky130_fd_sc_hd__a211oi_2
X_11783_ _04669_ _04724_ VGND VGND VPWR VPWR _04726_ sky130_fd_sc_hd__nor2_1
XTAP_TAPCELL_ROW_0_291 VGND VPWR sky130_fd_sc_hd__tapvpwrvgnd_1
XFILLER_25_181 VPWR VGND VPWR VGND sky130_ef_sc_hd__decap_12
XFILLER_9_325 VGND VGND VPWR VPWR sky130_fd_sc_hd__decap_8
X_10734_ net417 net575 _03430_ _03428_ VGND VGND VPWR VPWR _03584_ sky130_fd_sc_hd__a31o_1
X_10665_ _03381_ _03383_ _03507_ VGND VGND VPWR VPWR _03508_ sky130_fd_sc_hd__a21oi_2
XFILLER_40_195 VGND VGND VPWR VPWR sky130_fd_sc_hd__fill_1
X_13384_ clknet_3_5__leaf_clk _00030_ _00094_ VGND VGND VPWR VPWR net183 sky130_fd_sc_hd__dfrtp_1
X_12404_ net437 net446 net586 net584 VGND VGND VPWR VPWR _05404_ sky130_fd_sc_hd__and4_1
X_10596_ net512 net425 net345 net56 VGND VGND VPWR VPWR _03433_ sky130_fd_sc_hd__and4_1
X_12335_ _05325_ _05326_ VGND VGND VPWR VPWR _05328_ sky130_fd_sc_hd__xnor2_1
XTAP_TAPCELL_ROW_134_2171 VGND VPWR sky130_fd_sc_hd__tapvpwrvgnd_1
XFILLER_5_553 VGND VGND VPWR VPWR sky130_fd_sc_hd__decap_6
XFILLER_31_92 VPWR VGND VPWR VGND sky130_ef_sc_hd__decap_12
XFILLER_114_429 VGND VGND VPWR VPWR sky130_fd_sc_hd__fill_2
XFILLER_5_597 VPWR VGND VPWR VGND sky130_ef_sc_hd__decap_12
X_12266_ _05248_ _05251_ _05252_ VGND VGND VPWR VPWR _05253_ sky130_fd_sc_hd__and3_1
XFILLER_96_803 VGND VGND VPWR VPWR sky130_fd_sc_hd__fill_1
X_12197_ _05173_ _05174_ VGND VGND VPWR VPWR _05178_ sky130_fd_sc_hd__xor2_1
X_11217_ _04110_ _04111_ VGND VGND VPWR VPWR _04113_ sky130_fd_sc_hd__nand2b_1
XFILLER_122_462 VGND VGND VPWR VPWR sky130_fd_sc_hd__fill_1
XFILLER_110_602 VGND VGND VPWR VPWR sky130_fd_sc_hd__decap_8
XFILLER_68_538 VGND VGND VPWR VPWR sky130_fd_sc_hd__fill_2
XTAP_TAPCELL_ROW_52_1026 VGND VPWR sky130_fd_sc_hd__tapvpwrvgnd_1
X_11148_ _04036_ VGND VGND VPWR VPWR _04037_ sky130_fd_sc_hd__inv_2
XFILLER_95_335 VGND VGND VPWR VPWR sky130_fd_sc_hd__fill_1
XTAP_TAPCELL_ROW_108_1804 VGND VPWR sky130_fd_sc_hd__tapvpwrvgnd_1
XFILLER_49_785 VGND VGND VPWR VPWR sky130_fd_sc_hd__decap_3
X_11079_ _03426_ _03961_ VGND VGND VPWR VPWR _03962_ sky130_fd_sc_hd__xnor2_1
XFILLER_36_402 VGND VGND VPWR VPWR sky130_fd_sc_hd__decap_4
XFILLER_64_744 VGND VGND VPWR VPWR sky130_fd_sc_hd__fill_1
XFILLER_64_755 VGND VGND VPWR VPWR sky130_fd_sc_hd__fill_1
XTAP_TAPCELL_ROW_47_953 VGND VPWR sky130_fd_sc_hd__tapvpwrvgnd_1
X_07310_ _06597_ _06598_ _06599_ VGND VGND VPWR VPWR _06601_ sky130_fd_sc_hd__a21o_1
X_08290_ _01020_ _01024_ VGND VGND VPWR VPWR _01025_ sky130_fd_sc_hd__nand2b_1
XTAP_TAPCELL_ROW_63_1177 VGND VPWR sky130_fd_sc_hd__tapvpwrvgnd_1
X_07241_ net505 net102 net680 net521 VGND VGND VPWR VPWR _06532_ sky130_fd_sc_hd__a22oi_1
X_07172_ net36 net816 VGND VGND VPWR VPWR _06464_ sky130_fd_sc_hd__nand2_1
XFILLER_118_757 VPWR VGND VPWR VGND sky130_ef_sc_hd__decap_12
XTAP_TAPCELL_ROW_119_1966 VGND VPWR sky130_fd_sc_hd__tapvpwrvgnd_1
XTAP_TAPCELL_ROW_119_1955 VGND VPWR sky130_fd_sc_hd__tapvpwrvgnd_1
XFILLER_133_727 VGND VGND VPWR VPWR sky130_fd_sc_hd__fill_1
Xfanout304 net72 VGND VGND VPWR VPWR net304 sky130_fd_sc_hd__dlymetal6s2s_1
X_09813_ _02453_ _02459_ _02456_ VGND VGND VPWR VPWR _02584_ sky130_fd_sc_hd__o21a_1
XFILLER_98_151 VGND VGND VPWR VPWR sky130_fd_sc_hd__decap_6
Xfanout326 net63 VGND VGND VPWR VPWR net326 sky130_fd_sc_hd__buf_2
Xfanout315 net7 VGND VGND VPWR VPWR net315 sky130_fd_sc_hd__buf_6
Xfanout348 net53 VGND VGND VPWR VPWR net348 sky130_fd_sc_hd__buf_2
Xfanout337 net6 VGND VGND VPWR VPWR net337 sky130_fd_sc_hd__buf_6
XFILLER_101_657 VGND VGND VPWR VPWR sky130_fd_sc_hd__fill_1
Xfanout359 net5 VGND VGND VPWR VPWR net359 sky130_fd_sc_hd__buf_8
X_06956_ _03194_ _03216_ _05014_ _04982_ _04949_ VGND VGND VPWR VPWR _05047_ sky130_fd_sc_hd__a2111o_1
X_09744_ net248 _02378_ VGND VGND VPWR VPWR _02508_ sky130_fd_sc_hd__nand2_1
XFILLER_55_700 VPWR VGND VPWR VGND sky130_ef_sc_hd__decap_12
X_09675_ _02429_ _02432_ VGND VGND VPWR VPWR _02433_ sky130_fd_sc_hd__xor2_1
X_06887_ _04265_ _04276_ _04254_ VGND VGND VPWR VPWR _04297_ sky130_fd_sc_hd__a21bo_1
XFILLER_54_221 VGND VGND VPWR VPWR sky130_fd_sc_hd__decap_8
XFILLER_27_413 VGND VGND VPWR VPWR sky130_fd_sc_hd__fill_2
XFILLER_36_26 VGND VGND VPWR VPWR sky130_fd_sc_hd__fill_2
X_08626_ _01180_ _01182_ VGND VGND VPWR VPWR _01354_ sky130_fd_sc_hd__or2_1
XFILLER_82_563 VGND VGND VPWR VPWR sky130_fd_sc_hd__fill_1
XFILLER_36_59 VGND VGND VPWR VPWR sky130_fd_sc_hd__decap_8
XFILLER_70_736 VGND VGND VPWR VPWR sky130_fd_sc_hd__fill_2
XFILLER_14_118 VGND VGND VPWR VPWR sky130_fd_sc_hd__decap_4
XFILLER_42_416 VGND VGND VPWR VPWR sky130_fd_sc_hd__decap_4
X_08557_ _01284_ _01283_ _01282_ VGND VGND VPWR VPWR _01286_ sky130_fd_sc_hd__a21bo_1
XTAP_TAPCELL_ROW_25_647 VGND VPWR sky130_fd_sc_hd__tapvpwrvgnd_1
X_08488_ _01167_ _01215_ VGND VGND VPWR VPWR _01217_ sky130_fd_sc_hd__nor2_1
X_07508_ _00228_ _00245_ _00247_ VGND VGND VPWR VPWR _00249_ sky130_fd_sc_hd__nand3_2
XFILLER_23_685 VPWR VGND VPWR VGND sky130_ef_sc_hd__decap_12
X_07439_ _00171_ _00179_ VGND VGND VPWR VPWR _00180_ sky130_fd_sc_hd__xnor2_1
XFILLER_22_162 VPWR VGND VPWR VGND sky130_ef_sc_hd__decap_12
X_10450_ _03130_ _03272_ _03273_ VGND VGND VPWR VPWR _03274_ sky130_fd_sc_hd__and3_1
XTAP_TAPCELL_ROW_94_1605 VGND VPWR sky130_fd_sc_hd__tapvpwrvgnd_1
X_09109_ _01818_ _01833_ VGND VGND VPWR VPWR _01834_ sky130_fd_sc_hd__xnor2_1
XTAP_TAPCELL_ROW_94_1616 VGND VPWR sky130_fd_sc_hd__tapvpwrvgnd_1
X_10381_ _03197_ _03198_ VGND VGND VPWR VPWR _03199_ sky130_fd_sc_hd__nand2_1
XFILLER_124_749 VGND VGND VPWR VPWR sky130_fd_sc_hd__decap_6
X_12120_ _05091_ _05092_ _05089_ VGND VGND VPWR VPWR _05094_ sky130_fd_sc_hd__o21ai_1
XFILLER_2_501 VPWR VGND VPWR VGND sky130_ef_sc_hd__decap_12
XFILLER_123_248 VGND VGND VPWR VPWR sky130_fd_sc_hd__decap_8
XFILLER_123_237 VGND VGND VPWR VPWR sky130_fd_sc_hd__decap_6
XFILLER_117_51 VGND VGND VPWR VPWR sky130_fd_sc_hd__decap_4
XFILLER_104_440 VPWR VGND VPWR VGND sky130_ef_sc_hd__decap_12
X_12051_ _05015_ _05017_ VGND VGND VPWR VPWR _05019_ sky130_fd_sc_hd__and2b_1
XFILLER_7_3 VPWR VGND VPWR VGND sky130_ef_sc_hd__decap_12
XFILLER_2_545 VPWR VGND VPWR VGND sky130_ef_sc_hd__decap_12
XFILLER_132_793 VPWR VGND VPWR VGND sky130_ef_sc_hd__decap_12
XFILLER_2_589 VPWR VGND VPWR VGND sky130_ef_sc_hd__decap_12
X_11002_ _03874_ _03875_ VGND VGND VPWR VPWR _03877_ sky130_fd_sc_hd__xor2_1
XFILLER_131_281 VPWR VGND VPWR VGND sky130_ef_sc_hd__decap_12
XTAP_TAPCELL_ROW_5_361 VGND VPWR sky130_fd_sc_hd__tapvpwrvgnd_1
X_12953_ _06002_ _06003_ VGND VGND VPWR VPWR _06004_ sky130_fd_sc_hd__and2b_1
X_11904_ net666 net297 net295 net691 VGND VGND VPWR VPWR _04858_ sky130_fd_sc_hd__a22oi_1
XFILLER_45_254 VGND VGND VPWR VPWR sky130_fd_sc_hd__decap_6
XFILLER_18_446 VGND VGND VPWR VPWR sky130_fd_sc_hd__decap_8
XFILLER_45_276 VGND VGND VPWR VPWR sky130_fd_sc_hd__decap_4
XTAP_TAPCELL_ROW_44_912 VGND VPWR sky130_fd_sc_hd__tapvpwrvgnd_1
X_12884_ _05924_ _05927_ VGND VGND VPWR VPWR _05929_ sky130_fd_sc_hd__xnor2_1
XTAP_TAPCELL_ROW_103_1734 VGND VPWR sky130_fd_sc_hd__tapvpwrvgnd_1
X_11835_ net790 _04781_ _04780_ VGND VGND VPWR VPWR _04783_ sky130_fd_sc_hd__a21oi_1
X_11766_ _04676_ _04705_ VGND VGND VPWR VPWR _04707_ sky130_fd_sc_hd__or2_1
XFILLER_13_140 VPWR VGND VPWR VGND sky130_ef_sc_hd__decap_12
XTAP_TAPCELL_ROW_136_2211 VGND VPWR sky130_fd_sc_hd__tapvpwrvgnd_1
XTAP_TAPCELL_ROW_136_2200 VGND VPWR sky130_fd_sc_hd__tapvpwrvgnd_1
X_10717_ _03416_ _03418_ VGND VGND VPWR VPWR _03566_ sky130_fd_sc_hd__nand2_1
XFILLER_9_111 VGND VGND VPWR VPWR sky130_fd_sc_hd__fill_1
XFILLER_41_482 VGND VGND VPWR VPWR sky130_fd_sc_hd__fill_1
X_11697_ _04630_ _04631_ VGND VGND VPWR VPWR _04633_ sky130_fd_sc_hd__nor2_1
XFILLER_42_80 VGND VGND VPWR VPWR sky130_fd_sc_hd__decap_4
Xrebuffer3 _01300_ VGND VGND VPWR VPWR net703 sky130_fd_sc_hd__dlygate4sd1_1
X_10648_ _03487_ _03488_ VGND VGND VPWR VPWR _03491_ sky130_fd_sc_hd__xor2_1
X_13367_ clknet_3_2__leaf_clk _00042_ _00077_ VGND VGND VPWR VPWR net166 sky130_fd_sc_hd__dfrtp_1
X_10579_ _03244_ _03414_ VGND VGND VPWR VPWR _03415_ sky130_fd_sc_hd__or2_1
X_13298_ net394 VGND VGND VPWR VPWR _00072_ sky130_fd_sc_hd__inv_2
XFILLER_115_727 VGND VGND VPWR VPWR sky130_fd_sc_hd__fill_1
X_12318_ _05307_ _05309_ VGND VGND VPWR VPWR _05310_ sky130_fd_sc_hd__nor2_1
XFILLER_5_361 VPWR VGND VPWR VGND sky130_ef_sc_hd__decap_12
X_12249_ net428 net363 net48 net515 VGND VGND VPWR VPWR _05235_ sky130_fd_sc_hd__a22o_1
XTAP_TAPCELL_ROW_114_1896 VGND VPWR sky130_fd_sc_hd__tapvpwrvgnd_1
XTAP_TAPCELL_ROW_114_1885 VGND VPWR sky130_fd_sc_hd__tapvpwrvgnd_1
XFILLER_122_270 VPWR VGND VPWR VGND sky130_ef_sc_hd__decap_12
X_06810_ net688 net319 VGND VGND VPWR VPWR _03456_ sky130_fd_sc_hd__nand2_1
X_07790_ _00519_ _00528_ VGND VGND VPWR VPWR _00529_ sky130_fd_sc_hd__xnor2_1
XFILLER_56_519 VPWR VGND VPWR VGND sky130_ef_sc_hd__decap_12
X_06741_ _02381_ _02686_ VGND VGND VPWR VPWR _02708_ sky130_fd_sc_hd__nand2_1
XFILLER_95_187 VPWR VGND VPWR VGND sky130_ef_sc_hd__decap_12
X_09460_ _02009_ _02200_ VGND VGND VPWR VPWR _02201_ sky130_fd_sc_hd__xor2_2
XFILLER_36_243 VGND VGND VPWR VPWR sky130_fd_sc_hd__decap_4
X_08411_ _02044_ _02186_ VGND VGND VPWR VPWR _01141_ sky130_fd_sc_hd__nor2_1
XTAP_TAPCELL_ROW_65_1206 VGND VPWR sky130_fd_sc_hd__tapvpwrvgnd_1
XFILLER_36_276 VGND VGND VPWR VPWR sky130_fd_sc_hd__fill_1
X_09391_ _02088_ _02123_ VGND VGND VPWR VPWR _02125_ sky130_fd_sc_hd__xnor2_1
X_08342_ _01074_ _01075_ VGND VGND VPWR VPWR _01076_ sky130_fd_sc_hd__xnor2_1
XTAP_TAPCELL_ROW_22_606 VGND VPWR sky130_fd_sc_hd__tapvpwrvgnd_1
X_08273_ _01006_ _01007_ VGND VGND VPWR VPWR _01008_ sky130_fd_sc_hd__nor2_1
X_07224_ _06513_ _06514_ VGND VGND VPWR VPWR _06515_ sky130_fd_sc_hd__and2b_1
X_07155_ _06437_ _06445_ _06446_ VGND VGND VPWR VPWR _06447_ sky130_fd_sc_hd__nand3_1
X_07086_ _06376_ _06377_ VGND VGND VPWR VPWR _06378_ sky130_fd_sc_hd__nand2_1
XFILLER_118_587 VGND VGND VPWR VPWR sky130_fd_sc_hd__fill_1
XFILLER_105_204 VGND VGND VPWR VPWR sky130_fd_sc_hd__decap_3
XTAP_TAPCELL_ROW_76_1357 VGND VPWR sky130_fd_sc_hd__tapvpwrvgnd_1
XFILLER_114_793 VPWR VGND VPWR VGND sky130_ef_sc_hd__decap_12
XFILLER_99_493 VGND VGND VPWR VPWR sky130_fd_sc_hd__fill_2
XFILLER_86_121 VPWR VGND VPWR VGND sky130_ef_sc_hd__decap_12
X_07988_ _00717_ _00724_ VGND VGND VPWR VPWR _00725_ sky130_fd_sc_hd__and2b_1
X_09727_ _02238_ _02363_ _02362_ VGND VGND VPWR VPWR _02491_ sky130_fd_sc_hd__a21oi_1
XPHY_EDGE_ROW_114_Right_114 VGND VGND VPWR VPWR sky130_fd_sc_hd__decap_3
X_06939_ _02910_ _03009_ _02899_ VGND VGND VPWR VPWR _04861_ sky130_fd_sc_hd__a21o_1
XTAP_TAPCELL_ROW_2_320 VGND VPWR sky130_fd_sc_hd__tapvpwrvgnd_1
X_09658_ _02412_ _02414_ VGND VGND VPWR VPWR _02415_ sky130_fd_sc_hd__and2b_1
XFILLER_27_254 VGND VGND VPWR VPWR sky130_fd_sc_hd__decap_8
X_08609_ _01331_ _01337_ VGND VGND VPWR VPWR _01338_ sky130_fd_sc_hd__nand2_1
X_09589_ _01649_ _02340_ VGND VGND VPWR VPWR _02341_ sky130_fd_sc_hd__xnor2_1
XFILLER_63_57 VPWR VGND VPWR VGND sky130_ef_sc_hd__decap_12
XFILLER_15_449 VPWR VGND VPWR VGND sky130_ef_sc_hd__decap_12
X_11620_ _04550_ _04551_ VGND VGND VPWR VPWR _04552_ sky130_fd_sc_hd__xnor2_1
XFILLER_30_419 VGND VGND VPWR VPWR sky130_fd_sc_hd__fill_1
XFILLER_42_268 VGND VGND VPWR VPWR sky130_fd_sc_hd__fill_1
X_11551_ _04246_ _04369_ _04476_ VGND VGND VPWR VPWR _04477_ sky130_fd_sc_hd__a21oi_1
XFILLER_128_307 VGND VGND VPWR VPWR sky130_fd_sc_hd__fill_1
X_10502_ _03050_ _03180_ _03179_ _03056_ _03330_ VGND VGND VPWR VPWR _03331_ sky130_fd_sc_hd__a41o_1
XFILLER_7_615 VGND VGND VPWR VPWR sky130_fd_sc_hd__fill_1
XFILLER_6_125 VPWR VGND VPWR VGND sky130_ef_sc_hd__decap_12
X_11482_ _04270_ _04272_ VGND VGND VPWR VPWR _04402_ sky130_fd_sc_hd__nor2_1
X_10433_ _03115_ _03124_ _03123_ VGND VGND VPWR VPWR _03255_ sky130_fd_sc_hd__o21ba_1
X_13221_ _06272_ _06296_ VGND VGND VPWR VPWR _06297_ sky130_fd_sc_hd__xnor2_1
XTAP_TAPCELL_ROW_131_2130 VGND VPWR sky130_fd_sc_hd__tapvpwrvgnd_1
X_10364_ _03050_ _03056_ _03179_ _03180_ VGND VGND VPWR VPWR _03181_ sky130_fd_sc_hd__and4_1
X_13152_ net360 net361 net290 VGND VGND VPWR VPWR _06221_ sky130_fd_sc_hd__mux2_1
XFILLER_128_83 VGND VGND VPWR VPWR sky130_fd_sc_hd__fill_1
X_12103_ _05073_ _05074_ VGND VGND VPWR VPWR _05075_ sky130_fd_sc_hd__nor2_1
X_10295_ _02875_ _03104_ VGND VGND VPWR VPWR _03105_ sky130_fd_sc_hd__and2_1
X_13083_ _06141_ _06144_ VGND VGND VPWR VPWR _06146_ sky130_fd_sc_hd__xor2_1
XFILLER_120_741 VPWR VGND VPWR VGND sky130_ef_sc_hd__decap_12
XFILLER_104_281 VGND VGND VPWR VPWR sky130_fd_sc_hd__fill_2
X_12034_ _04863_ _04998_ VGND VGND VPWR VPWR _05000_ sky130_fd_sc_hd__and2_1
Xfanout690 net691 VGND VGND VPWR VPWR net690 sky130_fd_sc_hd__buf_2
XFILLER_65_349 VPWR VGND VPWR VGND sky130_ef_sc_hd__decap_12
XFILLER_46_552 VGND VGND VPWR VPWR sky130_fd_sc_hd__fill_1
XFILLER_19_744 VPWR VGND VPWR VGND sky130_ef_sc_hd__decap_12
X_12936_ _05872_ _05883_ _05871_ VGND VGND VPWR VPWR _05985_ sky130_fd_sc_hd__o21a_1
XFILLER_18_265 VGND VGND VPWR VPWR sky130_fd_sc_hd__decap_4
XFILLER_34_725 VPWR VGND VPWR VGND sky130_ef_sc_hd__decap_12
XFILLER_18_287 VGND VGND VPWR VPWR sky130_fd_sc_hd__decap_6
X_12867_ _05908_ _05909_ VGND VGND VPWR VPWR _05911_ sky130_fd_sc_hd__or2_1
X_11818_ net789 net44 VGND VGND VPWR VPWR _04765_ sky130_fd_sc_hd__nand2_1
XFILLER_33_279 VGND VGND VPWR VPWR sky130_fd_sc_hd__fill_1
X_12798_ net592 net284 _02273_ net617 VGND VGND VPWR VPWR _05835_ sky130_fd_sc_hd__o2bb2a_1
X_11749_ net618 net641 net301 net299 VGND VGND VPWR VPWR _04689_ sky130_fd_sc_hd__and4_1
XTAP_TAPCELL_ROW_60_1136 VGND VPWR sky130_fd_sc_hd__tapvpwrvgnd_1
XFILLER_127_351 VGND VGND VPWR VPWR sky130_fd_sc_hd__fill_1
XTAP_TAPCELL_ROW_116_1925 VGND VPWR sky130_fd_sc_hd__tapvpwrvgnd_1
XTAP_TAPCELL_ROW_116_1914 VGND VPWR sky130_fd_sc_hd__tapvpwrvgnd_1
XFILLER_6_681 VPWR VGND VPWR VGND sky130_ef_sc_hd__decap_12
XFILLER_115_535 VPWR VGND VPWR VGND sky130_ef_sc_hd__decap_12
XFILLER_88_419 VGND VGND VPWR VPWR sky130_fd_sc_hd__fill_1
X_08960_ _02011_ net324 _01684_ _01685_ VGND VGND VPWR VPWR _01686_ sky130_fd_sc_hd__a22o_1
X_08891_ _01600_ _01616_ VGND VGND VPWR VPWR _01617_ sky130_fd_sc_hd__xnor2_1
XFILLER_111_741 VPWR VGND VPWR VGND sky130_ef_sc_hd__decap_12
X_07911_ _00647_ _00648_ VGND VGND VPWR VPWR _00649_ sky130_fd_sc_hd__xnor2_1
X_07842_ _00476_ _00506_ _00505_ VGND VGND VPWR VPWR _00580_ sky130_fd_sc_hd__a21oi_1
XFILLER_96_441 VGND VGND VPWR VPWR sky130_fd_sc_hd__decap_8
XTAP_TAPCELL_ROW_71_1287 VGND VPWR sky130_fd_sc_hd__tapvpwrvgnd_1
XFILLER_111_785 VPWR VGND VPWR VGND sky130_ef_sc_hd__decap_12
XFILLER_96_474 VGND VGND VPWR VPWR sky130_fd_sc_hd__fill_2
XFILLER_69_699 VGND VGND VPWR VPWR sky130_fd_sc_hd__decap_8
XFILLER_68_165 VGND VGND VPWR VPWR sky130_fd_sc_hd__decap_4
X_09512_ _02097_ _02101_ _02096_ VGND VGND VPWR VPWR _02257_ sky130_fd_sc_hd__a21oi_1
XFILLER_83_135 VGND VGND VPWR VPWR sky130_fd_sc_hd__fill_1
X_07773_ _00509_ _00510_ net332 net381 VGND VGND VPWR VPWR _00512_ sky130_fd_sc_hd__and4bb_1
X_06724_ _02501_ _02511_ VGND VGND VPWR VPWR _02522_ sky130_fd_sc_hd__xor2_2
X_09443_ _01677_ _02180_ VGND VGND VPWR VPWR _02182_ sky130_fd_sc_hd__xnor2_1
XFILLER_52_533 VGND VGND VPWR VPWR sky130_fd_sc_hd__decap_6
X_09374_ _01933_ _02105_ VGND VGND VPWR VPWR _02106_ sky130_fd_sc_hd__xnor2_1
XFILLER_12_408 VPWR VGND VPWR VGND sky130_ef_sc_hd__decap_12
XFILLER_40_717 VGND VGND VPWR VPWR sky130_fd_sc_hd__fill_1
X_08325_ _00831_ _01058_ VGND VGND VPWR VPWR _01059_ sky130_fd_sc_hd__xnor2_1
XFILLER_33_49 VGND VGND VPWR VPWR sky130_fd_sc_hd__decap_6
XTAP_TAPCELL_ROW_35_786 VGND VPWR sky130_fd_sc_hd__tapvpwrvgnd_1
X_08256_ _00893_ _00990_ VGND VGND VPWR VPWR _00991_ sky130_fd_sc_hd__nor2_1
XFILLER_20_485 VGND VGND VPWR VPWR sky130_fd_sc_hd__fill_2
X_07207_ _04927_ _06259_ _06497_ _06496_ VGND VGND VPWR VPWR _06499_ sky130_fd_sc_hd__a2bb2o_4
X_08187_ _00891_ _00921_ VGND VGND VPWR VPWR _00923_ sky130_fd_sc_hd__xnor2_1
X_07138_ _06428_ _06429_ VGND VGND VPWR VPWR _06430_ sky130_fd_sc_hd__nand2_1
XFILLER_106_557 VGND VGND VPWR VPWR sky130_fd_sc_hd__fill_1
X_07069_ _06270_ _06248_ _06237_ VGND VGND VPWR VPWR _06281_ sky130_fd_sc_hd__and3_1
X_10080_ _02869_ _02870_ VGND VGND VPWR VPWR _00002_ sky130_fd_sc_hd__and2_1
XFILLER_87_463 VGND VGND VPWR VPWR sky130_fd_sc_hd__fill_1
XFILLER_87_441 VGND VGND VPWR VPWR sky130_fd_sc_hd__decap_3
XFILLER_114_41 VPWR VGND VPWR VGND sky130_ef_sc_hd__decap_12
XTAP_TAPCELL_ROW_89_1537 VGND VPWR sky130_fd_sc_hd__tapvpwrvgnd_1
XFILLER_114_85 VPWR VGND VPWR VGND sky130_ef_sc_hd__decap_12
XFILLER_28_530 VGND VGND VPWR VPWR sky130_fd_sc_hd__fill_2
XFILLER_90_639 VGND VGND VPWR VPWR sky130_fd_sc_hd__decap_4
X_10982_ _03853_ _03854_ _03681_ _03683_ VGND VGND VPWR VPWR _03856_ sky130_fd_sc_hd__a211oi_1
XFILLER_74_78 VGND VGND VPWR VPWR sky130_fd_sc_hd__decap_6
XFILLER_55_393 VPWR VGND VPWR VGND sky130_ef_sc_hd__decap_12
XFILLER_15_235 VGND VGND VPWR VPWR sky130_fd_sc_hd__fill_1
X_12721_ _05749_ _05750_ VGND VGND VPWR VPWR _05751_ sky130_fd_sc_hd__xnor2_1
XFILLER_70_341 VPWR VGND VPWR VGND sky130_ef_sc_hd__decap_12
XFILLER_16_769 VPWR VGND VPWR VGND sky130_ef_sc_hd__decap_12
X_12652_ _05673_ _05674_ VGND VGND VPWR VPWR _05675_ sky130_fd_sc_hd__and2_1
XFILLER_90_44 VPWR VGND VPWR VGND sky130_ef_sc_hd__decap_12
XFILLER_15_279 VGND VGND VPWR VPWR sky130_fd_sc_hd__fill_1
X_11603_ _04208_ _04445_ _04120_ VGND VGND VPWR VPWR _04533_ sky130_fd_sc_hd__o21a_1
XFILLER_30_205 VPWR VGND VPWR VGND sky130_ef_sc_hd__decap_12
X_12583_ _05583_ _05598_ VGND VGND VPWR VPWR _05600_ sky130_fd_sc_hd__xnor2_1
X_11534_ _04447_ _04456_ VGND VGND VPWR VPWR _04458_ sky130_fd_sc_hd__nor2_1
XFILLER_99_31 VPWR VGND VPWR VGND sky130_ef_sc_hd__decap_12
X_11465_ _04382_ _04378_ VGND VGND VPWR VPWR _04383_ sky130_fd_sc_hd__and2b_1
X_10416_ _03234_ _03235_ VGND VGND VPWR VPWR _03236_ sky130_fd_sc_hd__and2_1
X_13204_ _06047_ _06170_ _06276_ VGND VGND VPWR VPWR _06278_ sky130_fd_sc_hd__and3_1
XFILLER_136_181 VPWR VGND VPWR VGND sky130_ef_sc_hd__decap_12
XFILLER_124_321 VPWR VGND VPWR VGND sky130_ef_sc_hd__decap_12
XFILLER_99_75 VPWR VGND VPWR VGND sky130_ef_sc_hd__decap_12
X_11396_ _04302_ _04306_ VGND VGND VPWR VPWR _04307_ sky130_fd_sc_hd__xor2_1
XFILLER_112_516 VPWR VGND VPWR VGND sky130_ef_sc_hd__decap_12
X_10347_ _03159_ _03160_ _03005_ _03008_ VGND VGND VPWR VPWR _03163_ sky130_fd_sc_hd__o211a_4
XFILLER_3_673 VPWR VGND VPWR VGND sky130_ef_sc_hd__decap_12
X_13135_ _06200_ _06201_ VGND VGND VPWR VPWR _06203_ sky130_fd_sc_hd__nand2_1
XTAP_TAPCELL_ROW_111_1855 VGND VPWR sky130_fd_sc_hd__tapvpwrvgnd_1
XTAP_TAPCELL_ROW_111_1844 VGND VPWR sky130_fd_sc_hd__tapvpwrvgnd_1
X_10278_ _02879_ _02935_ _02937_ _02929_ VGND VGND VPWR VPWR _03087_ sky130_fd_sc_hd__o22ai_1
X_13066_ _05988_ _06001_ _05987_ VGND VGND VPWR VPWR _06127_ sky130_fd_sc_hd__a21bo_1
X_12017_ _04847_ _04853_ _04980_ _04979_ VGND VGND VPWR VPWR _04983_ sky130_fd_sc_hd__a22o_1
XFILLER_39_806 VGND VGND VPWR VPWR sky130_fd_sc_hd__fill_1
XFILLER_93_455 VPWR VGND VPWR VGND sky130_ef_sc_hd__decap_12
XFILLER_81_606 VGND VGND VPWR VPWR sky130_fd_sc_hd__decap_6
XFILLER_34_500 VPWR VGND VPWR VGND sky130_ef_sc_hd__decap_12
XFILLER_74_680 VGND VGND VPWR VPWR sky130_fd_sc_hd__decap_4
XFILLER_46_371 VGND VGND VPWR VPWR sky130_fd_sc_hd__decap_8
X_12919_ _05745_ _05966_ VGND VGND VPWR VPWR _05967_ sky130_fd_sc_hd__xor2_1
XFILLER_19_596 VPWR VGND VPWR VGND sky130_ef_sc_hd__decap_12
XFILLER_61_341 VGND VGND VPWR VPWR sky130_fd_sc_hd__fill_2
XFILLER_0_97 VPWR VGND VPWR VGND sky130_ef_sc_hd__decap_12
XPHY_EDGE_ROW_14_Left_151 VGND VGND VPWR VPWR sky130_fd_sc_hd__decap_3
XFILLER_15_791 VPWR VGND VPWR VGND sky130_ef_sc_hd__decap_12
XTAP_TAPCELL_ROW_32_745 VGND VPWR sky130_fd_sc_hd__tapvpwrvgnd_1
X_09090_ net479 net634 _01648_ _01647_ VGND VGND VPWR VPWR _01815_ sky130_fd_sc_hd__a31o_1
X_08110_ _00844_ _00845_ VGND VGND VPWR VPWR _00846_ sky130_fd_sc_hd__nand2_1
X_08041_ _00597_ _00609_ _00608_ VGND VGND VPWR VPWR _00778_ sky130_fd_sc_hd__o21ai_1
XFILLER_128_693 VGND VGND VPWR VPWR sky130_fd_sc_hd__decap_6
X_09992_ _02731_ _02777_ VGND VGND VPWR VPWR _02778_ sky130_fd_sc_hd__xnor2_1
XFILLER_103_505 VGND VGND VPWR VPWR sky130_fd_sc_hd__decap_6
XTAP_TAPCELL_ROW_73_1316 VGND VPWR sky130_fd_sc_hd__tapvpwrvgnd_1
XFILLER_0_109 VGND VGND VPWR VPWR sky130_fd_sc_hd__decap_3
XPHY_EDGE_ROW_23_Left_160 VGND VGND VPWR VPWR sky130_fd_sc_hd__decap_3
XFILLER_130_335 VPWR VGND VPWR VGND sky130_ef_sc_hd__decap_12
XFILLER_115_398 VGND VGND VPWR VPWR sky130_fd_sc_hd__fill_2
XFILLER_103_527 VGND VGND VPWR VPWR sky130_fd_sc_hd__fill_1
X_08943_ _01655_ _01667_ _01668_ VGND VGND VPWR VPWR _01669_ sky130_fd_sc_hd__nand3_1
XFILLER_130_368 VGND VGND VPWR VPWR sky130_fd_sc_hd__decap_3
XFILLER_69_463 VPWR VGND VPWR VGND sky130_ef_sc_hd__decap_12
X_08874_ _01599_ VGND VGND VPWR VPWR _01600_ sky130_fd_sc_hd__inv_2
XFILLER_96_260 VGND VGND VPWR VPWR sky130_fd_sc_hd__decap_4
XFILLER_69_485 VPWR VGND VPWR VGND sky130_ef_sc_hd__decap_12
XFILLER_57_625 VGND VGND VPWR VPWR sky130_fd_sc_hd__fill_2
XFILLER_28_38 VGND VGND VPWR VPWR sky130_fd_sc_hd__decap_6
XFILLER_29_316 VPWR VGND VPWR VGND sky130_ef_sc_hd__decap_12
X_07825_ _00437_ _00563_ VGND VGND VPWR VPWR _00564_ sky130_fd_sc_hd__xnor2_1
XFILLER_84_433 VGND VGND VPWR VPWR sky130_fd_sc_hd__fill_2
X_07756_ net444 net137 VGND VGND VPWR VPWR _00495_ sky130_fd_sc_hd__and2b_1
XFILLER_56_157 VGND VGND VPWR VPWR sky130_fd_sc_hd__fill_2
X_06707_ net390 net695 net613 net469 VGND VGND VPWR VPWR _02338_ sky130_fd_sc_hd__and4_1
XFILLER_71_127 VPWR VGND VPWR VGND sky130_ef_sc_hd__decap_12
XFILLER_44_26 VGND VGND VPWR VPWR sky130_fd_sc_hd__fill_2
X_07687_ _00425_ _00424_ _06662_ VGND VGND VPWR VPWR _00427_ sky130_fd_sc_hd__a21o_1
XTAP_TAPCELL_ROW_84_1467 VGND VPWR sky130_fd_sc_hd__tapvpwrvgnd_1
X_09426_ _01867_ _02027_ VGND VGND VPWR VPWR _02163_ sky130_fd_sc_hd__nor2_1
XFILLER_44_37 VPWR VGND VPWR VGND sky130_ef_sc_hd__decap_12
XFILLER_80_672 VGND VGND VPWR VPWR sky130_fd_sc_hd__fill_2
XFILLER_40_525 VGND VGND VPWR VPWR sky130_fd_sc_hd__decap_6
XFILLER_100_54 VGND VGND VPWR VPWR sky130_fd_sc_hd__fill_2
X_09357_ _01966_ _01998_ _01997_ VGND VGND VPWR VPWR _02088_ sky130_fd_sc_hd__a21oi_1
XFILLER_8_209 VPWR VGND VPWR VGND sky130_ef_sc_hd__decap_12
X_08308_ _00999_ _01004_ _01006_ VGND VGND VPWR VPWR _01042_ sky130_fd_sc_hd__a21oi_1
X_09288_ _01844_ _01847_ VGND VGND VPWR VPWR _02013_ sky130_fd_sc_hd__nand2_1
XFILLER_60_14 VGND VGND VPWR VPWR sky130_fd_sc_hd__decap_3
XFILLER_20_260 VPWR VGND VPWR VGND sky130_ef_sc_hd__decap_12
X_08239_ _00968_ _00972_ VGND VGND VPWR VPWR _00974_ sky130_fd_sc_hd__xnor2_2
XTAP_TAPCELL_ROW_10_439 VGND VPWR sky130_fd_sc_hd__tapvpwrvgnd_1
XTAP_TAPCELL_ROW_10_428 VGND VPWR sky130_fd_sc_hd__tapvpwrvgnd_1
XFILLER_125_129 VGND VGND VPWR VPWR sky130_fd_sc_hd__fill_1
XFILLER_118_170 VGND VGND VPWR VPWR sky130_fd_sc_hd__decap_3
XFILLER_107_3 VPWR VGND VPWR VGND sky130_ef_sc_hd__decap_12
X_11250_ _03907_ _04001_ _04000_ VGND VGND VPWR VPWR _04149_ sky130_fd_sc_hd__a21boi_2
XFILLER_106_365 VGND VGND VPWR VPWR sky130_fd_sc_hd__decap_3
X_10201_ _03000_ _03001_ _02999_ VGND VGND VPWR VPWR _03003_ sky130_fd_sc_hd__a21bo_1
X_11181_ _04071_ _04072_ VGND VGND VPWR VPWR _04073_ sky130_fd_sc_hd__or2_1
XFILLER_106_387 VGND VGND VPWR VPWR sky130_fd_sc_hd__fill_1
XFILLER_79_249 VPWR VGND VPWR VGND sky130_ef_sc_hd__decap_12
X_10132_ _02872_ _02926_ VGND VGND VPWR VPWR _02927_ sky130_fd_sc_hd__and2_1
XFILLER_125_51 VGND VGND VPWR VPWR sky130_fd_sc_hd__decap_4
X_10063_ _02806_ _02851_ VGND VGND VPWR VPWR _02852_ sky130_fd_sc_hd__nand2b_1
XFILLER_48_614 VGND VGND VPWR VPWR sky130_fd_sc_hd__decap_3
XFILLER_75_444 VGND VGND VPWR VPWR sky130_fd_sc_hd__decap_4
XTAP_TAPCELL_ROW_126_2062 VGND VPWR sky130_fd_sc_hd__tapvpwrvgnd_1
XFILLER_90_414 VGND VGND VPWR VPWR sky130_fd_sc_hd__fill_1
XFILLER_16_500 VGND VGND VPWR VPWR sky130_fd_sc_hd__fill_1
XFILLER_56_691 VGND VGND VPWR VPWR sky130_fd_sc_hd__fill_1
XFILLER_18_82 VGND VGND VPWR VPWR sky130_fd_sc_hd__fill_2
XFILLER_71_661 VGND VGND VPWR VPWR sky130_fd_sc_hd__fill_1
X_12704_ _05728_ _05731_ VGND VGND VPWR VPWR _05732_ sky130_fd_sc_hd__and2b_1
X_10965_ _03659_ _03661_ _03835_ _03836_ VGND VGND VPWR VPWR _03837_ sky130_fd_sc_hd__o211ai_2
X_10896_ _03749_ _03760_ VGND VGND VPWR VPWR _03761_ sky130_fd_sc_hd__xnor2_1
X_12635_ _05480_ _05482_ _05654_ _05655_ VGND VGND VPWR VPWR _05657_ sky130_fd_sc_hd__o211ai_1
XFILLER_31_547 VPWR VGND VPWR VGND sky130_ef_sc_hd__decap_12
XFILLER_31_569 VGND VGND VPWR VPWR sky130_fd_sc_hd__fill_1
X_12566_ _05415_ _05417_ VGND VGND VPWR VPWR _05581_ sky130_fd_sc_hd__nand2_1
X_11517_ _04431_ _04438_ VGND VGND VPWR VPWR _04440_ sky130_fd_sc_hd__xnor2_1
X_12497_ _05502_ _05503_ VGND VGND VPWR VPWR _05506_ sky130_fd_sc_hd__xor2_1
XFILLER_109_181 VPWR VGND VPWR VGND sky130_ef_sc_hd__decap_12
X_11448_ _04027_ _04244_ _04246_ VGND VGND VPWR VPWR _04365_ sky130_fd_sc_hd__a21boi_2
X_11379_ _04016_ _04159_ VGND VGND VPWR VPWR _04290_ sky130_fd_sc_hd__nand2_1
XFILLER_125_685 VPWR VGND VPWR VGND sky130_ef_sc_hd__decap_12
XFILLER_112_335 VGND VGND VPWR VPWR sky130_fd_sc_hd__decap_8
X_13118_ _06182_ _06184_ VGND VGND VPWR VPWR _06185_ sky130_fd_sc_hd__nand2_1
XTAP_TAPCELL_ROW_55_1068 VGND VPWR sky130_fd_sc_hd__tapvpwrvgnd_1
XFILLER_66_400 VPWR VGND VPWR VGND sky130_ef_sc_hd__decap_12
X_13049_ _06098_ _06107_ VGND VGND VPWR VPWR _06109_ sky130_fd_sc_hd__xnor2_1
XFILLER_38_135 VGND VGND VPWR VPWR sky130_fd_sc_hd__fill_1
XFILLER_39_669 VGND VGND VPWR VPWR sky130_fd_sc_hd__decap_3
X_07610_ _00345_ _00348_ VGND VGND VPWR VPWR _00350_ sky130_fd_sc_hd__xor2_1
X_08590_ _01140_ _01148_ _01139_ VGND VGND VPWR VPWR _01319_ sky130_fd_sc_hd__a21o_1
XFILLER_66_477 VGND VGND VPWR VPWR sky130_fd_sc_hd__decap_3
XFILLER_26_319 VGND VGND VPWR VPWR sky130_fd_sc_hd__decap_4
XTAP_TAPCELL_ROW_37_815 VGND VPWR sky130_fd_sc_hd__tapvpwrvgnd_1
XFILLER_38_179 VPWR VGND VPWR VGND sky130_ef_sc_hd__decap_12
X_07541_ _06665_ _00163_ _00162_ VGND VGND VPWR VPWR _00281_ sky130_fd_sc_hd__a21oi_1
XFILLER_93_285 VGND VGND VPWR VPWR sky130_fd_sc_hd__fill_1
XFILLER_19_393 VPWR VGND VPWR VGND sky130_ef_sc_hd__decap_12
X_07472_ _00209_ _00210_ _00211_ VGND VGND VPWR VPWR _00213_ sky130_fd_sc_hd__a21o_1
X_09211_ _01933_ _01934_ VGND VGND VPWR VPWR _01935_ sky130_fd_sc_hd__nor2_1
XFILLER_14_29 VGND VGND VPWR VPWR sky130_fd_sc_hd__decap_4
XFILLER_22_536 VGND VGND VPWR VPWR sky130_fd_sc_hd__decap_8
X_09142_ net340 net338 net291 VGND VGND VPWR VPWR _01867_ sky130_fd_sc_hd__o21a_4
XFILLER_135_405 VPWR VGND VPWR VGND sky130_ef_sc_hd__decap_12
X_09073_ _01777_ _01797_ VGND VGND VPWR VPWR _01798_ sky130_fd_sc_hd__nand2b_1
XFILLER_135_449 VPWR VGND VPWR VGND sky130_ef_sc_hd__decap_12
XFILLER_116_630 VGND VGND VPWR VPWR sky130_fd_sc_hd__decap_3
X_08024_ net418 _00184_ _00760_ VGND VGND VPWR VPWR _00761_ sky130_fd_sc_hd__o21a_1
XFILLER_30_39 VGND VGND VPWR VPWR sky130_fd_sc_hd__decap_8
XFILLER_89_503 VGND VGND VPWR VPWR sky130_fd_sc_hd__fill_1
XFILLER_1_429 VPWR VGND VPWR VGND sky130_ef_sc_hd__decap_12
XFILLER_130_121 VPWR VGND VPWR VGND sky130_ef_sc_hd__decap_12
X_09975_ _01949_ _02110_ _02689_ VGND VGND VPWR VPWR _02759_ sky130_fd_sc_hd__or3_1
XFILLER_130_165 VGND VGND VPWR VPWR sky130_fd_sc_hd__fill_1
XFILLER_103_379 VGND VGND VPWR VPWR sky130_fd_sc_hd__decap_4
X_08926_ _01650_ _01651_ VGND VGND VPWR VPWR _01652_ sky130_fd_sc_hd__nand2_1
X_08857_ _01581_ _01582_ _01443_ _01445_ VGND VGND VPWR VPWR _01584_ sky130_fd_sc_hd__o211ai_1
XFILLER_69_293 VPWR VGND VPWR VGND sky130_ef_sc_hd__decap_12
XFILLER_29_113 VPWR VGND VPWR VGND sky130_ef_sc_hd__decap_12
XFILLER_85_775 VGND VGND VPWR VPWR sky130_fd_sc_hd__decap_4
X_07808_ _00542_ _00544_ VGND VGND VPWR VPWR _00547_ sky130_fd_sc_hd__xnor2_1
XFILLER_57_455 VPWR VGND VPWR VGND sky130_ef_sc_hd__decap_12
XFILLER_45_606 VGND VGND VPWR VPWR sky130_fd_sc_hd__decap_8
X_08788_ _01403_ _01514_ VGND VGND VPWR VPWR _01515_ sky130_fd_sc_hd__nand2_1
XFILLER_55_69 VGND VGND VPWR VPWR sky130_fd_sc_hd__fill_2
X_07739_ net497 net490 net679 net678 VGND VGND VPWR VPWR _00478_ sky130_fd_sc_hd__and4_1
XFILLER_111_42 VPWR VGND VPWR VGND sky130_ef_sc_hd__decap_12
XFILLER_52_171 VGND VGND VPWR VPWR sky130_fd_sc_hd__decap_6
XFILLER_13_503 VGND VGND VPWR VPWR sky130_fd_sc_hd__fill_1
XTAP_TAPCELL_ROW_15_509 VGND VPWR sky130_fd_sc_hd__tapvpwrvgnd_1
X_10750_ _03567_ _03600_ VGND VGND VPWR VPWR _03602_ sky130_fd_sc_hd__xnor2_1
XFILLER_111_86 VPWR VGND VPWR VGND sky130_ef_sc_hd__decap_12
X_09409_ _02143_ _02144_ VGND VGND VPWR VPWR _02145_ sky130_fd_sc_hd__nor2_1
X_10681_ _03524_ _03525_ VGND VGND VPWR VPWR _03526_ sky130_fd_sc_hd__xnor2_1
XFILLER_71_57 VPWR VGND VPWR VGND sky130_ef_sc_hd__decap_12
X_12420_ _05239_ _05241_ _05420_ _05421_ VGND VGND VPWR VPWR _05422_ sky130_fd_sc_hd__a211oi_2
XTAP_TAPCELL_ROW_97_1658 VGND VPWR sky130_fd_sc_hd__tapvpwrvgnd_1
XTAP_TAPCELL_ROW_97_1647 VGND VPWR sky130_fd_sc_hd__tapvpwrvgnd_1
X_12351_ net568 _05345_ _05344_ VGND VGND VPWR VPWR _05346_ sky130_fd_sc_hd__a21bo_1
X_12282_ _05088_ _05097_ _05096_ VGND VGND VPWR VPWR _05271_ sky130_fd_sc_hd__a21boi_1
X_11302_ _04202_ _04203_ VGND VGND VPWR VPWR _04205_ sky130_fd_sc_hd__xnor2_1
XFILLER_4_245 VGND VGND VPWR VPWR sky130_fd_sc_hd__decap_6
X_11233_ _03590_ _04129_ VGND VGND VPWR VPWR _04130_ sky130_fd_sc_hd__xnor2_1
XFILLER_121_110 VGND VGND VPWR VPWR sky130_fd_sc_hd__fill_2
XFILLER_4_289 VPWR VGND VPWR VGND sky130_ef_sc_hd__decap_12
XFILLER_20_83 VGND VGND VPWR VPWR sky130_fd_sc_hd__fill_1
XFILLER_106_195 VGND VGND VPWR VPWR sky130_fd_sc_hd__fill_1
X_11164_ _04048_ _04052_ VGND VGND VPWR VPWR _04054_ sky130_fd_sc_hd__xnor2_1
XFILLER_76_720 VGND VGND VPWR VPWR sky130_fd_sc_hd__decap_6
XFILLER_67_219 VGND VGND VPWR VPWR sky130_fd_sc_hd__decap_4
X_10115_ _02860_ _02907_ VGND VGND VPWR VPWR _02908_ sky130_fd_sc_hd__and2_1
XFILLER_0_462 VGND VGND VPWR VPWR sky130_fd_sc_hd__decap_3
X_11095_ _03789_ _03791_ _03788_ VGND VGND VPWR VPWR _03979_ sky130_fd_sc_hd__o21ba_1
X_10046_ net459 net577 net575 net467 VGND VGND VPWR VPWR _02833_ sky130_fd_sc_hd__a22oi_1
XFILLER_36_628 VGND VGND VPWR VPWR sky130_fd_sc_hd__decap_6
XFILLER_90_211 VGND VGND VPWR VPWR sky130_fd_sc_hd__fill_2
XFILLER_35_116 VPWR VGND VPWR VGND sky130_ef_sc_hd__decap_12
X_11997_ _04928_ _04929_ _04957_ _04958_ VGND VGND VPWR VPWR _04961_ sky130_fd_sc_hd__o22a_1
XTAP_TAPCELL_ROW_106_1776 VGND VPWR sky130_fd_sc_hd__tapvpwrvgnd_1
X_10948_ _03814_ _03815_ _03816_ VGND VGND VPWR VPWR _03819_ sky130_fd_sc_hd__a21o_1
X_10879_ _03582_ _03597_ _03596_ VGND VGND VPWR VPWR _03743_ sky130_fd_sc_hd__o21ai_1
XFILLER_129_221 VGND VGND VPWR VPWR sky130_fd_sc_hd__decap_3
XFILLER_31_399 VGND VGND VPWR VPWR sky130_fd_sc_hd__fill_1
X_12618_ _05458_ _05460_ _05636_ _05638_ VGND VGND VPWR VPWR _05639_ sky130_fd_sc_hd__o211ai_2
XTAP_TAPCELL_ROW_42_884 VGND VPWR sky130_fd_sc_hd__tapvpwrvgnd_1
XFILLER_129_276 VGND VGND VPWR VPWR sky130_fd_sc_hd__decap_4
XFILLER_129_254 VGND VGND VPWR VPWR sky130_fd_sc_hd__decap_6
XFILLER_117_405 VGND VGND VPWR VPWR sky130_fd_sc_hd__fill_2
XFILLER_8_562 VGND VGND VPWR VPWR sky130_fd_sc_hd__decap_4
X_12549_ net462 _05386_ _05387_ _05388_ VGND VGND VPWR VPWR _05563_ sky130_fd_sc_hd__a2bb2o_1
XANTENNA_1 _02055_ VGND VGND VPWR VPWR sky130_fd_sc_hd__diode_2
XFILLER_6_41 VPWR VGND VPWR VGND sky130_ef_sc_hd__decap_12
XFILLER_6_85 VPWR VGND VPWR VGND sky130_ef_sc_hd__decap_12
XFILLER_98_333 VGND VGND VPWR VPWR sky130_fd_sc_hd__decap_4
Xfanout519 net2 VGND VGND VPWR VPWR net519 sky130_fd_sc_hd__clkbuf_4
Xfanout508 net511 VGND VGND VPWR VPWR net508 sky130_fd_sc_hd__clkbuf_2
X_06972_ _05199_ _05210_ VGND VGND VPWR VPWR _05221_ sky130_fd_sc_hd__xnor2_1
X_09760_ _02307_ _02406_ _02203_ VGND VGND VPWR VPWR _02526_ sky130_fd_sc_hd__o21a_1
X_09691_ _02098_ net572 net253 net97 VGND VGND VPWR VPWR _02451_ sky130_fd_sc_hd__and4_1
XFILLER_112_187 VGND VGND VPWR VPWR sky130_fd_sc_hd__decap_8
XFILLER_100_327 VPWR VGND VPWR VGND sky130_ef_sc_hd__decap_12
X_08711_ net702 _01302_ _01438_ _01437_ VGND VGND VPWR VPWR _01439_ sky130_fd_sc_hd__o211a_4
X_08642_ net509 net632 net630 net523 VGND VGND VPWR VPWR _01370_ sky130_fd_sc_hd__a22oi_2
XFILLER_82_701 VGND VGND VPWR VPWR sky130_fd_sc_hd__fill_2
XFILLER_67_764 VGND VGND VPWR VPWR sky130_fd_sc_hd__fill_2
XFILLER_27_617 VPWR VGND VPWR VGND sky130_ef_sc_hd__decap_12
XFILLER_94_583 VGND VGND VPWR VPWR sky130_fd_sc_hd__fill_1
Xrebuffer13 _00229_ VGND VGND VPWR VPWR net713 sky130_fd_sc_hd__dlygate4sd1_1
Xrebuffer24 _01273_ VGND VGND VPWR VPWR net724 sky130_fd_sc_hd__dlygate4sd1_1
XTAP_TAPCELL_ROW_68_1248 VGND VPWR sky130_fd_sc_hd__tapvpwrvgnd_1
Xrebuffer46 _02972_ VGND VGND VPWR VPWR net746 sky130_fd_sc_hd__dlygate4sd1_1
Xrebuffer35 net380 VGND VGND VPWR VPWR net735 sky130_fd_sc_hd__buf_4
X_08573_ _01231_ _01300_ _01301_ VGND VGND VPWR VPWR _01302_ sky130_fd_sc_hd__nor3_2
Xrebuffer68 net767 VGND VGND VPWR VPWR net768 sky130_fd_sc_hd__dlygate4sd1_1
Xrebuffer79 _04959_ VGND VGND VPWR VPWR net779 sky130_fd_sc_hd__dlygate4sd1_1
XFILLER_54_469 VGND VGND VPWR VPWR sky130_fd_sc_hd__fill_1
X_07524_ _00164_ _00261_ _00263_ VGND VGND VPWR VPWR _00265_ sky130_fd_sc_hd__nand3_1
XFILLER_81_299 VGND VGND VPWR VPWR sky130_fd_sc_hd__fill_1
XFILLER_81_277 VGND VGND VPWR VPWR sky130_fd_sc_hd__decap_3
XFILLER_25_28 VGND VGND VPWR VPWR sky130_fd_sc_hd__fill_2
XFILLER_35_661 VGND VGND VPWR VPWR sky130_fd_sc_hd__fill_1
X_07455_ _00180_ _00195_ VGND VGND VPWR VPWR _00196_ sky130_fd_sc_hd__xnor2_1
XTAP_TAPCELL_ROW_81_1426 VGND VPWR sky130_fd_sc_hd__tapvpwrvgnd_1
XFILLER_50_686 VPWR VGND VPWR VGND sky130_ef_sc_hd__decap_12
XFILLER_10_506 VGND VGND VPWR VPWR sky130_fd_sc_hd__decap_8
X_07386_ _06674_ _06675_ VGND VGND VPWR VPWR _06676_ sky130_fd_sc_hd__and2b_1
Xrebuffer103 _00389_ VGND VGND VPWR VPWR net803 sky130_fd_sc_hd__dlygate4sd1_1
Xrebuffer147 net846 VGND VGND VPWR VPWR net847 sky130_fd_sc_hd__dlymetal6s2s_1
Xrebuffer125 net485 VGND VGND VPWR VPWR net825 sky130_fd_sc_hd__buf_2
X_09125_ _01846_ _01847_ _01848_ VGND VGND VPWR VPWR _01850_ sky130_fd_sc_hd__a21o_1
XFILLER_136_769 VPWR VGND VPWR VGND sky130_ef_sc_hd__decap_12
XFILLER_136_747 VGND VGND VPWR VPWR sky130_fd_sc_hd__decap_8
X_09056_ net544 net264 net262 VGND VGND VPWR VPWR _01781_ sky130_fd_sc_hd__and3_1
XTAP_TAPCELL_ROW_20_578 VGND VPWR sky130_fd_sc_hd__tapvpwrvgnd_1
XFILLER_135_279 VGND VGND VPWR VPWR sky130_fd_sc_hd__fill_1
X_08007_ _00730_ _00743_ VGND VGND VPWR VPWR _00744_ sky130_fd_sc_hd__xor2_1
XTAP_TAPCELL_ROW_79_1399 VGND VPWR sky130_fd_sc_hd__tapvpwrvgnd_1
XFILLER_2_749 VGND VGND VPWR VPWR sky130_fd_sc_hd__decap_6
XFILLER_103_132 VPWR VGND VPWR VGND sky130_ef_sc_hd__decap_12
XTAP_TAPCELL_ROW_92_1588 VGND VPWR sky130_fd_sc_hd__tapvpwrvgnd_1
XTAP_TAPCELL_ROW_92_1577 VGND VPWR sky130_fd_sc_hd__tapvpwrvgnd_1
XFILLER_1_237 VPWR VGND VPWR VGND sky130_ef_sc_hd__decap_12
XFILLER_131_485 VPWR VGND VPWR VGND sky130_ef_sc_hd__decap_12
XFILLER_103_154 VPWR VGND VPWR VGND sky130_ef_sc_hd__decap_12
X_09958_ net407 _01822_ _01825_ _02655_ _02740_ VGND VGND VPWR VPWR _02741_ sky130_fd_sc_hd__o221a_1
XFILLER_89_377 VGND VGND VPWR VPWR sky130_fd_sc_hd__decap_3
XFILLER_77_517 VPWR VGND VPWR VGND sky130_ef_sc_hd__decap_12
X_08909_ _01594_ _01634_ VGND VGND VPWR VPWR _01635_ sky130_fd_sc_hd__nand2b_1
XFILLER_85_561 VGND VGND VPWR VPWR sky130_fd_sc_hd__decap_8
X_09889_ _02652_ _02666_ VGND VGND VPWR VPWR _02667_ sky130_fd_sc_hd__xnor2_1
XTAP_TAPCELL_ROW_123_2021 VGND VPWR sky130_fd_sc_hd__tapvpwrvgnd_1
XTAP_TAPCELL_ROW_123_2010 VGND VPWR sky130_fd_sc_hd__tapvpwrvgnd_1
XFILLER_122_41 VPWR VGND VPWR VGND sky130_ef_sc_hd__decap_12
XFILLER_73_723 VGND VGND VPWR VPWR sky130_fd_sc_hd__decap_4
X_11920_ _04720_ _04875_ VGND VGND VPWR VPWR _04876_ sky130_fd_sc_hd__xor2_1
X_11851_ _04759_ _04798_ _04800_ VGND VGND VPWR VPWR _04801_ sky130_fd_sc_hd__nor3_2
X_11782_ _04724_ VGND VGND VPWR VPWR _04725_ sky130_fd_sc_hd__inv_2
XTAP_TAPCELL_ROW_0_281 VGND VPWR sky130_fd_sc_hd__tapvpwrvgnd_1
XTAP_TAPCELL_ROW_28_689 VGND VPWR sky130_fd_sc_hd__tapvpwrvgnd_1
X_10802_ _03473_ _03475_ _03657_ _03658_ VGND VGND VPWR VPWR _03659_ sky130_fd_sc_hd__o211a_1
XTAP_TAPCELL_ROW_0_292 VGND VPWR sky130_fd_sc_hd__tapvpwrvgnd_1
XFILLER_13_322 VPWR VGND VPWR VGND sky130_ef_sc_hd__decap_12
XFILLER_25_193 VPWR VGND VPWR VGND sky130_ef_sc_hd__decap_12
X_10733_ _03405_ _03408_ VGND VGND VPWR VPWR _03583_ sky130_fd_sc_hd__nand2_1
XFILLER_41_686 VGND VGND VPWR VPWR sky130_fd_sc_hd__decap_3
X_10664_ _03343_ _03361_ _03359_ VGND VGND VPWR VPWR _03507_ sky130_fd_sc_hd__o21a_1
XFILLER_9_337 VPWR VGND VPWR VGND sky130_ef_sc_hd__decap_12
XFILLER_40_174 VGND VGND VPWR VPWR sky130_fd_sc_hd__decap_3
X_10595_ net425 net56 VGND VGND VPWR VPWR _03432_ sky130_fd_sc_hd__nand2_1
X_13383_ clknet_3_5__leaf_clk _00029_ _00093_ VGND VGND VPWR VPWR net182 sky130_fd_sc_hd__dfrtp_1
X_12403_ _05080_ _05255_ _05253_ VGND VGND VPWR VPWR _05403_ sky130_fd_sc_hd__a21o_1
XFILLER_126_235 VPWR VGND VPWR VGND sky130_ef_sc_hd__decap_12
X_12334_ _05325_ _05326_ VGND VGND VPWR VPWR _05327_ sky130_fd_sc_hd__nand2_1
XTAP_TAPCELL_ROW_134_2172 VGND VPWR sky130_fd_sc_hd__tapvpwrvgnd_1
XPHY_EDGE_ROW_128_Right_128 VGND VGND VPWR VPWR sky130_fd_sc_hd__decap_3
X_12265_ net791 net365 _05249_ _05250_ VGND VGND VPWR VPWR _05252_ sky130_fd_sc_hd__nand4_1
X_12196_ _05173_ _05174_ VGND VGND VPWR VPWR _05176_ sky130_fd_sc_hd__nor2_1
X_11216_ net827 net647 net636 net491 VGND VGND VPWR VPWR _04111_ sky130_fd_sc_hd__a22o_1
XTAP_TAPCELL_ROW_52_1027 VGND VPWR sky130_fd_sc_hd__tapvpwrvgnd_1
XTAP_TAPCELL_ROW_52_1016 VGND VPWR sky130_fd_sc_hd__tapvpwrvgnd_1
X_11147_ net615 net590 net272 net89 VGND VGND VPWR VPWR _04036_ sky130_fd_sc_hd__and4b_1
XFILLER_0_281 VGND VGND VPWR VPWR sky130_fd_sc_hd__decap_8
Xinput160 w33[6] VGND VGND VPWR VPWR net160 sky130_fd_sc_hd__clkbuf_2
XTAP_TAPCELL_ROW_108_1805 VGND VPWR sky130_fd_sc_hd__tapvpwrvgnd_1
X_11078_ _03957_ _03958_ VGND VGND VPWR VPWR _03961_ sky130_fd_sc_hd__xnor2_1
X_10029_ _02811_ _02815_ VGND VGND VPWR VPWR _02816_ sky130_fd_sc_hd__or2_1
XTAP_TAPCELL_ROW_47_954 VGND VPWR sky130_fd_sc_hd__tapvpwrvgnd_1
XFILLER_17_661 VGND VGND VPWR VPWR sky130_fd_sc_hd__decap_8
XFILLER_23_108 VGND VGND VPWR VPWR sky130_fd_sc_hd__decap_4
XFILLER_16_171 VPWR VGND VPWR VGND sky130_ef_sc_hd__decap_12
XTAP_TAPCELL_ROW_63_1178 VGND VPWR sky130_fd_sc_hd__tapvpwrvgnd_1
XFILLER_31_141 VGND VGND VPWR VPWR sky130_fd_sc_hd__fill_1
X_07240_ net318 net619 _06385_ _06384_ VGND VGND VPWR VPWR _06531_ sky130_fd_sc_hd__a31oi_1
XFILLER_31_163 VGND VGND VPWR VPWR sky130_fd_sc_hd__decap_4
XFILLER_32_697 VGND VGND VPWR VPWR sky130_fd_sc_hd__decap_3
X_07171_ _06459_ _06462_ VGND VGND VPWR VPWR _06463_ sky130_fd_sc_hd__xnor2_1
XTAP_TAPCELL_ROW_119_1967 VGND VPWR sky130_fd_sc_hd__tapvpwrvgnd_1
XTAP_TAPCELL_ROW_119_1956 VGND VPWR sky130_fd_sc_hd__tapvpwrvgnd_1
XFILLER_118_769 VPWR VGND VPWR VGND sky130_ef_sc_hd__decap_12
XFILLER_117_279 VGND VGND VPWR VPWR sky130_fd_sc_hd__fill_1
Xfanout305 net71 VGND VGND VPWR VPWR net305 sky130_fd_sc_hd__buf_2
XFILLER_99_653 VGND VGND VPWR VPWR sky130_fd_sc_hd__decap_8
Xfanout316 net69 VGND VGND VPWR VPWR net316 sky130_fd_sc_hd__buf_2
X_09812_ _02578_ _02581_ VGND VGND VPWR VPWR _02583_ sky130_fd_sc_hd__xor2_1
XFILLER_113_474 VGND VGND VPWR VPWR sky130_fd_sc_hd__fill_1
XFILLER_98_141 VGND VGND VPWR VPWR sky130_fd_sc_hd__decap_4
Xfanout327 net62 VGND VGND VPWR VPWR net327 sky130_fd_sc_hd__buf_2
Xfanout338 net59 VGND VGND VPWR VPWR net338 sky130_fd_sc_hd__buf_2
XFILLER_100_102 VGND VGND VPWR VPWR sky130_fd_sc_hd__decap_8
Xfanout349 net53 VGND VGND VPWR VPWR net349 sky130_fd_sc_hd__buf_1
X_06955_ _03194_ _03216_ _05025_ VGND VGND VPWR VPWR _05036_ sky130_fd_sc_hd__a21oi_1
X_09743_ _02506_ _02507_ VGND VGND VPWR VPWR _00054_ sky130_fd_sc_hd__and2b_1
X_09674_ _01825_ _02431_ VGND VGND VPWR VPWR _02432_ sky130_fd_sc_hd__xnor2_1
X_06886_ _04254_ _04265_ _04276_ VGND VGND VPWR VPWR _04287_ sky130_fd_sc_hd__nand3_1
XFILLER_67_583 VGND VGND VPWR VPWR sky130_fd_sc_hd__decap_3
XFILLER_55_712 VGND VGND VPWR VPWR sky130_fd_sc_hd__fill_2
X_08625_ _01351_ _01352_ VGND VGND VPWR VPWR _01353_ sky130_fd_sc_hd__xnor2_1
XFILLER_82_553 VGND VGND VPWR VPWR sky130_fd_sc_hd__fill_1
XFILLER_55_778 VGND VGND VPWR VPWR sky130_fd_sc_hd__decap_6
XFILLER_54_244 VGND VGND VPWR VPWR sky130_fd_sc_hd__fill_2
XPHY_EDGE_ROW_6_Left_143 VGND VGND VPWR VPWR sky130_fd_sc_hd__decap_3
X_08556_ _01282_ _01283_ net741 VGND VGND VPWR VPWR _01285_ sky130_fd_sc_hd__nand3_1
X_07507_ _00228_ _00245_ _00247_ VGND VGND VPWR VPWR _00248_ sky130_fd_sc_hd__and3_1
XTAP_TAPCELL_ROW_25_648 VGND VPWR sky130_fd_sc_hd__tapvpwrvgnd_1
X_08487_ _01167_ _01215_ VGND VGND VPWR VPWR _01216_ sky130_fd_sc_hd__and2_1
XFILLER_52_48 VGND VGND VPWR VPWR sky130_fd_sc_hd__fill_1
XFILLER_22_141 VGND VGND VPWR VPWR sky130_fd_sc_hd__decap_8
X_07438_ _00176_ _00177_ VGND VGND VPWR VPWR _00179_ sky130_fd_sc_hd__xor2_1
XFILLER_22_174 VPWR VGND VPWR VGND sky130_ef_sc_hd__decap_12
XFILLER_23_697 VGND VGND VPWR VPWR sky130_fd_sc_hd__decap_8
X_07369_ _06501_ _06499_ _06498_ VGND VGND VPWR VPWR _06660_ sky130_fd_sc_hd__a21o_1
XFILLER_6_307 VGND VGND VPWR VPWR sky130_fd_sc_hd__fill_1
XFILLER_136_533 VPWR VGND VPWR VGND sky130_ef_sc_hd__decap_12
XTAP_TAPCELL_ROW_94_1606 VGND VPWR sky130_fd_sc_hd__tapvpwrvgnd_1
X_09108_ _01829_ _01830_ VGND VGND VPWR VPWR _01833_ sky130_fd_sc_hd__xnor2_1
XFILLER_108_246 VGND VGND VPWR VPWR sky130_fd_sc_hd__decap_6
XTAP_TAPCELL_ROW_94_1617 VGND VPWR sky130_fd_sc_hd__tapvpwrvgnd_1
X_10380_ net266 net273 _03196_ VGND VGND VPWR VPWR _03198_ sky130_fd_sc_hd__nand3_1
X_09039_ net596 net258 net256 net621 VGND VGND VPWR VPWR _01764_ sky130_fd_sc_hd__a22o_1
XFILLER_117_780 VGND VGND VPWR VPWR sky130_fd_sc_hd__decap_4
XFILLER_2_513 VPWR VGND VPWR VGND sky130_ef_sc_hd__decap_12
X_12050_ _05017_ _05015_ VGND VGND VPWR VPWR _05018_ sky130_fd_sc_hd__and2b_1
XFILLER_2_557 VPWR VGND VPWR VGND sky130_ef_sc_hd__decap_12
XFILLER_117_85 VPWR VGND VPWR VGND sky130_ef_sc_hd__decap_12
XFILLER_104_452 VGND VGND VPWR VPWR sky130_fd_sc_hd__fill_1
XFILLER_77_314 VGND VGND VPWR VPWR sky130_fd_sc_hd__decap_6
X_11001_ _03874_ _03875_ VGND VGND VPWR VPWR _03876_ sky130_fd_sc_hd__and2_1
XFILLER_131_293 VGND VGND VPWR VPWR sky130_fd_sc_hd__decap_6
XTAP_TAPCELL_ROW_5_362 VGND VPWR sky130_fd_sc_hd__tapvpwrvgnd_1
XFILLER_133_51 VGND VGND VPWR VPWR sky130_fd_sc_hd__decap_4
X_12952_ _05887_ _05902_ _05886_ VGND VGND VPWR VPWR _06003_ sky130_fd_sc_hd__a21bo_1
X_11903_ net691 net666 net297 net295 VGND VGND VPWR VPWR _04857_ sky130_fd_sc_hd__and4_1
XTAP_TAPCELL_ROW_44_913 VGND VPWR sky130_fd_sc_hd__tapvpwrvgnd_1
X_12883_ _05924_ _05927_ VGND VGND VPWR VPWR _05928_ sky130_fd_sc_hd__and2b_1
XTAP_TAPCELL_ROW_103_1735 VGND VPWR sky130_fd_sc_hd__tapvpwrvgnd_1
X_11834_ _04780_ _04773_ _04781_ VGND VGND VPWR VPWR _04782_ sky130_fd_sc_hd__and3_1
XFILLER_14_620 VPWR VGND VPWR VGND sky130_ef_sc_hd__decap_12
X_11765_ _04676_ _04705_ VGND VGND VPWR VPWR _04706_ sky130_fd_sc_hd__nand2_1
XTAP_TAPCELL_ROW_136_2212 VGND VPWR sky130_fd_sc_hd__tapvpwrvgnd_1
XTAP_TAPCELL_ROW_136_2201 VGND VPWR sky130_fd_sc_hd__tapvpwrvgnd_1
X_11696_ _04591_ _04592_ _04590_ VGND VGND VPWR VPWR _04631_ sky130_fd_sc_hd__o21a_1
X_10716_ _03512_ _03563_ VGND VGND VPWR VPWR _03564_ sky130_fd_sc_hd__xor2_1
XFILLER_13_152 VPWR VGND VPWR VGND sky130_ef_sc_hd__decap_12
XFILLER_13_174 VPWR VGND VPWR VGND sky130_ef_sc_hd__decap_12
XFILLER_41_461 VGND VGND VPWR VPWR sky130_fd_sc_hd__decap_8
X_10647_ _03487_ _03488_ VGND VGND VPWR VPWR _03490_ sky130_fd_sc_hd__and2b_1
XFILLER_9_167 VGND VGND VPWR VPWR sky130_fd_sc_hd__fill_1
XFILLER_13_196 VGND VGND VPWR VPWR sky130_fd_sc_hd__decap_6
Xrebuffer4 _05295_ VGND VGND VPWR VPWR net704 sky130_fd_sc_hd__dlymetal6s2s_1
X_13366_ clknet_3_2__leaf_clk _00041_ _00076_ VGND VGND VPWR VPWR net165 sky130_fd_sc_hd__dfrtp_1
XFILLER_61_7 VGND VGND VPWR VPWR sky130_fd_sc_hd__decap_4
X_10578_ net250 _03114_ net655 net495 _03101_ VGND VGND VPWR VPWR _03414_ sky130_fd_sc_hd__o2111a_1
X_13297_ net394 VGND VGND VPWR VPWR _00071_ sky130_fd_sc_hd__inv_2
X_12317_ _05180_ _05182_ _05306_ VGND VGND VPWR VPWR _05309_ sky130_fd_sc_hd__and3_1
XFILLER_5_373 VPWR VGND VPWR VGND sky130_ef_sc_hd__decap_12
X_12248_ net515 net428 net363 net48 VGND VGND VPWR VPWR _05234_ sky130_fd_sc_hd__nand4_1
XFILLER_123_761 VPWR VGND VPWR VGND sky130_ef_sc_hd__decap_12
XTAP_TAPCELL_ROW_114_1897 VGND VPWR sky130_fd_sc_hd__tapvpwrvgnd_1
XTAP_TAPCELL_ROW_114_1886 VGND VPWR sky130_fd_sc_hd__tapvpwrvgnd_1
XFILLER_122_282 VGND VGND VPWR VPWR sky130_fd_sc_hd__decap_6
X_12179_ _04994_ _04997_ _05157_ VGND VGND VPWR VPWR _05158_ sky130_fd_sc_hd__a21o_1
XFILLER_95_166 VGND VGND VPWR VPWR sky130_fd_sc_hd__fill_2
XFILLER_68_369 VGND VGND VPWR VPWR sky130_fd_sc_hd__fill_1
X_06740_ _02381_ _02686_ VGND VGND VPWR VPWR _02697_ sky130_fd_sc_hd__or2_1
XFILLER_95_199 VPWR VGND VPWR VGND sky130_ef_sc_hd__decap_12
XFILLER_64_520 VPWR VGND VPWR VGND sky130_ef_sc_hd__decap_12
XFILLER_76_380 VGND VGND VPWR VPWR sky130_fd_sc_hd__fill_1
XFILLER_64_542 VGND VGND VPWR VPWR sky130_fd_sc_hd__decap_8
X_08410_ _01137_ _01138_ VGND VGND VPWR VPWR _01140_ sky130_fd_sc_hd__xor2_1
XTAP_TAPCELL_ROW_65_1207 VGND VPWR sky130_fd_sc_hd__tapvpwrvgnd_1
X_09390_ _02088_ _02123_ VGND VGND VPWR VPWR _02124_ sky130_fd_sc_hd__nand2b_1
X_08341_ _01054_ _01070_ VGND VGND VPWR VPWR _01075_ sky130_fd_sc_hd__xnor2_2
XTAP_TAPCELL_ROW_22_607 VGND VPWR sky130_fd_sc_hd__tapvpwrvgnd_1
X_08272_ _00906_ _00908_ _01005_ VGND VGND VPWR VPWR _01007_ sky130_fd_sc_hd__and3_1
XFILLER_60_792 VPWR VGND VPWR VGND sky130_ef_sc_hd__decap_12
XFILLER_20_634 VGND VGND VPWR VPWR sky130_fd_sc_hd__decap_6
X_07223_ net619 net316 net595 net318 VGND VGND VPWR VPWR _06514_ sky130_fd_sc_hd__a22o_1
XFILLER_20_645 VGND VGND VPWR VPWR sky130_fd_sc_hd__decap_3
XFILLER_118_533 VPWR VGND VPWR VGND sky130_ef_sc_hd__decap_12
X_07154_ _06442_ _06443_ _06444_ VGND VGND VPWR VPWR _06446_ sky130_fd_sc_hd__a21o_1
XFILLER_133_503 VGND VGND VPWR VPWR sky130_fd_sc_hd__fill_1
X_07085_ net267 net304 _06375_ VGND VGND VPWR VPWR _06377_ sky130_fd_sc_hd__nand3_1
XFILLER_118_599 VGND VGND VPWR VPWR sky130_fd_sc_hd__fill_2
XFILLER_106_739 VGND VGND VPWR VPWR sky130_fd_sc_hd__fill_1
XFILLER_105_216 VGND VGND VPWR VPWR sky130_fd_sc_hd__fill_1
XTAP_TAPCELL_ROW_76_1358 VGND VPWR sky130_fd_sc_hd__tapvpwrvgnd_1
XFILLER_99_461 VPWR VGND VPWR VGND sky130_ef_sc_hd__decap_12
XFILLER_86_133 VGND VGND VPWR VPWR sky130_fd_sc_hd__decap_6
X_07987_ _00718_ _00722_ VGND VGND VPWR VPWR _00724_ sky130_fd_sc_hd__xnor2_1
X_09726_ _02376_ _02488_ VGND VGND VPWR VPWR _02489_ sky130_fd_sc_hd__xnor2_1
X_06938_ _04741_ _04774_ _04763_ VGND VGND VPWR VPWR _04851_ sky130_fd_sc_hd__o21ai_1
XTAP_TAPCELL_ROW_2_321 VGND VPWR sky130_fd_sc_hd__tapvpwrvgnd_1
XFILLER_28_701 VPWR VGND VPWR VGND sky130_ef_sc_hd__decap_12
XFILLER_103_43 VGND VGND VPWR VPWR sky130_fd_sc_hd__fill_1
X_06869_ _02856_ _04090_ VGND VGND VPWR VPWR _04101_ sky130_fd_sc_hd__and2_1
X_09657_ _02304_ _02318_ _02303_ VGND VGND VPWR VPWR _02414_ sky130_fd_sc_hd__a21bo_1
XFILLER_43_704 VGND VGND VPWR VPWR sky130_fd_sc_hd__fill_1
X_09588_ net438 net161 VGND VGND VPWR VPWR _02340_ sky130_fd_sc_hd__and2b_1
X_08608_ _01121_ _01162_ _01163_ _01333_ _01334_ VGND VGND VPWR VPWR _01337_ sky130_fd_sc_hd__a41o_1
XFILLER_42_225 VGND VGND VPWR VPWR sky130_fd_sc_hd__decap_8
X_08539_ _01261_ _01260_ _01266_ VGND VGND VPWR VPWR _01268_ sky130_fd_sc_hd__a21o_1
XFILLER_63_69 VPWR VGND VPWR VGND sky130_ef_sc_hd__decap_12
XFILLER_129_809 VGND VGND VPWR VPWR sky130_fd_sc_hd__fill_2
XFILLER_70_589 VGND VGND VPWR VPWR sky130_fd_sc_hd__decap_8
X_11550_ _04474_ _04475_ VGND VGND VPWR VPWR _04476_ sky130_fd_sc_hd__or2_1
XFILLER_23_472 VGND VGND VPWR VPWR sky130_fd_sc_hd__decap_6
X_10501_ _03046_ _03049_ _03175_ _03176_ VGND VGND VPWR VPWR _03330_ sky130_fd_sc_hd__and4_1
XFILLER_10_122 VPWR VGND VPWR VGND sky130_ef_sc_hd__decap_12
X_13220_ _06294_ _06295_ VGND VGND VPWR VPWR _06296_ sky130_fd_sc_hd__nand2_1
X_11481_ _04398_ _04399_ VGND VGND VPWR VPWR _04401_ sky130_fd_sc_hd__xor2_1
X_10432_ _03226_ _03253_ VGND VGND VPWR VPWR _03254_ sky130_fd_sc_hd__xor2_1
XFILLER_12_40 VPWR VGND VPWR VGND sky130_ef_sc_hd__decap_12
XFILLER_6_137 VGND VGND VPWR VPWR sky130_fd_sc_hd__decap_3
XFILLER_136_385 VGND VGND VPWR VPWR sky130_fd_sc_hd__decap_3
XFILLER_136_363 VGND VGND VPWR VPWR sky130_fd_sc_hd__fill_1
XTAP_TAPCELL_ROW_131_2131 VGND VPWR sky130_fd_sc_hd__tapvpwrvgnd_1
XFILLER_109_588 VGND VGND VPWR VPWR sky130_fd_sc_hd__decap_6
X_10363_ _03175_ _03176_ _03178_ VGND VGND VPWR VPWR _03180_ sky130_fd_sc_hd__a21o_1
X_13151_ _05225_ _06103_ _06102_ VGND VGND VPWR VPWR _06220_ sky130_fd_sc_hd__a21o_1
XFILLER_124_547 VPWR VGND VPWR VGND sky130_ef_sc_hd__decap_12
X_12102_ _05071_ _05072_ _04930_ VGND VGND VPWR VPWR _05074_ sky130_fd_sc_hd__a21oi_1
X_13082_ _06141_ _06144_ VGND VGND VPWR VPWR _06145_ sky130_fd_sc_hd__or2_1
XFILLER_2_321 VPWR VGND VPWR VGND sky130_ef_sc_hd__decap_12
XFILLER_88_66 VPWR VGND VPWR VGND sky130_ef_sc_hd__decap_12
X_12033_ _04863_ _04998_ VGND VGND VPWR VPWR _04999_ sky130_fd_sc_hd__nor2_1
X_10294_ _02935_ _03102_ VGND VGND VPWR VPWR _03104_ sky130_fd_sc_hd__nor2_1
XFILLER_2_365 VPWR VGND VPWR VGND sky130_ef_sc_hd__decap_12
XFILLER_78_645 VGND VGND VPWR VPWR sky130_fd_sc_hd__decap_3
XFILLER_78_623 VGND VGND VPWR VPWR sky130_fd_sc_hd__decap_8
XFILLER_120_753 VGND VGND VPWR VPWR sky130_fd_sc_hd__decap_3
XPHY_EDGE_ROW_69_Left_206 VGND VGND VPWR VPWR sky130_fd_sc_hd__decap_3
Xfanout680 net103 VGND VGND VPWR VPWR net680 sky130_fd_sc_hd__clkbuf_2
XFILLER_77_166 VGND VGND VPWR VPWR sky130_fd_sc_hd__fill_2
Xfanout691 net10 VGND VGND VPWR VPWR net691 sky130_fd_sc_hd__buf_1
XFILLER_19_701 VPWR VGND VPWR VGND sky130_ef_sc_hd__decap_12
XFILLER_46_531 VGND VGND VPWR VPWR sky130_fd_sc_hd__fill_1
XFILLER_19_756 VPWR VGND VPWR VGND sky130_ef_sc_hd__decap_12
XFILLER_80_309 VGND VGND VPWR VPWR sky130_fd_sc_hd__fill_2
X_12935_ _05982_ _05983_ VGND VGND VPWR VPWR _05984_ sky130_fd_sc_hd__nor2_1
XFILLER_37_81 VGND VGND VPWR VPWR sky130_fd_sc_hd__fill_1
XFILLER_61_534 VGND VGND VPWR VPWR sky130_fd_sc_hd__fill_1
X_12866_ net486 net660 net658 net492 VGND VGND VPWR VPWR _05909_ sky130_fd_sc_hd__a22oi_1
XFILLER_33_214 VGND VGND VPWR VPWR sky130_fd_sc_hd__decap_3
XFILLER_34_737 VGND VGND VPWR VPWR sky130_fd_sc_hd__decap_4
X_11817_ _04761_ _04762_ VGND VGND VPWR VPWR _04764_ sky130_fd_sc_hd__nor2_1
XFILLER_14_483 VPWR VGND VPWR VGND sky130_ef_sc_hd__decap_12
X_12797_ _05832_ VGND VGND VPWR VPWR _05834_ sky130_fd_sc_hd__inv_2
XFILLER_42_781 VGND VGND VPWR VPWR sky130_fd_sc_hd__decap_8
XPHY_EDGE_ROW_78_Left_215 VGND VGND VPWR VPWR sky130_fd_sc_hd__decap_3
X_11748_ _04681_ _04687_ VGND VGND VPWR VPWR _04688_ sky130_fd_sc_hd__nand2b_1
XTAP_TAPCELL_ROW_60_1137 VGND VPWR sky130_fd_sc_hd__tapvpwrvgnd_1
X_11679_ _04581_ _04612_ VGND VGND VPWR VPWR _04614_ sky130_fd_sc_hd__and2_1
XTAP_TAPCELL_ROW_116_1915 VGND VPWR sky130_fd_sc_hd__tapvpwrvgnd_1
X_13349_ net399 VGND VGND VPWR VPWR _00123_ sky130_fd_sc_hd__inv_2
XFILLER_115_503 VGND VGND VPWR VPWR sky130_fd_sc_hd__fill_1
XFILLER_115_547 VPWR VGND VPWR VGND sky130_ef_sc_hd__decap_12
XFILLER_6_693 VGND VGND VPWR VPWR sky130_fd_sc_hd__decap_6
XFILLER_5_181 VPWR VGND VPWR VGND sky130_ef_sc_hd__decap_12
XFILLER_123_591 VGND VGND VPWR VPWR sky130_fd_sc_hd__fill_1
X_08890_ _01614_ _01615_ VGND VGND VPWR VPWR _01616_ sky130_fd_sc_hd__nand2_1
X_07910_ net418 net602 VGND VGND VPWR VPWR _00648_ sky130_fd_sc_hd__nand2_1
XPHY_EDGE_ROW_87_Left_224 VGND VGND VPWR VPWR sky130_fd_sc_hd__decap_3
X_07841_ _00455_ _00469_ _00468_ VGND VGND VPWR VPWR _00579_ sky130_fd_sc_hd__o21ai_1
XFILLER_111_753 VPWR VGND VPWR VGND sky130_ef_sc_hd__decap_12
XTAP_TAPCELL_ROW_71_1288 VGND VPWR sky130_fd_sc_hd__tapvpwrvgnd_1
XFILLER_68_133 VGND VGND VPWR VPWR sky130_fd_sc_hd__decap_6
XFILLER_111_797 VPWR VGND VPWR VGND sky130_ef_sc_hd__decap_12
XFILLER_96_497 VGND VGND VPWR VPWR sky130_fd_sc_hd__decap_3
XFILLER_84_615 VGND VGND VPWR VPWR sky130_fd_sc_hd__decap_8
X_07772_ net332 net381 _00509_ _00510_ VGND VGND VPWR VPWR _00511_ sky130_fd_sc_hd__o2bb2a_1
X_09511_ _02249_ _02254_ VGND VGND VPWR VPWR _02256_ sky130_fd_sc_hd__xnor2_1
X_06723_ net469 net611 VGND VGND VPWR VPWR _02511_ sky130_fd_sc_hd__nand2_1
XFILLER_83_169 VPWR VGND VPWR VGND sky130_ef_sc_hd__decap_12
XFILLER_71_309 VGND VGND VPWR VPWR sky130_fd_sc_hd__fill_1
XFILLER_64_361 VGND VGND VPWR VPWR sky130_fd_sc_hd__decap_3
X_09442_ _01676_ _02180_ VGND VGND VPWR VPWR _02181_ sky130_fd_sc_hd__nand2_1
XFILLER_24_203 VGND VGND VPWR VPWR sky130_fd_sc_hd__fill_1
X_09373_ _02103_ _02104_ VGND VGND VPWR VPWR _02105_ sky130_fd_sc_hd__nor2_1
XFILLER_24_258 VGND VGND VPWR VPWR sky130_fd_sc_hd__decap_3
XPHY_EDGE_ROW_96_Left_233 VGND VGND VPWR VPWR sky130_fd_sc_hd__decap_3
X_08324_ _00944_ _00946_ VGND VGND VPWR VPWR _01058_ sky130_fd_sc_hd__and2b_1
XTAP_TAPCELL_ROW_35_787 VGND VPWR sky130_fd_sc_hd__tapvpwrvgnd_1
XFILLER_40_729 VGND VGND VPWR VPWR sky130_fd_sc_hd__decap_6
X_08255_ net73 net303 net546 VGND VGND VPWR VPWR _00990_ sky130_fd_sc_hd__mux2_1
XFILLER_20_475 VGND VGND VPWR VPWR sky130_fd_sc_hd__fill_1
X_07206_ _04927_ _06259_ _06496_ _06497_ VGND VGND VPWR VPWR _06498_ sky130_fd_sc_hd__and4bb_1
X_08186_ _00921_ _00891_ VGND VGND VPWR VPWR _00922_ sky130_fd_sc_hd__and2b_1
X_07137_ _05779_ _06427_ VGND VGND VPWR VPWR _06429_ sky130_fd_sc_hd__or2_1
XFILLER_121_517 VPWR VGND VPWR VGND sky130_ef_sc_hd__decap_12
X_07068_ _04938_ _04982_ _04927_ VGND VGND VPWR VPWR _06270_ sky130_fd_sc_hd__a21bo_1
XFILLER_102_731 VPWR VGND VPWR VGND sky130_ef_sc_hd__decap_12
XFILLER_59_111 VGND VGND VPWR VPWR sky130_fd_sc_hd__fill_1
XTAP_TAPCELL_ROW_89_1538 VGND VPWR sky130_fd_sc_hd__tapvpwrvgnd_1
XFILLER_47_317 VGND VGND VPWR VPWR sky130_fd_sc_hd__decap_4
XFILLER_114_53 VPWR VGND VPWR VGND sky130_ef_sc_hd__decap_12
XFILLER_75_659 VGND VGND VPWR VPWR sky130_fd_sc_hd__fill_1
XFILLER_74_125 VGND VGND VPWR VPWR sky130_fd_sc_hd__fill_1
XFILLER_114_97 VPWR VGND VPWR VGND sky130_ef_sc_hd__decap_12
X_09709_ _02111_ _02470_ VGND VGND VPWR VPWR _02471_ sky130_fd_sc_hd__xnor2_1
XFILLER_74_46 VGND VGND VPWR VPWR sky130_fd_sc_hd__fill_1
XFILLER_62_309 VGND VGND VPWR VPWR sky130_fd_sc_hd__decap_8
XFILLER_55_350 VPWR VGND VPWR VGND sky130_ef_sc_hd__decap_12
X_10981_ net765 _03683_ _03853_ _03854_ VGND VGND VPWR VPWR _03855_ sky130_fd_sc_hd__o211a_1
XFILLER_16_715 VPWR VGND VPWR VGND sky130_ef_sc_hd__decap_12
X_12720_ net334 net362 VGND VGND VPWR VPWR _05750_ sky130_fd_sc_hd__nand2_1
XFILLER_130_41 VPWR VGND VPWR VGND sky130_ef_sc_hd__decap_12
XFILLER_70_353 VGND VGND VPWR VPWR sky130_fd_sc_hd__decap_8
X_12651_ net617 net293 _05499_ _05498_ VGND VGND VPWR VPWR _05674_ sky130_fd_sc_hd__a31o_1
XFILLER_130_85 VPWR VGND VPWR VGND sky130_ef_sc_hd__decap_12
XFILLER_24_770 VPWR VGND VPWR VGND sky130_ef_sc_hd__decap_12
XFILLER_30_217 VGND VGND VPWR VPWR sky130_fd_sc_hd__decap_3
X_11602_ _03890_ _03542_ _03724_ VGND VGND VPWR VPWR _04532_ sky130_fd_sc_hd__mux2_1
XFILLER_129_617 VPWR VGND VPWR VGND sky130_ef_sc_hd__decap_12
XFILLER_90_67 VPWR VGND VPWR VGND sky130_ef_sc_hd__decap_12
XFILLER_90_56 VGND VGND VPWR VPWR sky130_fd_sc_hd__decap_4
X_12582_ _05598_ _05583_ VGND VGND VPWR VPWR _05599_ sky130_fd_sc_hd__and2b_1
XFILLER_11_453 VGND VGND VPWR VPWR sky130_fd_sc_hd__fill_1
X_11533_ _04447_ _04456_ VGND VGND VPWR VPWR _04457_ sky130_fd_sc_hd__and2_1
X_11464_ _03890_ _04381_ VGND VGND VPWR VPWR _04382_ sky130_fd_sc_hd__xnor2_1
XFILLER_23_94 VGND VGND VPWR VPWR sky130_fd_sc_hd__fill_1
XFILLER_99_43 VPWR VGND VPWR VGND sky130_ef_sc_hd__decap_12
X_10415_ _03232_ _03233_ _03230_ VGND VGND VPWR VPWR _03235_ sky130_fd_sc_hd__a21bo_1
X_13203_ _06047_ _06170_ _06276_ VGND VGND VPWR VPWR _06277_ sky130_fd_sc_hd__a21oi_1
XFILLER_136_193 VGND VGND VPWR VPWR sky130_fd_sc_hd__decap_3
XFILLER_124_333 VGND VGND VPWR VPWR sky130_fd_sc_hd__fill_1
XFILLER_99_87 VPWR VGND VPWR VGND sky130_ef_sc_hd__decap_12
X_11395_ _03427_ _04305_ VGND VGND VPWR VPWR _04306_ sky130_fd_sc_hd__xnor2_1
XFILLER_97_206 VPWR VGND VPWR VGND sky130_ef_sc_hd__decap_12
X_10346_ _03008_ _03005_ net237 _03160_ VGND VGND VPWR VPWR _03161_ sky130_fd_sc_hd__a211oi_4
XFILLER_3_641 VPWR VGND VPWR VGND sky130_ef_sc_hd__decap_12
X_13134_ _06200_ _06201_ VGND VGND VPWR VPWR _06202_ sky130_fd_sc_hd__nor2_1
XTAP_TAPCELL_ROW_111_1845 VGND VPWR sky130_fd_sc_hd__tapvpwrvgnd_1
X_10277_ _03083_ _03084_ VGND VGND VPWR VPWR _03086_ sky130_fd_sc_hd__or2_1
X_13065_ _06113_ _06125_ VGND VGND VPWR VPWR _06126_ sky130_fd_sc_hd__xnor2_1
XFILLER_3_685 VPWR VGND VPWR VGND sky130_ef_sc_hd__decap_12
X_12016_ _04847_ _04853_ _04979_ _04980_ VGND VGND VPWR VPWR _04981_ sky130_fd_sc_hd__and4_1
XFILLER_2_195 VGND VGND VPWR VPWR sky130_fd_sc_hd__fill_1
XFILLER_78_475 VGND VGND VPWR VPWR sky130_fd_sc_hd__fill_1
XFILLER_93_445 VGND VGND VPWR VPWR sky130_fd_sc_hd__decap_3
XFILLER_66_659 VGND VGND VPWR VPWR sky130_fd_sc_hd__decap_4
XFILLER_65_147 VGND VGND VPWR VPWR sky130_fd_sc_hd__fill_1
XFILLER_93_478 VPWR VGND VPWR VGND sky130_ef_sc_hd__decap_12
XFILLER_80_139 VGND VGND VPWR VPWR sky130_fd_sc_hd__fill_1
X_12918_ _05867_ _05965_ VGND VGND VPWR VPWR _05966_ sky130_fd_sc_hd__nor2_1
XFILLER_34_512 VGND VGND VPWR VPWR sky130_fd_sc_hd__decap_3
XFILLER_34_545 VGND VGND VPWR VPWR sky130_fd_sc_hd__decap_8
XFILLER_61_375 VPWR VGND VPWR VGND sky130_ef_sc_hd__decap_12
X_12849_ _05590_ _05782_ _05785_ VGND VGND VPWR VPWR _05891_ sky130_fd_sc_hd__a21oi_2
XFILLER_34_589 VPWR VGND VPWR VGND sky130_ef_sc_hd__decap_12
XTAP_TAPCELL_ROW_122_1996 VGND VPWR sky130_fd_sc_hd__tapvpwrvgnd_1
XFILLER_9_52 VGND VGND VPWR VPWR sky130_fd_sc_hd__decap_4
XTAP_TAPCELL_ROW_32_746 VGND VPWR sky130_fd_sc_hd__tapvpwrvgnd_1
XFILLER_119_105 VGND VGND VPWR VPWR sky130_fd_sc_hd__decap_6
XFILLER_135_609 VGND VGND VPWR VPWR sky130_fd_sc_hd__decap_6
X_08040_ _00774_ _00775_ VGND VGND VPWR VPWR _00777_ sky130_fd_sc_hd__xor2_1
XFILLER_127_160 VGND VGND VPWR VPWR sky130_fd_sc_hd__decap_3
XFILLER_115_300 VPWR VGND VPWR VGND sky130_ef_sc_hd__decap_12
XFILLER_127_182 VGND VGND VPWR VPWR sky130_fd_sc_hd__decap_8
X_09991_ _02732_ _02776_ VGND VGND VPWR VPWR _02777_ sky130_fd_sc_hd__xnor2_1
XTAP_TAPCELL_ROW_73_1317 VGND VPWR sky130_fd_sc_hd__tapvpwrvgnd_1
X_08942_ _01663_ _01664_ _01666_ VGND VGND VPWR VPWR _01668_ sky130_fd_sc_hd__a21o_1
XFILLER_69_420 VGND VGND VPWR VPWR sky130_fd_sc_hd__decap_3
XFILLER_130_347 VPWR VGND VPWR VGND sky130_ef_sc_hd__decap_12
X_08873_ _01597_ _01598_ VGND VGND VPWR VPWR _01599_ sky130_fd_sc_hd__xnor2_1
XFILLER_111_572 VPWR VGND VPWR VGND sky130_ef_sc_hd__decap_12
XFILLER_111_561 VGND VGND VPWR VPWR sky130_fd_sc_hd__decap_4
XFILLER_69_475 VGND VGND VPWR VPWR sky130_fd_sc_hd__fill_2
XFILLER_57_615 VGND VGND VPWR VPWR sky130_fd_sc_hd__fill_1
XFILLER_57_604 VGND VGND VPWR VPWR sky130_fd_sc_hd__decap_3
X_07824_ _00560_ _00561_ VGND VGND VPWR VPWR _00563_ sky130_fd_sc_hd__xnor2_1
XFILLER_69_497 VGND VGND VPWR VPWR sky130_fd_sc_hd__decap_6
X_07755_ _00362_ _00365_ VGND VGND VPWR VPWR _00494_ sky130_fd_sc_hd__nor2_1
X_07686_ _06662_ _00424_ _00425_ VGND VGND VPWR VPWR _00426_ sky130_fd_sc_hd__nand3_1
X_06706_ _02316_ VGND VGND VPWR VPWR _02327_ sky130_fd_sc_hd__inv_2
XFILLER_71_139 VGND VGND VPWR VPWR sky130_fd_sc_hd__decap_6
XFILLER_44_16 VGND VGND VPWR VPWR sky130_fd_sc_hd__fill_2
XFILLER_37_372 VGND VGND VPWR VPWR sky130_fd_sc_hd__fill_2
X_09425_ _02128_ _02161_ VGND VGND VPWR VPWR _02162_ sky130_fd_sc_hd__xor2_1
XTAP_TAPCELL_ROW_84_1468 VGND VPWR sky130_fd_sc_hd__tapvpwrvgnd_1
XFILLER_52_342 VGND VGND VPWR VPWR sky130_fd_sc_hd__fill_2
XFILLER_44_49 VGND VGND VPWR VPWR sky130_fd_sc_hd__decap_6
XFILLER_80_695 VGND VGND VPWR VPWR sky130_fd_sc_hd__decap_4
X_09356_ _01942_ _01959_ _01958_ VGND VGND VPWR VPWR _02086_ sky130_fd_sc_hd__o21a_1
XFILLER_100_44 VGND VGND VPWR VPWR sky130_fd_sc_hd__decap_3
XFILLER_12_228 VPWR VGND VPWR VGND sky130_ef_sc_hd__decap_12
X_08307_ _01039_ _01040_ VGND VGND VPWR VPWR _01041_ sky130_fd_sc_hd__xnor2_1
X_09287_ _02009_ _02010_ VGND VGND VPWR VPWR _02012_ sky130_fd_sc_hd__xnor2_1
X_08238_ _00968_ _00972_ VGND VGND VPWR VPWR _00973_ sky130_fd_sc_hd__and2b_1
XTAP_TAPCELL_ROW_10_429 VGND VPWR sky130_fd_sc_hd__tapvpwrvgnd_1
X_08169_ _00752_ _00754_ _00751_ VGND VGND VPWR VPWR _00905_ sky130_fd_sc_hd__a21oi_1
X_10200_ _02999_ _03000_ net898 VGND VGND VPWR VPWR _03002_ sky130_fd_sc_hd__nand3_4
X_11180_ _03944_ _03950_ net246 VGND VGND VPWR VPWR _04072_ sky130_fd_sc_hd__a21oi_1
X_10131_ _02922_ _02925_ VGND VGND VPWR VPWR _02926_ sky130_fd_sc_hd__xnor2_1
X_10062_ _02840_ _02850_ VGND VGND VPWR VPWR _02851_ sky130_fd_sc_hd__xor2_1
XFILLER_102_561 VGND VGND VPWR VPWR sky130_fd_sc_hd__fill_1
XFILLER_88_784 VGND VGND VPWR VPWR sky130_fd_sc_hd__decap_4
XFILLER_87_250 VGND VGND VPWR VPWR sky130_fd_sc_hd__fill_2
XFILLER_102_594 VPWR VGND VPWR VGND sky130_ef_sc_hd__decap_12
XTAP_TAPCELL_ROW_126_2063 VGND VPWR sky130_fd_sc_hd__tapvpwrvgnd_1
XTAP_TAPCELL_ROW_126_2052 VGND VPWR sky130_fd_sc_hd__tapvpwrvgnd_1
XFILLER_18_50 VGND VGND VPWR VPWR sky130_fd_sc_hd__fill_2
XFILLER_43_353 VPWR VGND VPWR VGND sky130_ef_sc_hd__decap_12
X_12703_ _05389_ _05730_ VGND VGND VPWR VPWR _05731_ sky130_fd_sc_hd__xnor2_1
X_10964_ _03833_ _03834_ _03800_ VGND VGND VPWR VPWR _03836_ sky130_fd_sc_hd__a21o_1
XFILLER_71_684 VGND VGND VPWR VPWR sky130_fd_sc_hd__fill_1
XFILLER_71_673 VGND VGND VPWR VPWR sky130_fd_sc_hd__fill_1
XFILLER_16_589 VPWR VGND VPWR VGND sky130_ef_sc_hd__decap_12
X_10895_ _03758_ _03759_ VGND VGND VPWR VPWR _03760_ sky130_fd_sc_hd__and2b_1
XFILLER_70_183 VGND VGND VPWR VPWR sky130_fd_sc_hd__decap_8
X_12634_ _05654_ _05655_ _05480_ _05482_ VGND VGND VPWR VPWR _05656_ sky130_fd_sc_hd__a211o_1
XFILLER_31_559 VGND VGND VPWR VPWR sky130_fd_sc_hd__fill_1
XFILLER_34_93 VGND VGND VPWR VPWR sky130_fd_sc_hd__fill_2
X_12565_ _05543_ _05578_ VGND VGND VPWR VPWR _05580_ sky130_fd_sc_hd__xor2_1
XFILLER_8_755 VGND VGND VPWR VPWR sky130_fd_sc_hd__fill_1
X_11516_ _04432_ _04437_ VGND VGND VPWR VPWR _04438_ sky130_fd_sc_hd__xnor2_1
X_12496_ _05502_ _05503_ VGND VGND VPWR VPWR _05504_ sky130_fd_sc_hd__nand2_1
X_11447_ _04229_ _04231_ VGND VGND VPWR VPWR _04364_ sky130_fd_sc_hd__nor2_1
XFILLER_124_141 VPWR VGND VPWR VGND sky130_ef_sc_hd__decap_12
XFILLER_109_193 VGND VGND VPWR VPWR sky130_fd_sc_hd__decap_8
XFILLER_98_515 VPWR VGND VPWR VGND sky130_ef_sc_hd__decap_12
X_11378_ _04286_ _04288_ VGND VGND VPWR VPWR _04289_ sky130_fd_sc_hd__or2_1
XFILLER_125_697 VPWR VGND VPWR VGND sky130_ef_sc_hd__decap_12
XTAP_TAPCELL_ROW_55_1058 VGND VPWR sky130_fd_sc_hd__tapvpwrvgnd_1
X_10329_ net747 _03141_ _03138_ VGND VGND VPWR VPWR _03143_ sky130_fd_sc_hd__o21ai_1
X_13117_ _05689_ _06181_ VGND VGND VPWR VPWR _06184_ sky130_fd_sc_hd__or2_1
XFILLER_98_559 VGND VGND VPWR VPWR sky130_fd_sc_hd__fill_2
XTAP_TAPCELL_ROW_55_1069 VGND VPWR sky130_fd_sc_hd__tapvpwrvgnd_1
XFILLER_94_721 VGND VGND VPWR VPWR sky130_fd_sc_hd__decap_6
XFILLER_66_412 VGND VGND VPWR VPWR sky130_fd_sc_hd__decap_8
X_13048_ _06098_ _06107_ VGND VGND VPWR VPWR _06108_ sky130_fd_sc_hd__nand2_1
XFILLER_39_615 VGND VGND VPWR VPWR sky130_fd_sc_hd__fill_1
XFILLER_15_3 VGND VGND VPWR VPWR sky130_fd_sc_hd__decap_6
XTAP_TAPCELL_ROW_37_816 VGND VPWR sky130_fd_sc_hd__tapvpwrvgnd_1
X_07540_ _00280_ _00279_ VGND VGND VPWR VPWR _00049_ sky130_fd_sc_hd__xor2_1
XFILLER_53_128 VPWR VGND VPWR VGND sky130_ef_sc_hd__decap_12
X_07471_ _00209_ _00210_ _00211_ VGND VGND VPWR VPWR _00212_ sky130_fd_sc_hd__nand3_1
X_09210_ net645 net254 _02197_ net670 VGND VGND VPWR VPWR _01934_ sky130_fd_sc_hd__o2bb2a_1
XFILLER_61_194 VGND VGND VPWR VPWR sky130_fd_sc_hd__decap_4
XFILLER_22_559 VGND VGND VPWR VPWR sky130_fd_sc_hd__decap_4
X_09141_ net291 net340 net338 VGND VGND VPWR VPWR _01866_ sky130_fd_sc_hd__nand3_2
X_09072_ _01794_ _01795_ VGND VGND VPWR VPWR _01797_ sky130_fd_sc_hd__xnor2_1
XFILLER_135_417 VPWR VGND VPWR VGND sky130_ef_sc_hd__decap_12
X_08023_ net418 _02164_ _06561_ VGND VGND VPWR VPWR _00760_ sky130_fd_sc_hd__o21ai_1
XFILLER_116_653 VGND VGND VPWR VPWR sky130_fd_sc_hd__decap_4
XFILLER_104_804 VGND VGND VPWR VPWR sky130_fd_sc_hd__decap_4
XFILLER_130_133 VGND VGND VPWR VPWR sky130_fd_sc_hd__decap_6
X_09974_ _02679_ _02680_ _02456_ VGND VGND VPWR VPWR _02758_ sky130_fd_sc_hd__mux2_1
X_08925_ _01497_ _01499_ VGND VGND VPWR VPWR _01651_ sky130_fd_sc_hd__nand2_1
XFILLER_69_261 VPWR VGND VPWR VGND sky130_ef_sc_hd__decap_12
X_08856_ _01445_ _01443_ _01581_ _01582_ VGND VGND VPWR VPWR _01583_ sky130_fd_sc_hd__a211o_4
XFILLER_29_125 VGND VGND VPWR VPWR sky130_fd_sc_hd__fill_2
XFILLER_84_253 VGND VGND VPWR VPWR sky130_fd_sc_hd__decap_3
X_07807_ net607 _00206_ VGND VGND VPWR VPWR _00546_ sky130_fd_sc_hd__nand2_1
XFILLER_29_147 VPWR VGND VPWR VGND sky130_ef_sc_hd__decap_12
XFILLER_29_169 VGND VGND VPWR VPWR sky130_fd_sc_hd__decap_4
X_08787_ _01505_ _01512_ VGND VGND VPWR VPWR _01514_ sky130_fd_sc_hd__xor2_1
XFILLER_55_37 VGND VGND VPWR VPWR sky130_fd_sc_hd__fill_1
X_07738_ _00360_ _00376_ _00375_ VGND VGND VPWR VPWR _00477_ sky130_fd_sc_hd__a21oi_1
XFILLER_72_448 VPWR VGND VPWR VGND sky130_ef_sc_hd__decap_12
XFILLER_111_54 VGND VGND VPWR VPWR sky130_fd_sc_hd__fill_2
X_07669_ _00406_ _00405_ _00246_ _00248_ VGND VGND VPWR VPWR _00409_ sky130_fd_sc_hd__a211o_1
XFILLER_53_673 VPWR VGND VPWR VGND sky130_ef_sc_hd__decap_12
XFILLER_13_515 VPWR VGND VPWR VGND sky130_ef_sc_hd__decap_12
XFILLER_111_98 VPWR VGND VPWR VGND sky130_ef_sc_hd__decap_12
X_09408_ _02139_ _02140_ _02141_ VGND VGND VPWR VPWR _02144_ sky130_fd_sc_hd__a21oi_1
XFILLER_71_36 VGND VGND VPWR VPWR sky130_fd_sc_hd__fill_1
XFILLER_13_548 VPWR VGND VPWR VGND sky130_ef_sc_hd__decap_12
X_10680_ net638 net87 VGND VGND VPWR VPWR _03525_ sky130_fd_sc_hd__nand2_1
X_09339_ _02065_ _02067_ _01922_ VGND VGND VPWR VPWR _02069_ sky130_fd_sc_hd__a21o_1
XFILLER_71_69 VGND VGND VPWR VPWR sky130_fd_sc_hd__decap_6
XFILLER_9_519 VGND VGND VPWR VPWR sky130_fd_sc_hd__decap_4
XPHY_EDGE_ROW_109_Right_109 VGND VGND VPWR VPWR sky130_fd_sc_hd__decap_3
XTAP_TAPCELL_ROW_97_1648 VGND VPWR sky130_fd_sc_hd__tapvpwrvgnd_1
X_12350_ net542 net298 _05342_ _05343_ VGND VGND VPWR VPWR _05345_ sky130_fd_sc_hd__and4_1
XTAP_TAPCELL_ROW_97_1659 VGND VPWR sky130_fd_sc_hd__tapvpwrvgnd_1
X_11301_ _04202_ _04203_ VGND VGND VPWR VPWR _04204_ sky130_fd_sc_hd__and2b_1
X_12281_ _05262_ _05269_ VGND VGND VPWR VPWR _05270_ sky130_fd_sc_hd__xnor2_1
XFILLER_106_141 VGND VGND VPWR VPWR sky130_fd_sc_hd__decap_4
X_11232_ _03396_ _04128_ VGND VGND VPWR VPWR _04129_ sky130_fd_sc_hd__xnor2_1
XFILLER_122_601 VGND VGND VPWR VPWR sky130_fd_sc_hd__decap_4
XFILLER_20_73 VGND VGND VPWR VPWR sky130_fd_sc_hd__decap_3
X_11163_ _04048_ _04052_ VGND VGND VPWR VPWR _04053_ sky130_fd_sc_hd__nand2b_1
X_10114_ _02890_ _02895_ VGND VGND VPWR VPWR _02907_ sky130_fd_sc_hd__xnor2_1
XFILLER_96_77 VGND VGND VPWR VPWR sky130_fd_sc_hd__fill_1
XFILLER_0_441 VGND VGND VPWR VPWR sky130_fd_sc_hd__decap_3
X_11094_ _03977_ VGND VGND VPWR VPWR _03978_ sky130_fd_sc_hd__inv_2
XFILLER_76_754 VGND VGND VPWR VPWR sky130_fd_sc_hd__fill_2
X_10045_ _02793_ _02831_ VGND VGND VPWR VPWR _02832_ sky130_fd_sc_hd__xnor2_1
XPHY_EDGE_ROW_42_Left_179 VGND VGND VPWR VPWR sky130_fd_sc_hd__decap_3
XFILLER_91_735 VGND VGND VPWR VPWR sky130_fd_sc_hd__decap_6
XFILLER_35_128 VGND VGND VPWR VPWR sky130_fd_sc_hd__decap_4
X_11996_ _04928_ _04929_ _04958_ _04957_ VGND VGND VPWR VPWR _04959_ sky130_fd_sc_hd__nor4_4
XFILLER_28_191 VGND VGND VPWR VPWR sky130_fd_sc_hd__decap_4
XTAP_TAPCELL_ROW_106_1777 VGND VPWR sky130_fd_sc_hd__tapvpwrvgnd_1
XFILLER_43_150 VGND VGND VPWR VPWR sky130_fd_sc_hd__decap_3
X_10947_ _03814_ _03815_ _03816_ VGND VGND VPWR VPWR _03818_ sky130_fd_sc_hd__nand3_1
XFILLER_91_7 VGND VGND VPWR VPWR sky130_fd_sc_hd__fill_2
XFILLER_84_6 VGND VGND VPWR VPWR sky130_fd_sc_hd__decap_8
X_10878_ _03697_ _03739_ VGND VGND VPWR VPWR _03742_ sky130_fd_sc_hd__xnor2_1
X_12617_ _05634_ _05635_ _05601_ VGND VGND VPWR VPWR _05638_ sky130_fd_sc_hd__a21o_1
XPHY_EDGE_ROW_51_Left_188 VGND VGND VPWR VPWR sky130_fd_sc_hd__decap_3
XFILLER_12_570 VGND VGND VPWR VPWR sky130_fd_sc_hd__decap_8
XTAP_TAPCELL_ROW_42_885 VGND VPWR sky130_fd_sc_hd__tapvpwrvgnd_1
XFILLER_117_417 VPWR VGND VPWR VGND sky130_ef_sc_hd__decap_12
XFILLER_8_574 VPWR VGND VPWR VGND sky130_ef_sc_hd__decap_12
XFILLER_8_541 VGND VGND VPWR VPWR sky130_fd_sc_hd__fill_2
X_12548_ _05550_ _05561_ VGND VGND VPWR VPWR _05562_ sky130_fd_sc_hd__xnor2_1
XANTENNA_2 _02055_ VGND VGND VPWR VPWR sky130_fd_sc_hd__diode_2
X_12479_ _05305_ _05304_ _05303_ VGND VGND VPWR VPWR _05487_ sky130_fd_sc_hd__a21oi_4
XFILLER_6_53 VPWR VGND VPWR VGND sky130_ef_sc_hd__decap_12
XFILLER_125_461 VPWR VGND VPWR VGND sky130_ef_sc_hd__decap_12
XFILLER_113_623 VPWR VGND VPWR VGND sky130_ef_sc_hd__decap_12
XFILLER_6_97 VGND VGND VPWR VPWR sky130_fd_sc_hd__decap_8
Xfanout509 net510 VGND VGND VPWR VPWR net509 sky130_fd_sc_hd__buf_2
XFILLER_98_356 VGND VGND VPWR VPWR sky130_fd_sc_hd__decap_8
XFILLER_112_155 VGND VGND VPWR VPWR sky130_fd_sc_hd__decap_3
X_06971_ net319 net643 VGND VGND VPWR VPWR _05210_ sky130_fd_sc_hd__nand2_1
XPHY_EDGE_ROW_60_Left_197 VGND VGND VPWR VPWR sky130_fd_sc_hd__decap_3
XFILLER_100_339 VPWR VGND VPWR VGND sky130_ef_sc_hd__decap_12
X_09690_ _02322_ _02352_ _02351_ VGND VGND VPWR VPWR _02450_ sky130_fd_sc_hd__a21o_1
X_08710_ _01434_ net722 _01389_ VGND VGND VPWR VPWR _01438_ sky130_fd_sc_hd__o21ai_4
XFILLER_66_220 VGND VGND VPWR VPWR sky130_fd_sc_hd__decap_4
X_08641_ net523 net509 net632 net630 VGND VGND VPWR VPWR _01369_ sky130_fd_sc_hd__and4_1
Xrebuffer25 _05964_ VGND VGND VPWR VPWR net725 sky130_fd_sc_hd__dlymetal6s2s_1
Xrebuffer14 _00229_ VGND VGND VPWR VPWR net714 sky130_fd_sc_hd__dlygate4sd1_1
Xrebuffer36 net735 VGND VGND VPWR VPWR net736 sky130_fd_sc_hd__dlygate4sd1_1
XFILLER_27_629 VGND VGND VPWR VPWR sky130_fd_sc_hd__decap_4
XFILLER_82_757 VGND VGND VPWR VPWR sky130_fd_sc_hd__decap_6
XFILLER_81_223 VGND VGND VPWR VPWR sky130_fd_sc_hd__fill_1
X_08572_ _01290_ _01292_ _01295_ _01299_ VGND VGND VPWR VPWR _01301_ sky130_fd_sc_hd__o211a_4
Xrebuffer69 net767 VGND VGND VPWR VPWR net769 sky130_fd_sc_hd__dlygate4sd1_1
XTAP_TAPCELL_ROW_68_1249 VGND VPWR sky130_fd_sc_hd__tapvpwrvgnd_1
XFILLER_54_459 VGND VGND VPWR VPWR sky130_fd_sc_hd__decap_3
Xrebuffer47 _03139_ VGND VGND VPWR VPWR net747 sky130_fd_sc_hd__dlymetal6s2s_1
X_07523_ _00164_ _00261_ _00263_ VGND VGND VPWR VPWR _00264_ sky130_fd_sc_hd__and3_1
X_07454_ _00191_ _00192_ VGND VGND VPWR VPWR _00195_ sky130_fd_sc_hd__xnor2_1
XFILLER_90_790 VPWR VGND VPWR VGND sky130_ef_sc_hd__decap_12
XTAP_TAPCELL_ROW_81_1427 VGND VPWR sky130_fd_sc_hd__tapvpwrvgnd_1
X_07385_ net619 net306 net594 net316 VGND VGND VPWR VPWR _06675_ sky130_fd_sc_hd__a22o_1
Xrebuffer104 net391 VGND VGND VPWR VPWR net804 sky130_fd_sc_hd__dlymetal6s2s_1
XFILLER_50_698 VGND VGND VPWR VPWR sky130_fd_sc_hd__fill_2
XFILLER_108_417 VGND VGND VPWR VPWR sky130_fd_sc_hd__decap_3
X_09124_ _01846_ _01847_ _01848_ VGND VGND VPWR VPWR _01849_ sky130_fd_sc_hd__nand3_1
Xrebuffer126 net825 VGND VGND VPWR VPWR net826 sky130_fd_sc_hd__dlygate4sd1_1
XFILLER_135_225 VPWR VGND VPWR VGND sky130_ef_sc_hd__decap_12
XFILLER_108_439 VGND VGND VPWR VPWR sky130_fd_sc_hd__fill_1
X_09055_ net502 net629 _01642_ _01641_ VGND VGND VPWR VPWR _01780_ sky130_fd_sc_hd__a31o_1
XTAP_TAPCELL_ROW_20_568 VGND VPWR sky130_fd_sc_hd__tapvpwrvgnd_1
XTAP_TAPCELL_ROW_20_579 VGND VPWR sky130_fd_sc_hd__tapvpwrvgnd_1
X_08006_ _00731_ _00741_ VGND VGND VPWR VPWR _00743_ sky130_fd_sc_hd__xor2_1
XFILLER_1_205 VPWR VGND VPWR VGND sky130_ef_sc_hd__decap_12
XFILLER_116_494 VGND VGND VPWR VPWR sky130_fd_sc_hd__decap_8
XFILLER_104_645 VPWR VGND VPWR VGND sky130_ef_sc_hd__decap_12
XFILLER_103_111 VGND VGND VPWR VPWR sky130_fd_sc_hd__fill_1
XTAP_TAPCELL_ROW_92_1578 VGND VPWR sky130_fd_sc_hd__tapvpwrvgnd_1
XFILLER_1_249 VPWR VGND VPWR VGND sky130_ef_sc_hd__decap_12
XFILLER_103_166 VGND VGND VPWR VPWR sky130_fd_sc_hd__fill_2
XTAP_TAPCELL_ROW_92_1589 VGND VPWR sky130_fd_sc_hd__tapvpwrvgnd_1
X_09957_ _02659_ _02661_ _02658_ VGND VGND VPWR VPWR _02740_ sky130_fd_sc_hd__a21oi_1
XFILLER_77_529 VGND VGND VPWR VPWR sky130_fd_sc_hd__decap_8
XFILLER_131_497 VGND VGND VPWR VPWR sky130_fd_sc_hd__decap_6
X_08908_ _01617_ _01633_ VGND VGND VPWR VPWR _01634_ sky130_fd_sc_hd__xnor2_1
X_09888_ _02663_ _02665_ VGND VGND VPWR VPWR _02666_ sky130_fd_sc_hd__nor2_1
XFILLER_58_765 VGND VGND VPWR VPWR sky130_fd_sc_hd__decap_4
XTAP_TAPCELL_ROW_123_2022 VGND VPWR sky130_fd_sc_hd__tapvpwrvgnd_1
XTAP_TAPCELL_ROW_123_2011 VGND VPWR sky130_fd_sc_hd__tapvpwrvgnd_1
X_08839_ _01428_ _01425_ _01564_ _01565_ VGND VGND VPWR VPWR _01566_ sky130_fd_sc_hd__a211o_1
XFILLER_58_787 VPWR VGND VPWR VGND sky130_ef_sc_hd__decap_12
XFILLER_122_53 VPWR VGND VPWR VGND sky130_ef_sc_hd__decap_12
X_11850_ _04789_ _04790_ _04797_ VGND VGND VPWR VPWR _04800_ sky130_fd_sc_hd__a21oi_1
XFILLER_122_97 VGND VGND VPWR VPWR sky130_fd_sc_hd__decap_3
XFILLER_60_407 VPWR VGND VPWR VGND sky130_ef_sc_hd__decap_12
X_11781_ net500 net676 VGND VGND VPWR VPWR _04724_ sky130_fd_sc_hd__nand2_2
X_10801_ _03652_ _03655_ _03634_ VGND VGND VPWR VPWR _03658_ sky130_fd_sc_hd__a21o_1
XTAP_TAPCELL_ROW_0_282 VGND VPWR sky130_fd_sc_hd__tapvpwrvgnd_1
XTAP_TAPCELL_ROW_0_293 VGND VPWR sky130_fd_sc_hd__tapvpwrvgnd_1
XFILLER_13_301 VPWR VGND VPWR VGND sky130_ef_sc_hd__decap_12
XFILLER_13_334 VGND VGND VPWR VPWR sky130_fd_sc_hd__fill_2
X_10732_ _03572_ _03581_ VGND VGND VPWR VPWR _03582_ sky130_fd_sc_hd__xnor2_1
XFILLER_15_84 VPWR VGND VPWR VGND sky130_ef_sc_hd__decap_12
XFILLER_40_131 VGND VGND VPWR VPWR sky130_fd_sc_hd__fill_1
X_10663_ _03505_ _03506_ VGND VGND VPWR VPWR _00022_ sky130_fd_sc_hd__xor2_1
XFILLER_9_349 VPWR VGND VPWR VGND sky130_ef_sc_hd__decap_12
XFILLER_13_389 VGND VGND VPWR VPWR sky130_fd_sc_hd__decap_3
XFILLER_41_698 VGND VGND VPWR VPWR sky130_fd_sc_hd__fill_1
X_13382_ clknet_3_5__leaf_clk _00028_ _00092_ VGND VGND VPWR VPWR net181 sky130_fd_sc_hd__dfrtp_1
X_10594_ _03263_ _03430_ VGND VGND VPWR VPWR _03431_ sky130_fd_sc_hd__xnor2_1
XFILLER_40_197 VPWR VGND VPWR VGND sky130_ef_sc_hd__decap_12
X_12402_ _05365_ _05401_ VGND VGND VPWR VPWR _05402_ sky130_fd_sc_hd__xor2_1
X_12333_ net568 net300 _05151_ _05150_ VGND VGND VPWR VPWR _05326_ sky130_fd_sc_hd__a31o_1
XTAP_TAPCELL_ROW_134_2173 VGND VPWR sky130_fd_sc_hd__tapvpwrvgnd_1
XFILLER_126_247 VGND VGND VPWR VPWR sky130_fd_sc_hd__decap_4
X_12264_ net379 net365 _05249_ _05250_ VGND VGND VPWR VPWR _05251_ sky130_fd_sc_hd__a22o_1
X_12195_ _05173_ _05174_ VGND VGND VPWR VPWR _05175_ sky130_fd_sc_hd__nand2_1
X_11215_ net489 net482 net647 net636 VGND VGND VPWR VPWR _04110_ sky130_fd_sc_hd__and4_1
XFILLER_122_475 VGND VGND VPWR VPWR sky130_fd_sc_hd__fill_1
XTAP_TAPCELL_ROW_52_1028 VGND VPWR sky130_fd_sc_hd__tapvpwrvgnd_1
XTAP_TAPCELL_ROW_52_1017 VGND VPWR sky130_fd_sc_hd__tapvpwrvgnd_1
X_11146_ _04032_ _04033_ VGND VGND VPWR VPWR _04034_ sky130_fd_sc_hd__nand2_1
XFILLER_110_637 VGND VGND VPWR VPWR sky130_fd_sc_hd__fill_1
XFILLER_95_337 VGND VGND VPWR VPWR sky130_fd_sc_hd__decap_4
XFILLER_1_783 VGND VGND VPWR VPWR sky130_fd_sc_hd__fill_1
X_11077_ _03957_ _03958_ VGND VGND VPWR VPWR _03960_ sky130_fd_sc_hd__nor2_1
XTAP_TAPCELL_ROW_108_1806 VGND VPWR sky130_fd_sc_hd__tapvpwrvgnd_1
Xinput161 w33[7] VGND VGND VPWR VPWR net161 sky130_fd_sc_hd__clkbuf_4
X_10028_ _02812_ _02814_ VGND VGND VPWR VPWR _02815_ sky130_fd_sc_hd__or2_1
XFILLER_48_253 VGND VGND VPWR VPWR sky130_fd_sc_hd__fill_1
XFILLER_0_293 VGND VGND VPWR VPWR sky130_fd_sc_hd__decap_4
Xinput150 w32[4] VGND VGND VPWR VPWR net150 sky130_fd_sc_hd__buf_1
XFILLER_48_264 VPWR VGND VPWR VGND sky130_ef_sc_hd__decap_12
XFILLER_91_554 VGND VGND VPWR VPWR sky130_fd_sc_hd__decap_6
XFILLER_64_779 VGND VGND VPWR VPWR sky130_fd_sc_hd__fill_1
XFILLER_64_757 VGND VGND VPWR VPWR sky130_fd_sc_hd__decap_4
XFILLER_63_223 VGND VGND VPWR VPWR sky130_fd_sc_hd__fill_1
XTAP_TAPCELL_ROW_47_955 VGND VPWR sky130_fd_sc_hd__tapvpwrvgnd_1
XFILLER_51_407 VGND VGND VPWR VPWR sky130_fd_sc_hd__decap_6
X_11979_ net336 net370 net368 net357 VGND VGND VPWR VPWR _04941_ sky130_fd_sc_hd__a22oi_2
XFILLER_16_161 VGND VGND VPWR VPWR sky130_fd_sc_hd__fill_2
XFILLER_16_183 VPWR VGND VPWR VGND sky130_ef_sc_hd__decap_12
XFILLER_20_805 VGND VGND VPWR VPWR sky130_fd_sc_hd__decap_6
XTAP_TAPCELL_ROW_63_1179 VGND VPWR sky130_fd_sc_hd__tapvpwrvgnd_1
X_07170_ _06460_ _06461_ VGND VGND VPWR VPWR _06462_ sky130_fd_sc_hd__and2b_1
XTAP_TAPCELL_ROW_119_1957 VGND VPWR sky130_fd_sc_hd__tapvpwrvgnd_1
XFILLER_117_225 VPWR VGND VPWR VGND sky130_ef_sc_hd__decap_12
XFILLER_133_729 VPWR VGND VPWR VGND sky130_ef_sc_hd__decap_12
XFILLER_126_781 VPWR VGND VPWR VGND sky130_ef_sc_hd__decap_12
XFILLER_98_131 VGND VGND VPWR VPWR sky130_fd_sc_hd__decap_8
Xfanout317 net69 VGND VGND VPWR VPWR net317 sky130_fd_sc_hd__clkbuf_2
X_09811_ _02578_ _02581_ VGND VGND VPWR VPWR _02582_ sky130_fd_sc_hd__nand2_1
Xfanout306 net70 VGND VGND VPWR VPWR net306 sky130_fd_sc_hd__buf_2
XFILLER_98_164 VPWR VGND VPWR VGND sky130_ef_sc_hd__decap_12
Xfanout339 net59 VGND VGND VPWR VPWR net339 sky130_fd_sc_hd__clkbuf_2
Xfanout328 net62 VGND VGND VPWR VPWR net328 sky130_fd_sc_hd__buf_1
X_09742_ _02499_ _02502_ _02503_ _02505_ VGND VGND VPWR VPWR _02507_ sky130_fd_sc_hd__or4_4
XFILLER_101_637 VPWR VGND VPWR VGND sky130_ef_sc_hd__decap_12
X_06954_ _04982_ _05014_ VGND VGND VPWR VPWR _05025_ sky130_fd_sc_hd__or2_4
XFILLER_67_551 VGND VGND VPWR VPWR sky130_fd_sc_hd__decap_3
X_09673_ net423 _01822_ _02430_ VGND VGND VPWR VPWR _02431_ sky130_fd_sc_hd__o21a_1
X_06885_ net427 net389 net378 net804 VGND VGND VPWR VPWR _04276_ sky130_fd_sc_hd__a22o_1
XFILLER_54_201 VGND VGND VPWR VPWR sky130_fd_sc_hd__fill_1
X_08624_ net644 net260 VGND VGND VPWR VPWR _01352_ sky130_fd_sc_hd__nand2_1
X_08555_ _01281_ _01275_ _01128_ VGND VGND VPWR VPWR _01284_ sky130_fd_sc_hd__a21o_1
X_07506_ _00243_ _00242_ _00244_ VGND VGND VPWR VPWR _00247_ sky130_fd_sc_hd__a21o_1
XTAP_TAPCELL_ROW_25_638 VGND VPWR sky130_fd_sc_hd__tapvpwrvgnd_1
XTAP_TAPCELL_ROW_25_649 VGND VPWR sky130_fd_sc_hd__tapvpwrvgnd_1
XFILLER_35_470 VPWR VGND VPWR VGND sky130_ef_sc_hd__decap_12
XFILLER_42_429 VGND VGND VPWR VPWR sky130_fd_sc_hd__fill_1
X_08486_ _01211_ _01214_ VGND VGND VPWR VPWR _01215_ sky130_fd_sc_hd__xnor2_1
XFILLER_50_451 VGND VGND VPWR VPWR sky130_fd_sc_hd__decap_6
X_07437_ _00176_ _00177_ VGND VGND VPWR VPWR _00178_ sky130_fd_sc_hd__and2_1
XFILLER_50_462 VGND VGND VPWR VPWR sky130_fd_sc_hd__decap_8
XFILLER_136_501 VGND VGND VPWR VPWR sky130_fd_sc_hd__decap_3
X_07368_ _06496_ _06657_ VGND VGND VPWR VPWR _06659_ sky130_fd_sc_hd__xor2_1
XFILLER_7_809 VGND VGND VPWR VPWR sky130_fd_sc_hd__fill_2
XFILLER_22_186 VGND VGND VPWR VPWR sky130_fd_sc_hd__decap_8
XFILLER_22_197 VGND VGND VPWR VPWR sky130_fd_sc_hd__decap_3
XFILLER_109_737 VGND VGND VPWR VPWR sky130_fd_sc_hd__fill_2
X_09107_ _01829_ _01830_ VGND VGND VPWR VPWR _01832_ sky130_fd_sc_hd__and2b_1
XFILLER_136_567 VGND VGND VPWR VPWR sky130_fd_sc_hd__decap_3
XFILLER_136_545 VGND VGND VPWR VPWR sky130_fd_sc_hd__decap_8
XTAP_TAPCELL_ROW_94_1607 VGND VPWR sky130_fd_sc_hd__tapvpwrvgnd_1
X_07299_ net614 net612 net411 net403 VGND VGND VPWR VPWR _06590_ sky130_fd_sc_hd__and4_1
XFILLER_136_589 VGND VGND VPWR VPWR sky130_fd_sc_hd__fill_2
X_09038_ net621 net596 net258 net256 VGND VGND VPWR VPWR _01763_ sky130_fd_sc_hd__and4_1
XFILLER_123_217 VGND VGND VPWR VPWR sky130_fd_sc_hd__decap_6
XPHY_EDGE_ROW_107_Left_244 VGND VGND VPWR VPWR sky130_fd_sc_hd__decap_3
XFILLER_2_525 VGND VGND VPWR VPWR sky130_fd_sc_hd__decap_6
XFILLER_117_97 VGND VGND VPWR VPWR sky130_fd_sc_hd__fill_2
XFILLER_89_142 VPWR VGND VPWR VGND sky130_ef_sc_hd__decap_12
XFILLER_77_46 VGND VGND VPWR VPWR sky130_fd_sc_hd__decap_8
XFILLER_2_569 VPWR VGND VPWR VGND sky130_ef_sc_hd__decap_12
X_11000_ net615 net274 _03700_ _03699_ VGND VGND VPWR VPWR _03875_ sky130_fd_sc_hd__a31o_1
XFILLER_77_57 VPWR VGND VPWR VGND sky130_ef_sc_hd__decap_12
XTAP_TAPCELL_ROW_5_363 VGND VPWR sky130_fd_sc_hd__tapvpwrvgnd_1
XFILLER_46_735 VGND VGND VPWR VPWR sky130_fd_sc_hd__decap_4
XFILLER_46_724 VGND VGND VPWR VPWR sky130_fd_sc_hd__fill_1
XFILLER_46_713 VGND VGND VPWR VPWR sky130_fd_sc_hd__fill_1
X_12951_ _05988_ _06001_ VGND VGND VPWR VPWR _06002_ sky130_fd_sc_hd__xnor2_1
XFILLER_18_404 VPWR VGND VPWR VGND sky130_ef_sc_hd__decap_12
XPHY_EDGE_ROW_116_Left_253 VGND VGND VPWR VPWR sky130_fd_sc_hd__decap_3
XFILLER_73_521 VGND VGND VPWR VPWR sky130_fd_sc_hd__decap_8
X_11902_ _04700_ _04701_ _04704_ VGND VGND VPWR VPWR _04856_ sky130_fd_sc_hd__a21bo_1
XFILLER_46_746 VGND VGND VPWR VPWR sky130_fd_sc_hd__decap_8
XFILLER_46_757 VGND VGND VPWR VPWR sky130_fd_sc_hd__decap_4
X_12882_ _05389_ _05926_ VGND VGND VPWR VPWR _05927_ sky130_fd_sc_hd__xnor2_1
X_11833_ net781 _04772_ _04771_ VGND VGND VPWR VPWR _04781_ sky130_fd_sc_hd__o21ai_1
XTAP_TAPCELL_ROW_44_914 VGND VPWR sky130_fd_sc_hd__tapvpwrvgnd_1
XTAP_TAPCELL_ROW_103_1736 VGND VPWR sky130_fd_sc_hd__tapvpwrvgnd_1
XFILLER_45_289 VGND VGND VPWR VPWR sky130_fd_sc_hd__decap_4
XFILLER_14_632 VPWR VGND VPWR VGND sky130_ef_sc_hd__decap_12
XFILLER_26_492 VGND VGND VPWR VPWR sky130_fd_sc_hd__decap_4
X_11764_ _04680_ _04703_ VGND VGND VPWR VPWR _04705_ sky130_fd_sc_hd__xnor2_1
XFILLER_60_259 VGND VGND VPWR VPWR sky130_fd_sc_hd__fill_1
XTAP_TAPCELL_ROW_136_2202 VGND VPWR sky130_fd_sc_hd__tapvpwrvgnd_1
X_11695_ _04626_ _04629_ VGND VGND VPWR VPWR _04630_ sky130_fd_sc_hd__xnor2_1
X_10715_ _03513_ _03561_ VGND VGND VPWR VPWR _03563_ sky130_fd_sc_hd__xnor2_1
XFILLER_9_113 VPWR VGND VPWR VGND sky130_ef_sc_hd__decap_12
XFILLER_13_164 VGND VGND VPWR VPWR sky130_fd_sc_hd__decap_4
XFILLER_14_698 VGND VGND VPWR VPWR sky130_fd_sc_hd__fill_2
XTAP_TAPCELL_ROW_136_2213 VGND VPWR sky130_fd_sc_hd__tapvpwrvgnd_1
X_10646_ _03254_ _03312_ _03311_ VGND VGND VPWR VPWR _03488_ sky130_fd_sc_hd__a21bo_1
XFILLER_13_186 VGND VGND VPWR VPWR sky130_fd_sc_hd__decap_4
XPHY_EDGE_ROW_125_Left_262 VGND VGND VPWR VPWR sky130_fd_sc_hd__decap_3
Xrebuffer5 _03150_ VGND VGND VPWR VPWR net705 sky130_fd_sc_hd__dlymetal6s2s_1
X_13365_ clknet_3_2__leaf_clk _00040_ _00075_ VGND VGND VPWR VPWR net164 sky130_fd_sc_hd__dfrtp_1
X_10577_ _03409_ _03410_ _03242_ VGND VGND VPWR VPWR _03413_ sky130_fd_sc_hd__a21bo_1
X_13296_ net394 VGND VGND VPWR VPWR _00070_ sky130_fd_sc_hd__inv_2
XFILLER_108_781 VPWR VGND VPWR VGND sky130_ef_sc_hd__decap_12
X_12316_ _05180_ _05182_ _05306_ VGND VGND VPWR VPWR _05307_ sky130_fd_sc_hd__a21oi_1
XFILLER_5_385 VGND VGND VPWR VPWR sky130_fd_sc_hd__decap_6
X_12247_ net515 net428 net362 net48 VGND VGND VPWR VPWR _05233_ sky130_fd_sc_hd__and4_1
XFILLER_123_773 VGND VGND VPWR VPWR sky130_fd_sc_hd__decap_8
XTAP_TAPCELL_ROW_114_1887 VGND VPWR sky130_fd_sc_hd__tapvpwrvgnd_1
XFILLER_96_624 VPWR VGND VPWR VGND sky130_ef_sc_hd__decap_12
X_12178_ _05147_ _05156_ VGND VGND VPWR VPWR _05157_ sky130_fd_sc_hd__xnor2_1
X_11129_ _03855_ _03688_ _03687_ _03856_ VGND VGND VPWR VPWR _04017_ sky130_fd_sc_hd__or4_4
XFILLER_49_551 VGND VGND VPWR VPWR sky130_fd_sc_hd__fill_1
XPHY_EDGE_ROW_134_Left_271 VGND VGND VPWR VPWR sky130_fd_sc_hd__decap_3
XFILLER_76_392 VPWR VGND VPWR VGND sky130_ef_sc_hd__decap_12
XFILLER_37_735 VGND VGND VPWR VPWR sky130_fd_sc_hd__fill_1
XTAP_TAPCELL_ROW_65_1208 VGND VPWR sky130_fd_sc_hd__tapvpwrvgnd_1
XFILLER_64_587 VGND VGND VPWR VPWR sky130_fd_sc_hd__fill_1
XFILLER_52_749 VGND VGND VPWR VPWR sky130_fd_sc_hd__decap_6
X_08340_ _01072_ _01073_ VGND VGND VPWR VPWR _01074_ sky130_fd_sc_hd__xnor2_1
XFILLER_51_248 VGND VGND VPWR VPWR sky130_fd_sc_hd__decap_4
X_08271_ _00906_ _00908_ _01005_ VGND VGND VPWR VPWR _01006_ sky130_fd_sc_hd__a21oi_1
XTAP_TAPCELL_ROW_22_608 VGND VPWR sky130_fd_sc_hd__tapvpwrvgnd_1
X_07222_ net318 net619 net316 net594 VGND VGND VPWR VPWR _06513_ sky130_fd_sc_hd__and4_1
XFILLER_118_501 VGND VGND VPWR VPWR sky130_fd_sc_hd__decap_8
X_07153_ _06442_ _06443_ _06444_ VGND VGND VPWR VPWR _06445_ sky130_fd_sc_hd__nand3_1
XFILLER_118_545 VGND VGND VPWR VPWR sky130_fd_sc_hd__decap_3
X_07084_ net267 net303 _06375_ VGND VGND VPWR VPWR _06376_ sky130_fd_sc_hd__a21o_1
XFILLER_133_559 VGND VGND VPWR VPWR sky130_fd_sc_hd__fill_1
XTAP_TAPCELL_ROW_76_1359 VGND VPWR sky130_fd_sc_hd__tapvpwrvgnd_1
XFILLER_120_209 VGND VGND VPWR VPWR sky130_fd_sc_hd__fill_1
XFILLER_114_751 VGND VGND VPWR VPWR sky130_fd_sc_hd__decap_4
XFILLER_113_250 VPWR VGND VPWR VGND sky130_ef_sc_hd__decap_12
XFILLER_99_473 VGND VGND VPWR VPWR sky130_fd_sc_hd__fill_1
XFILLER_59_326 VGND VGND VPWR VPWR sky130_fd_sc_hd__fill_1
XFILLER_113_294 VPWR VGND VPWR VGND sky130_ef_sc_hd__decap_12
X_07986_ _00718_ _00722_ VGND VGND VPWR VPWR _00723_ sky130_fd_sc_hd__and2b_1
X_09725_ _02485_ _02486_ VGND VGND VPWR VPWR _02488_ sky130_fd_sc_hd__xor2_1
X_06937_ _04807_ _04818_ _03707_ VGND VGND VPWR VPWR _04840_ sky130_fd_sc_hd__a21o_1
XFILLER_47_38 VGND VGND VPWR VPWR sky130_fd_sc_hd__decap_3
XTAP_TAPCELL_ROW_2_322 VGND VPWR sky130_fd_sc_hd__tapvpwrvgnd_1
XFILLER_28_713 VGND VGND VPWR VPWR sky130_fd_sc_hd__decap_6
XFILLER_103_33 VGND VGND VPWR VPWR sky130_fd_sc_hd__decap_3
X_09656_ _02399_ _02411_ VGND VGND VPWR VPWR _02412_ sky130_fd_sc_hd__xnor2_1
XFILLER_27_223 VGND VGND VPWR VPWR sky130_fd_sc_hd__fill_1
XFILLER_28_735 VGND VGND VPWR VPWR sky130_fd_sc_hd__decap_3
XFILLER_28_757 VGND VGND VPWR VPWR sky130_fd_sc_hd__decap_6
XFILLER_28_768 VPWR VGND VPWR VGND sky130_ef_sc_hd__decap_12
XFILLER_103_55 VGND VGND VPWR VPWR sky130_fd_sc_hd__fill_1
X_08607_ _01334_ _01335_ VGND VGND VPWR VPWR _01336_ sky130_fd_sc_hd__or2_1
X_06868_ _04014_ _04079_ VGND VGND VPWR VPWR _04090_ sky130_fd_sc_hd__nor2_1
XFILLER_63_15 VPWR VGND VPWR VGND sky130_ef_sc_hd__decap_12
X_06799_ _02987_ _03325_ VGND VGND VPWR VPWR _03335_ sky130_fd_sc_hd__nor2_1
XFILLER_103_99 VPWR VGND VPWR VGND sky130_ef_sc_hd__decap_12
XFILLER_103_77 VGND VGND VPWR VPWR sky130_fd_sc_hd__decap_8
X_09587_ _02193_ _02196_ VGND VGND VPWR VPWR _02339_ sky130_fd_sc_hd__nor2_1
XFILLER_27_289 VGND VGND VPWR VPWR sky130_fd_sc_hd__decap_3
X_08538_ _01260_ _01261_ _01266_ VGND VGND VPWR VPWR _01267_ sky130_fd_sc_hd__nand3_1
XFILLER_42_248 VGND VGND VPWR VPWR sky130_fd_sc_hd__decap_4
X_08469_ _01192_ _01194_ VGND VGND VPWR VPWR _01198_ sky130_fd_sc_hd__xnor2_1
XFILLER_51_771 VPWR VGND VPWR VGND sky130_ef_sc_hd__decap_12
XFILLER_10_101 VGND VGND VPWR VPWR sky130_fd_sc_hd__fill_1
XFILLER_128_309 VPWR VGND VPWR VGND sky130_ef_sc_hd__decap_12
X_10500_ _03327_ _03328_ VGND VGND VPWR VPWR _03329_ sky130_fd_sc_hd__nand2b_4
XFILLER_10_134 VGND VGND VPWR VPWR sky130_fd_sc_hd__decap_6
XFILLER_10_156 VGND VGND VPWR VPWR sky130_fd_sc_hd__decap_6
XFILLER_7_617 VPWR VGND VPWR VGND sky130_ef_sc_hd__decap_12
XFILLER_6_105 VGND VGND VPWR VPWR sky130_fd_sc_hd__decap_3
X_11480_ _04398_ _04399_ VGND VGND VPWR VPWR _04400_ sky130_fd_sc_hd__and2b_1
X_10431_ _03251_ _03252_ VGND VGND VPWR VPWR _03253_ sky130_fd_sc_hd__nand2_1
XFILLER_12_52 VPWR VGND VPWR VGND sky130_ef_sc_hd__decap_12
XTAP_TAPCELL_ROW_131_2132 VGND VPWR sky130_fd_sc_hd__tapvpwrvgnd_1
XFILLER_128_41 VPWR VGND VPWR VGND sky130_ef_sc_hd__decap_12
X_10362_ _03175_ _03176_ _03178_ VGND VGND VPWR VPWR _03179_ sky130_fd_sc_hd__nand3_1
X_13150_ _06218_ _06219_ VGND VGND VPWR VPWR _00029_ sky130_fd_sc_hd__xnor2_1
XFILLER_128_85 VPWR VGND VPWR VGND sky130_ef_sc_hd__decap_12
XFILLER_124_559 VPWR VGND VPWR VGND sky130_ef_sc_hd__decap_12
X_10293_ _02875_ _02930_ _02934_ VGND VGND VPWR VPWR _03103_ sky130_fd_sc_hd__a21o_1
X_12101_ _04930_ _05071_ _05072_ VGND VGND VPWR VPWR _05073_ sky130_fd_sc_hd__and3_1
X_13081_ _05388_ _06143_ VGND VGND VPWR VPWR _06144_ sky130_fd_sc_hd__xnor2_1
XFILLER_88_78 VGND VGND VPWR VPWR sky130_fd_sc_hd__decap_6
X_12032_ _04996_ _04997_ VGND VGND VPWR VPWR _04998_ sky130_fd_sc_hd__nand2_1
XFILLER_2_333 VPWR VGND VPWR VGND sky130_ef_sc_hd__decap_12
XFILLER_132_581 VGND VGND VPWR VPWR sky130_fd_sc_hd__decap_6
XFILLER_104_250 VGND VGND VPWR VPWR sky130_fd_sc_hd__fill_2
XFILLER_2_377 VPWR VGND VPWR VGND sky130_ef_sc_hd__decap_12
XFILLER_77_145 VGND VGND VPWR VPWR sky130_fd_sc_hd__fill_2
Xfanout670 net671 VGND VGND VPWR VPWR net670 sky130_fd_sc_hd__buf_1
Xfanout692 net693 VGND VGND VPWR VPWR net692 sky130_fd_sc_hd__buf_2
Xfanout681 net102 VGND VGND VPWR VPWR net681 sky130_fd_sc_hd__buf_2
XFILLER_92_115 VGND VGND VPWR VPWR sky130_fd_sc_hd__decap_8
XFILLER_65_307 VPWR VGND VPWR VGND sky130_ef_sc_hd__decap_12
XFILLER_19_713 VPWR VGND VPWR VGND sky130_ef_sc_hd__decap_12
XTAP_TAPCELL_ROW_129_2094 VGND VPWR sky130_fd_sc_hd__tapvpwrvgnd_1
X_12934_ _05970_ _05981_ VGND VGND VPWR VPWR _05983_ sky130_fd_sc_hd__and2_1
XPHY_EDGE_ROW_16_Right_16 VGND VGND VPWR VPWR sky130_fd_sc_hd__decap_3
XFILLER_19_768 VPWR VGND VPWR VGND sky130_ef_sc_hd__decap_12
X_12865_ net492 net486 net660 net658 VGND VGND VPWR VPWR _05908_ sky130_fd_sc_hd__and4_1
X_11816_ net515 net366 net364 net698 VGND VGND VPWR VPWR _04762_ sky130_fd_sc_hd__a22oi_1
X_12796_ net617 net592 net284 net81 VGND VGND VPWR VPWR _05832_ sky130_fd_sc_hd__and4b_1
X_11747_ _04682_ _04685_ VGND VGND VPWR VPWR _04687_ sky130_fd_sc_hd__xnor2_1
XTAP_TAPCELL_ROW_60_1138 VGND VPWR sky130_fd_sc_hd__tapvpwrvgnd_1
XFILLER_14_495 VGND VGND VPWR VPWR sky130_fd_sc_hd__decap_4
XFILLER_41_281 VPWR VGND VPWR VGND sky130_ef_sc_hd__decap_12
X_11678_ _04581_ _04612_ VGND VGND VPWR VPWR _04613_ sky130_fd_sc_hd__nor2_1
X_13417_ clknet_3_6__leaf_clk _00057_ _00127_ VGND VGND VPWR VPWR net216 sky130_fd_sc_hd__dfrtp_1
XTAP_TAPCELL_ROW_116_1916 VGND VPWR sky130_fd_sc_hd__tapvpwrvgnd_1
XPHY_EDGE_ROW_25_Right_25 VGND VGND VPWR VPWR sky130_fd_sc_hd__decap_3
X_10629_ _03466_ _03468_ VGND VGND VPWR VPWR _03470_ sky130_fd_sc_hd__xnor2_1
X_13348_ net399 VGND VGND VPWR VPWR _00122_ sky130_fd_sc_hd__inv_2
XFILLER_115_559 VGND VGND VPWR VPWR sky130_fd_sc_hd__fill_1
XFILLER_5_193 VPWR VGND VPWR VGND sky130_ef_sc_hd__decap_12
X_13279_ _06357_ _06358_ VGND VGND VPWR VPWR _06359_ sky130_fd_sc_hd__xnor2_1
X_07840_ _00576_ _00577_ VGND VGND VPWR VPWR _00578_ sky130_fd_sc_hd__nor2_1
XFILLER_111_765 VPWR VGND VPWR VGND sky130_ef_sc_hd__decap_12
XFILLER_69_668 VGND VGND VPWR VPWR sky130_fd_sc_hd__decap_4
XFILLER_110_253 VGND VGND VPWR VPWR sky130_fd_sc_hd__fill_2
X_07771_ net383 net309 net287 net385 VGND VGND VPWR VPWR _00510_ sky130_fd_sc_hd__a22oi_1
XTAP_TAPCELL_ROW_71_1289 VGND VPWR sky130_fd_sc_hd__tapvpwrvgnd_1
X_09510_ _02249_ _02250_ _02253_ VGND VGND VPWR VPWR _02255_ sky130_fd_sc_hd__or3_1
X_06722_ _02479_ _02490_ VGND VGND VPWR VPWR _02501_ sky130_fd_sc_hd__nand2_1
XPHY_EDGE_ROW_34_Right_34 VGND VGND VPWR VPWR sky130_fd_sc_hd__decap_3
XFILLER_64_395 VGND VGND VPWR VPWR sky130_fd_sc_hd__fill_1
X_09441_ _02178_ _02179_ VGND VGND VPWR VPWR _02180_ sky130_fd_sc_hd__xnor2_1
X_09372_ _01931_ _01936_ _02102_ VGND VGND VPWR VPWR _02104_ sky130_fd_sc_hd__and3_1
XFILLER_52_568 VGND VGND VPWR VPWR sky130_fd_sc_hd__decap_4
XFILLER_52_546 VGND VGND VPWR VPWR sky130_fd_sc_hd__decap_8
X_08323_ _00979_ _00978_ _00967_ VGND VGND VPWR VPWR _01057_ sky130_fd_sc_hd__mux2_1
XFILLER_33_782 VGND VGND VPWR VPWR sky130_fd_sc_hd__fill_2
XTAP_TAPCELL_ROW_35_788 VGND VPWR sky130_fd_sc_hd__tapvpwrvgnd_1
XFILLER_20_421 VPWR VGND VPWR VGND sky130_ef_sc_hd__decap_12
XFILLER_32_281 VPWR VGND VPWR VGND sky130_ef_sc_hd__decap_12
X_08254_ _00861_ _00884_ _00883_ VGND VGND VPWR VPWR _00989_ sky130_fd_sc_hd__a21o_1
XPHY_EDGE_ROW_43_Right_43 VGND VGND VPWR VPWR sky130_fd_sc_hd__decap_3
XFILLER_20_465 VGND VGND VPWR VPWR sky130_fd_sc_hd__fill_1
X_07205_ _06494_ _06495_ _06216_ _06237_ VGND VGND VPWR VPWR _06497_ sky130_fd_sc_hd__o211ai_2
X_08185_ _00892_ _00919_ VGND VGND VPWR VPWR _00921_ sky130_fd_sc_hd__xnor2_1
X_07136_ _05779_ _06427_ VGND VGND VPWR VPWR _06428_ sky130_fd_sc_hd__nand2_1
X_07067_ _06237_ _06248_ VGND VGND VPWR VPWR _06259_ sky130_fd_sc_hd__nand2_2
XFILLER_121_529 VPWR VGND VPWR VGND sky130_ef_sc_hd__decap_12
XFILLER_58_26 VGND VGND VPWR VPWR sky130_fd_sc_hd__fill_2
XFILLER_102_743 VGND VGND VPWR VPWR sky130_fd_sc_hd__decap_8
XFILLER_59_123 VGND VGND VPWR VPWR sky130_fd_sc_hd__decap_4
XFILLER_58_48 VGND VGND VPWR VPWR sky130_fd_sc_hd__fill_2
XTAP_TAPCELL_ROW_89_1539 VGND VPWR sky130_fd_sc_hd__tapvpwrvgnd_1
XPHY_EDGE_ROW_52_Right_52 VGND VGND VPWR VPWR sky130_fd_sc_hd__decap_3
X_07969_ _00705_ _00706_ VGND VGND VPWR VPWR _00040_ sky130_fd_sc_hd__xnor2_1
XFILLER_114_65 VPWR VGND VPWR VGND sky130_ef_sc_hd__decap_12
X_09708_ _02467_ _02469_ VGND VGND VPWR VPWR _02470_ sky130_fd_sc_hd__nand2_1
X_10980_ _03851_ _03852_ _03508_ VGND VGND VPWR VPWR _03854_ sky130_fd_sc_hd__a21o_1
XFILLER_28_543 VGND VGND VPWR VPWR sky130_fd_sc_hd__decap_6
XFILLER_28_576 VPWR VGND VPWR VGND sky130_ef_sc_hd__decap_12
XFILLER_82_170 VGND VGND VPWR VPWR sky130_fd_sc_hd__decap_3
X_09639_ _02383_ _02394_ VGND VGND VPWR VPWR _02395_ sky130_fd_sc_hd__nor2_1
XFILLER_74_69 VGND VGND VPWR VPWR sky130_fd_sc_hd__fill_1
XFILLER_55_362 VGND VGND VPWR VPWR sky130_fd_sc_hd__decap_6
XFILLER_16_727 VGND VGND VPWR VPWR sky130_fd_sc_hd__fill_1
XFILLER_130_53 VPWR VGND VPWR VGND sky130_ef_sc_hd__decap_12
X_12650_ _05671_ _05672_ VGND VGND VPWR VPWR _05673_ sky130_fd_sc_hd__xor2_1
XFILLER_130_97 VPWR VGND VPWR VGND sky130_ef_sc_hd__decap_12
XFILLER_90_24 VGND VGND VPWR VPWR sky130_fd_sc_hd__decap_4
XFILLER_43_579 VGND VGND VPWR VPWR sky130_fd_sc_hd__fill_1
X_11601_ _03890_ _04485_ _04484_ VGND VGND VPWR VPWR _04531_ sky130_fd_sc_hd__a21oi_1
XFILLER_24_782 VPWR VGND VPWR VGND sky130_ef_sc_hd__decap_12
XFILLER_90_79 VGND VGND VPWR VPWR sky130_fd_sc_hd__decap_4
XPHY_EDGE_ROW_61_Right_61 VGND VGND VPWR VPWR sky130_fd_sc_hd__decap_3
XFILLER_11_421 VGND VGND VPWR VPWR sky130_fd_sc_hd__fill_1
XFILLER_23_281 VGND VGND VPWR VPWR sky130_fd_sc_hd__decap_6
XFILLER_23_292 VGND VGND VPWR VPWR sky130_fd_sc_hd__fill_1
X_12581_ _05588_ _05597_ VGND VGND VPWR VPWR _05598_ sky130_fd_sc_hd__xnor2_1
XFILLER_129_629 VPWR VGND VPWR VGND sky130_ef_sc_hd__decap_12
X_11532_ _04455_ VGND VGND VPWR VPWR _04456_ sky130_fd_sc_hd__inv_2
XFILLER_128_139 VGND VGND VPWR VPWR sky130_fd_sc_hd__fill_1
XFILLER_7_447 VGND VGND VPWR VPWR sky130_fd_sc_hd__fill_1
X_11463_ net247 _04379_ VGND VGND VPWR VPWR _04381_ sky130_fd_sc_hd__xor2_1
XFILLER_109_375 VGND VGND VPWR VPWR sky130_fd_sc_hd__decap_6
XFILLER_109_353 VGND VGND VPWR VPWR sky130_fd_sc_hd__decap_8
XFILLER_99_55 VGND VGND VPWR VPWR sky130_fd_sc_hd__fill_1
X_10414_ _03230_ _03232_ _03233_ VGND VGND VPWR VPWR _03234_ sky130_fd_sc_hd__nand3b_1
X_13202_ _06274_ _06275_ VGND VGND VPWR VPWR _06276_ sky130_fd_sc_hd__or2_1
XFILLER_109_386 VGND VGND VPWR VPWR sky130_fd_sc_hd__decap_6
X_11394_ _04303_ _04304_ VGND VGND VPWR VPWR _04305_ sky130_fd_sc_hd__nor2_1
X_13133_ _06038_ _06075_ _06037_ VGND VGND VPWR VPWR _06201_ sky130_fd_sc_hd__a21boi_1
XFILLER_112_507 VGND VGND VPWR VPWR sky130_fd_sc_hd__decap_3
XFILLER_99_99 VPWR VGND VPWR VGND sky130_ef_sc_hd__decap_12
X_10345_ _03127_ _03128_ _03157_ _03158_ VGND VGND VPWR VPWR _03160_ sky130_fd_sc_hd__o22a_2
XFILLER_3_653 VPWR VGND VPWR VGND sky130_ef_sc_hd__decap_12
XTAP_TAPCELL_ROW_111_1846 VGND VPWR sky130_fd_sc_hd__tapvpwrvgnd_1
XFILLER_97_218 VGND VGND VPWR VPWR sky130_fd_sc_hd__decap_6
XPHY_EDGE_ROW_70_Right_70 VGND VGND VPWR VPWR sky130_fd_sc_hd__decap_3
X_10276_ _03058_ _03082_ VGND VGND VPWR VPWR _03084_ sky130_fd_sc_hd__and2b_1
X_13064_ _06114_ _06123_ VGND VGND VPWR VPWR _06125_ sky130_fd_sc_hd__xnor2_1
XFILLER_3_697 VPWR VGND VPWR VGND sky130_ef_sc_hd__decap_12
XFILLER_2_141 VPWR VGND VPWR VGND sky130_ef_sc_hd__decap_12
X_12015_ _04975_ _04976_ _04978_ VGND VGND VPWR VPWR _04980_ sky130_fd_sc_hd__a21o_1
XFILLER_120_562 VGND VGND VPWR VPWR sky130_fd_sc_hd__decap_3
XFILLER_66_616 VGND VGND VPWR VPWR sky130_fd_sc_hd__decap_8
XFILLER_65_104 VGND VGND VPWR VPWR sky130_fd_sc_hd__fill_1
XFILLER_48_70 VGND VGND VPWR VPWR sky130_fd_sc_hd__decap_6
XFILLER_38_307 VGND VGND VPWR VPWR sky130_fd_sc_hd__fill_1
XFILLER_93_424 VGND VGND VPWR VPWR sky130_fd_sc_hd__decap_3
XFILLER_78_498 VPWR VGND VPWR VGND sky130_ef_sc_hd__decap_12
XFILLER_48_81 VGND VGND VPWR VPWR sky130_fd_sc_hd__decap_3
XFILLER_46_351 VGND VGND VPWR VPWR sky130_fd_sc_hd__decap_4
XFILLER_46_362 VGND VGND VPWR VPWR sky130_fd_sc_hd__fill_2
X_12917_ net290 net362 _05864_ VGND VGND VPWR VPWR _05965_ sky130_fd_sc_hd__a21oi_1
XFILLER_0_55 VGND VGND VPWR VPWR sky130_fd_sc_hd__fill_1
XFILLER_73_192 VGND VGND VPWR VPWR sky130_fd_sc_hd__fill_1
X_12848_ _05756_ _05765_ _05764_ VGND VGND VPWR VPWR _05890_ sky130_fd_sc_hd__a21o_1
XFILLER_61_387 VGND VGND VPWR VPWR sky130_fd_sc_hd__decap_4
XFILLER_21_207 VGND VGND VPWR VPWR sky130_fd_sc_hd__decap_4
XFILLER_21_218 VGND VGND VPWR VPWR sky130_fd_sc_hd__decap_6
XFILLER_34_579 VGND VGND VPWR VPWR sky130_fd_sc_hd__decap_8
XTAP_TAPCELL_ROW_122_1997 VGND VPWR sky130_fd_sc_hd__tapvpwrvgnd_1
X_12779_ _05486_ _05658_ _05487_ _05814_ _05657_ VGND VGND VPWR VPWR _05815_ sky130_fd_sc_hd__o311a_4
XTAP_TAPCELL_ROW_32_736 VGND VPWR sky130_fd_sc_hd__tapvpwrvgnd_1
XTAP_TAPCELL_ROW_32_747 VGND VPWR sky130_fd_sc_hd__tapvpwrvgnd_1
XFILLER_30_752 VGND VGND VPWR VPWR sky130_fd_sc_hd__decap_4
XFILLER_119_139 VPWR VGND VPWR VGND sky130_ef_sc_hd__decap_12
XTAP_TAPCELL_ROW_12_460 VGND VPWR sky130_fd_sc_hd__tapvpwrvgnd_1
XFILLER_134_109 VPWR VGND VPWR VGND sky130_ef_sc_hd__decap_12
XFILLER_115_312 VGND VGND VPWR VPWR sky130_fd_sc_hd__decap_6
X_09990_ _02774_ _02775_ VGND VGND VPWR VPWR _02776_ sky130_fd_sc_hd__xnor2_1
XTAP_TAPCELL_ROW_73_1318 VGND VPWR sky130_fd_sc_hd__tapvpwrvgnd_1
X_08941_ _01663_ _01664_ _01666_ VGND VGND VPWR VPWR _01667_ sky130_fd_sc_hd__nand3_1
XFILLER_130_359 VGND VGND VPWR VPWR sky130_fd_sc_hd__decap_4
X_08872_ net271 _02197_ VGND VGND VPWR VPWR _01598_ sky130_fd_sc_hd__nor2_1
X_07823_ _00560_ _00561_ VGND VGND VPWR VPWR _00562_ sky130_fd_sc_hd__and2b_1
XFILLER_111_551 VGND VGND VPWR VPWR sky130_fd_sc_hd__fill_1
XFILLER_97_785 VPWR VGND VPWR VGND sky130_ef_sc_hd__decap_12
XFILLER_111_595 VPWR VGND VPWR VGND sky130_ef_sc_hd__decap_12
XFILLER_111_584 VGND VGND VPWR VPWR sky130_fd_sc_hd__fill_2
X_07754_ net453 _00184_ _00186_ _00347_ VGND VGND VPWR VPWR _00493_ sky130_fd_sc_hd__a2bb2o_1
X_07685_ _00423_ _00422_ _00268_ _00270_ VGND VGND VPWR VPWR _00425_ sky130_fd_sc_hd__a211o_1
X_06705_ net390 net695 net613 net469 VGND VGND VPWR VPWR _02316_ sky130_fd_sc_hd__a22o_1
XFILLER_65_671 VGND VGND VPWR VPWR sky130_fd_sc_hd__fill_1
X_09424_ _02129_ _02159_ VGND VGND VPWR VPWR _02161_ sky130_fd_sc_hd__xnor2_1
XTAP_TAPCELL_ROW_84_1469 VGND VPWR sky130_fd_sc_hd__tapvpwrvgnd_1
XFILLER_80_630 VGND VGND VPWR VPWR sky130_fd_sc_hd__decap_4
X_09355_ _02083_ _02084_ VGND VGND VPWR VPWR _02085_ sky130_fd_sc_hd__nor2_1
XFILLER_40_549 VPWR VGND VPWR VGND sky130_ef_sc_hd__decap_12
X_08306_ _00985_ _00986_ _01017_ VGND VGND VPWR VPWR _01040_ sky130_fd_sc_hd__o21a_1
X_09286_ net414 net552 VGND VGND VPWR VPWR _02010_ sky130_fd_sc_hd__nand2_1
XFILLER_20_251 VGND VGND VPWR VPWR sky130_fd_sc_hd__fill_1
X_08237_ _00186_ _00971_ VGND VGND VPWR VPWR _00972_ sky130_fd_sc_hd__xnor2_1
XFILLER_21_785 VPWR VGND VPWR VGND sky130_ef_sc_hd__decap_12
XFILLER_119_673 VGND VGND VPWR VPWR sky130_fd_sc_hd__fill_2
Xclkbuf_3_0__f_clk clknet_0_clk VGND VGND VPWR VPWR clknet_3_0__leaf_clk sky130_fd_sc_hd__clkbuf_16
X_08168_ _00669_ _00756_ VGND VGND VPWR VPWR _00904_ sky130_fd_sc_hd__nand2_1
XFILLER_134_643 VGND VGND VPWR VPWR sky130_fd_sc_hd__fill_1
XFILLER_118_194 VGND VGND VPWR VPWR sky130_fd_sc_hd__fill_2
X_07119_ net685 net498 net505 net683 VGND VGND VPWR VPWR _06411_ sky130_fd_sc_hd__a22o_1
X_08099_ _02109_ net374 net373 net287 VGND VGND VPWR VPWR _00835_ sky130_fd_sc_hd__and4_1
XFILLER_79_218 VGND VGND VPWR VPWR sky130_fd_sc_hd__decap_6
XFILLER_69_69 VPWR VGND VPWR VGND sky130_ef_sc_hd__decap_12
X_10130_ _02923_ _02924_ VGND VGND VPWR VPWR _02925_ sky130_fd_sc_hd__nor2_1
XFILLER_0_601 VPWR VGND VPWR VGND sky130_ef_sc_hd__decap_12
XFILLER_121_359 VGND VGND VPWR VPWR sky130_fd_sc_hd__fill_1
X_10061_ _02848_ _02849_ VGND VGND VPWR VPWR _02850_ sky130_fd_sc_hd__and2_1
XFILLER_0_645 VPWR VGND VPWR VGND sky130_ef_sc_hd__decap_12
XFILLER_87_262 VPWR VGND VPWR VGND sky130_ef_sc_hd__decap_12
XFILLER_75_435 VGND VGND VPWR VPWR sky130_fd_sc_hd__decap_3
XTAP_TAPCELL_ROW_126_2064 VGND VPWR sky130_fd_sc_hd__tapvpwrvgnd_1
XTAP_TAPCELL_ROW_126_2053 VGND VPWR sky130_fd_sc_hd__tapvpwrvgnd_1
X_10963_ _03800_ _03833_ _03834_ VGND VGND VPWR VPWR _03835_ sky130_fd_sc_hd__nand3_1
XFILLER_16_557 VGND VGND VPWR VPWR sky130_fd_sc_hd__fill_1
X_12702_ _05195_ _05729_ VGND VGND VPWR VPWR _05730_ sky130_fd_sc_hd__xnor2_1
XFILLER_43_365 VGND VGND VPWR VPWR sky130_fd_sc_hd__fill_2
X_10894_ _03755_ _03756_ _03757_ VGND VGND VPWR VPWR _03759_ sky130_fd_sc_hd__a21o_1
X_12633_ _05652_ _05653_ _05307_ VGND VGND VPWR VPWR _05655_ sky130_fd_sc_hd__a21o_1
XFILLER_8_701 VPWR VGND VPWR VGND sky130_ef_sc_hd__decap_12
XFILLER_34_83 VGND VGND VPWR VPWR sky130_fd_sc_hd__fill_1
X_12564_ _05543_ _05578_ VGND VGND VPWR VPWR _05579_ sky130_fd_sc_hd__and2_1
X_11515_ _04435_ _04436_ VGND VGND VPWR VPWR _04437_ sky130_fd_sc_hd__nor2_1
X_12495_ net640 net293 _05322_ _05321_ VGND VGND VPWR VPWR _05503_ sky130_fd_sc_hd__a31o_1
XFILLER_50_82 VGND VGND VPWR VPWR sky130_fd_sc_hd__fill_2
X_11446_ _04253_ _04268_ _04267_ VGND VGND VPWR VPWR _04362_ sky130_fd_sc_hd__o21ai_1
X_11377_ _04284_ _04285_ VGND VGND VPWR VPWR _04288_ sky130_fd_sc_hd__and2_1
XFILLER_124_153 VGND VGND VPWR VPWR sky130_fd_sc_hd__decap_8
XFILLER_98_527 VGND VGND VPWR VPWR sky130_fd_sc_hd__decap_4
X_10328_ _03139_ _03138_ _03141_ VGND VGND VPWR VPWR _03142_ sky130_fd_sc_hd__or3_4
XFILLER_3_461 VPWR VGND VPWR VGND sky130_ef_sc_hd__decap_12
X_13116_ _05689_ _06181_ VGND VGND VPWR VPWR _06182_ sky130_fd_sc_hd__nand2_1
XTAP_TAPCELL_ROW_55_1059 VGND VPWR sky130_fd_sc_hd__tapvpwrvgnd_1
X_13047_ _06099_ _06104_ VGND VGND VPWR VPWR _06107_ sky130_fd_sc_hd__xnor2_1
X_10259_ _02886_ _03064_ VGND VGND VPWR VPWR _03066_ sky130_fd_sc_hd__or2_1
XFILLER_93_210 VGND VGND VPWR VPWR sky130_fd_sc_hd__decap_3
XFILLER_93_265 VGND VGND VPWR VPWR sky130_fd_sc_hd__fill_1
XTAP_TAPCELL_ROW_37_806 VGND VPWR sky130_fd_sc_hd__tapvpwrvgnd_1
XFILLER_81_416 VPWR VGND VPWR VGND sky130_ef_sc_hd__decap_12
XFILLER_47_660 VPWR VGND VPWR VGND sky130_ef_sc_hd__decap_12
XTAP_TAPCELL_ROW_37_817 VGND VPWR sky130_fd_sc_hd__tapvpwrvgnd_1
XFILLER_81_449 VGND VGND VPWR VPWR sky130_fd_sc_hd__decap_6
XFILLER_62_630 VGND VGND VPWR VPWR sky130_fd_sc_hd__decap_8
XFILLER_46_170 VPWR VGND VPWR VGND sky130_ef_sc_hd__decap_12
XTAP_TAPCELL_ROW_17_530 VGND VPWR sky130_fd_sc_hd__tapvpwrvgnd_1
XFILLER_34_321 VGND VGND VPWR VPWR sky130_fd_sc_hd__decap_6
X_07470_ _02011_ net373 _06596_ _06594_ VGND VGND VPWR VPWR _00211_ sky130_fd_sc_hd__a31o_1
XFILLER_50_803 VGND VGND VPWR VPWR sky130_fd_sc_hd__fill_1
XFILLER_34_365 VGND VGND VPWR VPWR sky130_fd_sc_hd__decap_4
XFILLER_62_696 VGND VGND VPWR VPWR sky130_fd_sc_hd__decap_4
XFILLER_61_173 VGND VGND VPWR VPWR sky130_fd_sc_hd__fill_1
X_09140_ _01857_ _01864_ VGND VGND VPWR VPWR _01865_ sky130_fd_sc_hd__xor2_1
X_09071_ _01795_ _01794_ VGND VGND VPWR VPWR _01796_ sky130_fd_sc_hd__nand2b_1
X_08022_ _00646_ _00648_ _00645_ VGND VGND VPWR VPWR _00759_ sky130_fd_sc_hd__o21ba_1
XFILLER_135_429 VPWR VGND VPWR VGND sky130_ef_sc_hd__decap_12
XFILLER_89_505 VPWR VGND VPWR VGND sky130_ef_sc_hd__decap_12
XFILLER_115_153 VPWR VGND VPWR VGND sky130_ef_sc_hd__decap_12
X_09973_ _02688_ _02695_ _02694_ VGND VGND VPWR VPWR _02757_ sky130_fd_sc_hd__a21oi_1
XFILLER_89_527 VGND VGND VPWR VPWR sky130_fd_sc_hd__decap_4
XFILLER_103_337 VGND VGND VPWR VPWR sky130_fd_sc_hd__fill_1
X_08924_ _01648_ _01649_ VGND VGND VPWR VPWR _01650_ sky130_fd_sc_hd__xnor2_1
X_08855_ _01579_ _01580_ _01362_ _01364_ VGND VGND VPWR VPWR _01582_ sky130_fd_sc_hd__a211oi_2
XFILLER_85_733 VGND VGND VPWR VPWR sky130_fd_sc_hd__fill_1
XFILLER_69_273 VGND VGND VPWR VPWR sky130_fd_sc_hd__decap_6
X_08786_ _01505_ _01512_ VGND VGND VPWR VPWR _01513_ sky130_fd_sc_hd__nand2_1
XFILLER_85_788 VGND VGND VPWR VPWR sky130_fd_sc_hd__decap_4
X_07806_ net607 _00206_ VGND VGND VPWR VPWR _00545_ sky130_fd_sc_hd__and2_1
XPHY_EDGE_ROW_2_Right_2 VGND VGND VPWR VPWR sky130_fd_sc_hd__decap_3
XFILLER_29_159 VGND VGND VPWR VPWR sky130_fd_sc_hd__fill_2
X_07737_ _00343_ _00354_ _00353_ VGND VGND VPWR VPWR _00476_ sky130_fd_sc_hd__o21ai_1
XFILLER_85_799 VGND VGND VPWR VPWR sky130_fd_sc_hd__fill_1
XFILLER_72_438 VGND VGND VPWR VPWR sky130_fd_sc_hd__fill_1
XFILLER_37_181 VPWR VGND VPWR VGND sky130_ef_sc_hd__decap_12
X_07668_ _00246_ _00248_ _00405_ _00406_ VGND VGND VPWR VPWR _00408_ sky130_fd_sc_hd__o211ai_1
XFILLER_53_685 VPWR VGND VPWR VGND sky130_ef_sc_hd__decap_12
XFILLER_13_505 VGND VGND VPWR VPWR sky130_fd_sc_hd__fill_2
XFILLER_40_302 VGND VGND VPWR VPWR sky130_fd_sc_hd__decap_6
X_09407_ _02139_ _02140_ _02141_ VGND VGND VPWR VPWR _02143_ sky130_fd_sc_hd__and3_1
X_07599_ net497 net681 _00173_ _00172_ VGND VGND VPWR VPWR _00339_ sky130_fd_sc_hd__a31o_1
XFILLER_13_527 VPWR VGND VPWR VGND sky130_ef_sc_hd__decap_12
X_09338_ _01922_ _02065_ _02067_ VGND VGND VPWR VPWR _02068_ sky130_fd_sc_hd__nand3_1
XTAP_TAPCELL_ROW_97_1649 VGND VPWR sky130_fd_sc_hd__tapvpwrvgnd_1
X_09269_ _01992_ _01991_ VGND VGND VPWR VPWR _01993_ sky130_fd_sc_hd__nand2b_1
X_11300_ _04089_ _04104_ _04088_ VGND VGND VPWR VPWR _04203_ sky130_fd_sc_hd__a21bo_1
XFILLER_112_3 VPWR VGND VPWR VGND sky130_ef_sc_hd__decap_12
X_12280_ _05266_ _05267_ VGND VGND VPWR VPWR _05269_ sky130_fd_sc_hd__xnor2_1
XFILLER_20_41 VGND VGND VPWR VPWR sky130_fd_sc_hd__fill_1
X_11231_ net433 net153 VGND VGND VPWR VPWR _04128_ sky130_fd_sc_hd__and2b_1
XFILLER_136_41 VPWR VGND VPWR VGND sky130_ef_sc_hd__decap_12
X_11162_ _03889_ _04051_ VGND VGND VPWR VPWR _04052_ sky130_fd_sc_hd__xnor2_1
XFILLER_136_85 VPWR VGND VPWR VGND sky130_ef_sc_hd__decap_12
XFILLER_122_657 VGND VGND VPWR VPWR sky130_fd_sc_hd__decap_6
X_10113_ _02896_ _02905_ VGND VGND VPWR VPWR _02906_ sky130_fd_sc_hd__and2_1
XFILLER_121_167 VGND VGND VPWR VPWR sky130_fd_sc_hd__fill_1
X_11093_ _03975_ _03976_ VGND VGND VPWR VPWR _03977_ sky130_fd_sc_hd__xnor2_1
X_10044_ _02828_ _02829_ VGND VGND VPWR VPWR _02831_ sky130_fd_sc_hd__xnor2_1
XFILLER_48_424 VGND VGND VPWR VPWR sky130_fd_sc_hd__decap_8
XFILLER_0_497 VGND VGND VPWR VPWR sky130_fd_sc_hd__decap_3
XFILLER_29_50 VGND VGND VPWR VPWR sky130_fd_sc_hd__decap_6
XFILLER_75_265 VPWR VGND VPWR VGND sky130_ef_sc_hd__decap_12
XFILLER_63_405 VGND VGND VPWR VPWR sky130_fd_sc_hd__decap_8
XFILLER_63_449 VPWR VGND VPWR VGND sky130_ef_sc_hd__decap_12
XFILLER_56_490 VGND VGND VPWR VPWR sky130_fd_sc_hd__decap_4
X_11995_ _04956_ _04954_ _04787_ _04789_ VGND VGND VPWR VPWR _04958_ sky130_fd_sc_hd__o211a_4
XFILLER_16_321 VGND VGND VPWR VPWR sky130_fd_sc_hd__decap_3
XTAP_TAPCELL_ROW_106_1778 VGND VPWR sky130_fd_sc_hd__tapvpwrvgnd_1
XFILLER_90_268 VPWR VGND VPWR VGND sky130_ef_sc_hd__decap_12
XFILLER_44_652 VGND VGND VPWR VPWR sky130_fd_sc_hd__fill_1
X_10946_ _03643_ _03648_ _03641_ VGND VGND VPWR VPWR _03816_ sky130_fd_sc_hd__a21bo_1
XFILLER_71_493 VGND VGND VPWR VPWR sky130_fd_sc_hd__decap_3
X_10877_ _03739_ _03697_ VGND VGND VPWR VPWR _03741_ sky130_fd_sc_hd__nand2b_1
XFILLER_129_201 VPWR VGND VPWR VGND sky130_ef_sc_hd__decap_12
XFILLER_31_357 VGND VGND VPWR VPWR sky130_fd_sc_hd__fill_1
X_12616_ _05601_ _05634_ _05635_ VGND VGND VPWR VPWR _05636_ sky130_fd_sc_hd__nand3_1
XFILLER_12_560 VGND VGND VPWR VPWR sky130_fd_sc_hd__decap_6
XFILLER_12_582 VGND VGND VPWR VPWR sky130_fd_sc_hd__decap_6
XTAP_TAPCELL_ROW_42_886 VGND VPWR sky130_fd_sc_hd__tapvpwrvgnd_1
X_12547_ _05558_ _05559_ VGND VGND VPWR VPWR _05561_ sky130_fd_sc_hd__and2b_1
XANTENNA_3 _02077_ VGND VGND VPWR VPWR sky130_fd_sc_hd__diode_2
XFILLER_117_429 VGND VGND VPWR VPWR sky130_fd_sc_hd__decap_4
X_12478_ _05300_ _05485_ VGND VGND VPWR VPWR _05486_ sky130_fd_sc_hd__xnor2_2
XFILLER_8_586 VGND VGND VPWR VPWR sky130_fd_sc_hd__fill_2
XFILLER_6_65 VPWR VGND VPWR VGND sky130_ef_sc_hd__decap_12
X_11429_ net408 _03586_ _04343_ VGND VGND VPWR VPWR _04344_ sky130_fd_sc_hd__o21a_1
XFILLER_125_473 VGND VGND VPWR VPWR sky130_fd_sc_hd__decap_8
XFILLER_113_635 VPWR VGND VPWR VGND sky130_ef_sc_hd__decap_12
XFILLER_112_134 VGND VGND VPWR VPWR sky130_fd_sc_hd__decap_6
XFILLER_4_781 VPWR VGND VPWR VGND sky130_ef_sc_hd__decap_12
X_06970_ _05177_ _05188_ VGND VGND VPWR VPWR _05199_ sky130_fd_sc_hd__and2b_1
XFILLER_100_307 VGND VGND VPWR VPWR sky130_fd_sc_hd__fill_1
XFILLER_67_722 VGND VGND VPWR VPWR sky130_fd_sc_hd__decap_6
X_08640_ net530 net628 VGND VGND VPWR VPWR _01368_ sky130_fd_sc_hd__nand2_1
XFILLER_94_563 VPWR VGND VPWR VGND sky130_ef_sc_hd__decap_12
XFILLER_67_755 VGND VGND VPWR VPWR sky130_fd_sc_hd__fill_1
XFILLER_66_232 VPWR VGND VPWR VGND sky130_ef_sc_hd__decap_12
Xrebuffer26 _05964_ VGND VGND VPWR VPWR net726 sky130_fd_sc_hd__buf_1
XFILLER_67_788 VGND VGND VPWR VPWR sky130_fd_sc_hd__decap_3
XFILLER_54_427 VGND VGND VPWR VPWR sky130_fd_sc_hd__fill_1
XFILLER_54_416 VGND VGND VPWR VPWR sky130_fd_sc_hd__decap_4
Xrebuffer15 _04951_ VGND VGND VPWR VPWR net715 sky130_fd_sc_hd__buf_6
X_08571_ _01299_ _01295_ _01290_ _01292_ VGND VGND VPWR VPWR _01300_ sky130_fd_sc_hd__a211oi_4
Xrebuffer37 net735 VGND VGND VPWR VPWR net737 sky130_fd_sc_hd__dlymetal6s2s_1
Xrebuffer48 _03155_ VGND VGND VPWR VPWR net748 sky130_fd_sc_hd__dlymetal6s2s_1
X_07522_ _00259_ _00260_ _06640_ _06642_ VGND VGND VPWR VPWR _00263_ sky130_fd_sc_hd__o211ai_2
X_07453_ _00191_ _00192_ VGND VGND VPWR VPWR _00194_ sky130_fd_sc_hd__and2b_1
XTAP_TAPCELL_ROW_81_1428 VGND VPWR sky130_fd_sc_hd__tapvpwrvgnd_1
XFILLER_35_685 VPWR VGND VPWR VGND sky130_ef_sc_hd__decap_12
XFILLER_50_655 VPWR VGND VPWR VGND sky130_ef_sc_hd__decap_12
XFILLER_22_368 VGND VGND VPWR VPWR sky130_fd_sc_hd__decap_3
X_07384_ net619 net316 net306 net594 VGND VGND VPWR VPWR _06674_ sky130_fd_sc_hd__and4_1
X_09123_ _02011_ net324 _01685_ _01683_ VGND VGND VPWR VPWR _01848_ sky130_fd_sc_hd__a31o_1
Xrebuffer105 _05899_ VGND VGND VPWR VPWR net805 sky130_fd_sc_hd__dlygate4sd1_1
Xrebuffer116 net355 VGND VGND VPWR VPWR net816 sky130_fd_sc_hd__buf_8
Xrebuffer127 net826 VGND VGND VPWR VPWR net827 sky130_fd_sc_hd__buf_1
X_09054_ _01644_ _01653_ _01652_ VGND VGND VPWR VPWR _01779_ sky130_fd_sc_hd__a21bo_1
Xrebuffer149 net429 VGND VGND VPWR VPWR net849 sky130_fd_sc_hd__buf_1
XTAP_TAPCELL_ROW_20_569 VGND VPWR sky130_fd_sc_hd__tapvpwrvgnd_1
XFILLER_135_237 VPWR VGND VPWR VGND sky130_ef_sc_hd__decap_12
X_08005_ _00741_ _00731_ VGND VGND VPWR VPWR _00742_ sky130_fd_sc_hd__nand2b_1
XFILLER_104_602 VGND VGND VPWR VPWR sky130_fd_sc_hd__fill_2
XFILLER_89_302 VGND VGND VPWR VPWR sky130_fd_sc_hd__fill_2
XTAP_TAPCELL_ROW_92_1579 VGND VPWR sky130_fd_sc_hd__tapvpwrvgnd_1
XFILLER_1_217 VGND VGND VPWR VPWR sky130_fd_sc_hd__decap_6
X_09956_ _02510_ _02635_ _02508_ VGND VGND VPWR VPWR _02738_ sky130_fd_sc_hd__o21ai_1
X_08907_ _01629_ _01630_ VGND VGND VPWR VPWR _01633_ sky130_fd_sc_hd__xor2_1
X_09887_ _02558_ _02560_ _02662_ VGND VGND VPWR VPWR _02665_ sky130_fd_sc_hd__and3_1
XFILLER_58_744 VGND VGND VPWR VPWR sky130_fd_sc_hd__fill_2
XFILLER_57_210 VGND VGND VPWR VPWR sky130_fd_sc_hd__decap_4
XFILLER_106_99 VPWR VGND VPWR VGND sky130_ef_sc_hd__decap_12
XFILLER_85_541 VPWR VGND VPWR VGND sky130_ef_sc_hd__decap_12
X_08838_ _01562_ _01563_ _01545_ VGND VGND VPWR VPWR _01565_ sky130_fd_sc_hd__a21oi_1
XTAP_TAPCELL_ROW_123_2012 VGND VPWR sky130_fd_sc_hd__tapvpwrvgnd_1
XFILLER_85_585 VGND VGND VPWR VPWR sky130_fd_sc_hd__decap_8
XFILLER_58_799 VGND VGND VPWR VPWR sky130_fd_sc_hd__decap_3
XFILLER_57_265 VGND VGND VPWR VPWR sky130_fd_sc_hd__decap_4
XFILLER_45_405 VPWR VGND VPWR VGND sky130_ef_sc_hd__decap_12
XTAP_TAPCELL_ROW_123_2023 VGND VPWR sky130_fd_sc_hd__tapvpwrvgnd_1
XFILLER_122_65 VPWR VGND VPWR VGND sky130_ef_sc_hd__decap_12
X_08769_ net501 net629 VGND VGND VPWR VPWR _01496_ sky130_fd_sc_hd__nand2_1
XFILLER_45_449 VGND VGND VPWR VPWR sky130_fd_sc_hd__decap_4
XFILLER_60_419 VGND VGND VPWR VPWR sky130_fd_sc_hd__fill_1
X_11780_ net499 net106 net676 net507 VGND VGND VPWR VPWR _04723_ sky130_fd_sc_hd__a22o_1
XFILLER_14_803 VGND VGND VPWR VPWR sky130_fd_sc_hd__decap_8
X_10800_ _03634_ _03652_ _03655_ VGND VGND VPWR VPWR _03657_ sky130_fd_sc_hd__nand3_1
XTAP_TAPCELL_ROW_0_283 VGND VPWR sky130_fd_sc_hd__tapvpwrvgnd_1
XTAP_TAPCELL_ROW_0_294 VGND VPWR sky130_fd_sc_hd__tapvpwrvgnd_1
XFILLER_13_313 VGND VGND VPWR VPWR sky130_fd_sc_hd__decap_4
X_10731_ _03578_ _03579_ VGND VGND VPWR VPWR _03581_ sky130_fd_sc_hd__xor2_1
XFILLER_41_611 VGND VGND VPWR VPWR sky130_fd_sc_hd__decap_4
XFILLER_41_644 VGND VGND VPWR VPWR sky130_fd_sc_hd__decap_6
X_10662_ _03331_ _03328_ _03327_ VGND VGND VPWR VPWR _03506_ sky130_fd_sc_hd__a21o_1
XFILLER_15_96 VGND VGND VPWR VPWR sky130_fd_sc_hd__decap_6
X_12401_ _05366_ _05399_ VGND VGND VPWR VPWR _05401_ sky130_fd_sc_hd__xnor2_1
X_13381_ clknet_3_5__leaf_clk _00027_ _00091_ VGND VGND VPWR VPWR net180 sky130_fd_sc_hd__dfrtp_1
XFILLER_21_390 VGND VGND VPWR VPWR sky130_fd_sc_hd__fill_2
X_10593_ _03428_ _03429_ VGND VGND VPWR VPWR _03430_ sky130_fd_sc_hd__nor2_1
XFILLER_127_727 VGND VGND VPWR VPWR sky130_fd_sc_hd__fill_1
X_12332_ _05323_ _05324_ VGND VGND VPWR VPWR _05325_ sky130_fd_sc_hd__xnor2_1
XTAP_TAPCELL_ROW_134_2174 VGND VPWR sky130_fd_sc_hd__tapvpwrvgnd_1
X_12263_ net334 net44 net367 net359 VGND VGND VPWR VPWR _05250_ sky130_fd_sc_hd__a22o_1
X_11214_ _03971_ _03990_ _03989_ VGND VGND VPWR VPWR _04109_ sky130_fd_sc_hd__a21oi_1
X_12194_ _04870_ _04873_ _05013_ _05012_ _05002_ VGND VGND VPWR VPWR _05174_ sky130_fd_sc_hd__a32o_1
XTAP_TAPCELL_ROW_52_1029 VGND VPWR sky130_fd_sc_hd__tapvpwrvgnd_1
XTAP_TAPCELL_ROW_52_1018 VGND VPWR sky130_fd_sc_hd__tapvpwrvgnd_1
X_11145_ _04029_ _04030_ _04031_ VGND VGND VPWR VPWR _04033_ sky130_fd_sc_hd__o21ai_1
X_11076_ net375 net342 VGND VGND VPWR VPWR _03958_ sky130_fd_sc_hd__nand2b_1
X_10027_ net266 net686 net282 net280 VGND VGND VPWR VPWR _02814_ sky130_fd_sc_hd__and4_1
Xinput140 w31[2] VGND VGND VPWR VPWR net140 sky130_fd_sc_hd__dlymetal6s2s_1
Xinput151 w32[5] VGND VGND VPWR VPWR net151 sky130_fd_sc_hd__buf_1
XTAP_TAPCELL_ROW_108_1807 VGND VPWR sky130_fd_sc_hd__tapvpwrvgnd_1
XFILLER_49_799 VGND VGND VPWR VPWR sky130_fd_sc_hd__decap_8
XFILLER_48_276 VGND VGND VPWR VPWR sky130_fd_sc_hd__fill_2
XTAP_TAPCELL_ROW_47_956 VGND VPWR sky130_fd_sc_hd__tapvpwrvgnd_1
XFILLER_36_449 VGND VGND VPWR VPWR sky130_fd_sc_hd__decap_4
XFILLER_91_588 VPWR VGND VPWR VGND sky130_ef_sc_hd__decap_12
X_11978_ net357 net336 net370 net368 VGND VGND VPWR VPWR _04940_ sky130_fd_sc_hd__and4_1
XFILLER_44_471 VGND VGND VPWR VPWR sky130_fd_sc_hd__decap_4
X_10929_ _03797_ _03781_ VGND VGND VPWR VPWR _03798_ sky130_fd_sc_hd__and2b_1
XFILLER_16_195 VGND VGND VPWR VPWR sky130_fd_sc_hd__fill_1
XTAP_TAPCELL_ROW_119_1958 VGND VPWR sky130_fd_sc_hd__tapvpwrvgnd_1
XFILLER_117_237 VGND VGND VPWR VPWR sky130_fd_sc_hd__fill_1
XTAP_TAPCELL_ROW_78_1390 VGND VPWR sky130_fd_sc_hd__tapvpwrvgnd_1
XFILLER_126_793 VPWR VGND VPWR VGND sky130_ef_sc_hd__decap_12
XFILLER_125_281 VGND VGND VPWR VPWR sky130_fd_sc_hd__fill_1
XPHY_EDGE_ROW_99_Right_99 VGND VGND VPWR VPWR sky130_fd_sc_hd__decap_3
Xfanout307 net70 VGND VGND VPWR VPWR net307 sky130_fd_sc_hd__buf_1
X_09810_ _02579_ _02580_ VGND VGND VPWR VPWR _02581_ sky130_fd_sc_hd__nor2_1
Xfanout318 net68 VGND VGND VPWR VPWR net318 sky130_fd_sc_hd__clkbuf_4
XFILLER_113_443 VGND VGND VPWR VPWR sky130_fd_sc_hd__decap_4
XFILLER_99_688 VGND VGND VPWR VPWR sky130_fd_sc_hd__decap_6
Xfanout329 net61 VGND VGND VPWR VPWR net329 sky130_fd_sc_hd__buf_2
XFILLER_59_508 VPWR VGND VPWR VGND sky130_ef_sc_hd__decap_12
X_09741_ _02503_ _02502_ _02505_ _02499_ VGND VGND VPWR VPWR _02506_ sky130_fd_sc_hd__o31a_1
X_06953_ _04916_ _04960_ _04971_ VGND VGND VPWR VPWR _05014_ sky130_fd_sc_hd__o21ba_1
XFILLER_101_649 VGND VGND VPWR VPWR sky130_fd_sc_hd__decap_8
XFILLER_98_176 VPWR VGND VPWR VGND sky130_ef_sc_hd__decap_12
X_09672_ net423 _02219_ _01649_ VGND VGND VPWR VPWR _02430_ sky130_fd_sc_hd__o21ai_1
X_06884_ net519 net387 VGND VGND VPWR VPWR _04265_ sky130_fd_sc_hd__and2_1
XFILLER_27_405 VGND VGND VPWR VPWR sky130_fd_sc_hd__decap_8
XFILLER_36_18 VGND VGND VPWR VPWR sky130_fd_sc_hd__decap_8
X_08623_ _01349_ _01350_ VGND VGND VPWR VPWR _01351_ sky130_fd_sc_hd__and2b_1
XFILLER_82_533 VGND VGND VPWR VPWR sky130_fd_sc_hd__fill_1
XFILLER_27_449 VGND VGND VPWR VPWR sky130_fd_sc_hd__decap_4
XFILLER_36_29 VPWR VGND VPWR VGND sky130_ef_sc_hd__decap_12
X_08554_ net447 net558 VGND VGND VPWR VPWR _01283_ sky130_fd_sc_hd__and2_1
XFILLER_54_279 VPWR VGND VPWR VGND sky130_ef_sc_hd__decap_12
X_07505_ _00245_ VGND VGND VPWR VPWR _00246_ sky130_fd_sc_hd__inv_2
XFILLER_63_791 VGND VGND VPWR VPWR sky130_fd_sc_hd__fill_1
XTAP_TAPCELL_ROW_25_639 VGND VPWR sky130_fd_sc_hd__tapvpwrvgnd_1
XFILLER_35_482 VGND VGND VPWR VPWR sky130_fd_sc_hd__decap_8
X_08485_ _01212_ _01213_ VGND VGND VPWR VPWR _01214_ sky130_fd_sc_hd__nor2_1
X_07436_ net252 net477 _06560_ _06559_ VGND VGND VPWR VPWR _00177_ sky130_fd_sc_hd__a31o_1
XFILLER_50_474 VGND VGND VPWR VPWR sky130_fd_sc_hd__fill_2
XFILLER_10_316 VPWR VGND VPWR VGND sky130_ef_sc_hd__decap_12
X_07367_ _06496_ _06657_ VGND VGND VPWR VPWR _06658_ sky130_fd_sc_hd__nor2_1
XFILLER_109_727 VGND VGND VPWR VPWR sky130_fd_sc_hd__fill_1
XFILLER_109_716 VGND VGND VPWR VPWR sky130_fd_sc_hd__decap_6
XFILLER_108_204 VPWR VGND VPWR VGND sky130_ef_sc_hd__decap_12
X_09106_ _01830_ _01829_ VGND VGND VPWR VPWR _01831_ sky130_fd_sc_hd__nand2b_1
XFILLER_6_309 VPWR VGND VPWR VGND sky130_ef_sc_hd__decap_12
X_09037_ net670 net254 _02197_ net693 VGND VGND VPWR VPWR _01762_ sky130_fd_sc_hd__o2bb2a_1
XTAP_TAPCELL_ROW_94_1608 VGND VPWR sky130_fd_sc_hd__tapvpwrvgnd_1
X_07298_ net612 net411 VGND VGND VPWR VPWR _06589_ sky130_fd_sc_hd__nand2_1
XFILLER_104_421 VGND VGND VPWR VPWR sky130_fd_sc_hd__decap_4
XFILLER_104_410 VGND VGND VPWR VPWR sky130_fd_sc_hd__decap_3
XFILLER_89_154 VGND VGND VPWR VPWR sky130_fd_sc_hd__decap_6
XFILLER_104_498 VGND VGND VPWR VPWR sky130_fd_sc_hd__decap_8
XFILLER_77_69 VPWR VGND VPWR VGND sky130_ef_sc_hd__decap_12
X_09939_ _02718_ _02719_ VGND VGND VPWR VPWR _02721_ sky130_fd_sc_hd__xnor2_1
XFILLER_58_552 VGND VGND VPWR VPWR sky130_fd_sc_hd__fill_2
XTAP_TAPCELL_ROW_5_364 VGND VPWR sky130_fd_sc_hd__tapvpwrvgnd_1
XFILLER_100_660 VGND VGND VPWR VPWR sky130_fd_sc_hd__decap_4
X_12950_ _05989_ _05999_ VGND VGND VPWR VPWR _06001_ sky130_fd_sc_hd__xnor2_1
XFILLER_18_416 VGND VGND VPWR VPWR sky130_fd_sc_hd__decap_4
X_11901_ _04854_ VGND VGND VPWR VPWR _04855_ sky130_fd_sc_hd__inv_2
XFILLER_45_213 VGND VGND VPWR VPWR sky130_fd_sc_hd__fill_1
X_12881_ _05195_ _05925_ VGND VGND VPWR VPWR _05926_ sky130_fd_sc_hd__xnor2_1
X_11832_ net700 net44 _04617_ _04616_ VGND VGND VPWR VPWR _04780_ sky130_fd_sc_hd__a31o_1
XFILLER_45_268 VGND VGND VPWR VPWR sky130_fd_sc_hd__fill_1
XTAP_TAPCELL_ROW_44_915 VGND VPWR sky130_fd_sc_hd__tapvpwrvgnd_1
XTAP_TAPCELL_ROW_44_904 VGND VPWR sky130_fd_sc_hd__tapvpwrvgnd_1
XTAP_TAPCELL_ROW_103_1737 VGND VPWR sky130_fd_sc_hd__tapvpwrvgnd_1
XFILLER_60_249 VGND VGND VPWR VPWR sky130_fd_sc_hd__decap_3
X_11763_ _04677_ _04678_ _04679_ _04703_ VGND VGND VPWR VPWR _04704_ sky130_fd_sc_hd__a211o_1
XTAP_TAPCELL_ROW_136_2203 VGND VPWR sky130_fd_sc_hd__tapvpwrvgnd_1
X_11694_ _04627_ _04628_ VGND VGND VPWR VPWR _04629_ sky130_fd_sc_hd__or2_1
X_10714_ _03513_ _03561_ VGND VGND VPWR VPWR _03562_ sky130_fd_sc_hd__and2b_1
XFILLER_9_103 VGND VGND VPWR VPWR sky130_fd_sc_hd__decap_4
XTAP_TAPCELL_ROW_136_2214 VGND VPWR sky130_fd_sc_hd__tapvpwrvgnd_1
X_10645_ _03424_ _03485_ VGND VGND VPWR VPWR _03487_ sky130_fd_sc_hd__xnor2_1
XFILLER_42_50 VGND VGND VPWR VPWR sky130_fd_sc_hd__decap_6
X_13364_ clknet_3_2__leaf_clk _00039_ _00074_ VGND VGND VPWR VPWR net163 sky130_fd_sc_hd__dfrtp_1
XFILLER_127_513 VGND VGND VPWR VPWR sky130_fd_sc_hd__fill_2
XFILLER_127_546 VGND VGND VPWR VPWR sky130_fd_sc_hd__fill_1
Xrebuffer6 net705 VGND VGND VPWR VPWR net706 sky130_fd_sc_hd__dlymetal6s2s_1
X_12315_ _05142_ _05160_ _05158_ VGND VGND VPWR VPWR _05306_ sky130_fd_sc_hd__o21a_1
X_10576_ _03242_ _03409_ _03410_ VGND VGND VPWR VPWR _03411_ sky130_fd_sc_hd__nand3b_1
X_13295_ net399 VGND VGND VPWR VPWR _00069_ sky130_fd_sc_hd__inv_2
XFILLER_108_793 VPWR VGND VPWR VGND sky130_ef_sc_hd__decap_12
XFILLER_107_281 VGND VGND VPWR VPWR sky130_fd_sc_hd__decap_6
X_12246_ net428 net48 VGND VGND VPWR VPWR _05231_ sky130_fd_sc_hd__nand2_1
XTAP_TAPCELL_ROW_114_1888 VGND VPWR sky130_fd_sc_hd__tapvpwrvgnd_1
X_12177_ _05152_ _05153_ VGND VGND VPWR VPWR _05156_ sky130_fd_sc_hd__xnor2_1
XFILLER_123_785 VPWR VGND VPWR VGND sky130_ef_sc_hd__decap_12
XFILLER_122_262 VGND VGND VPWR VPWR sky130_fd_sc_hd__fill_1
XFILLER_95_113 VPWR VGND VPWR VGND sky130_ef_sc_hd__decap_12
X_11128_ _04011_ _04012_ VGND VGND VPWR VPWR _04016_ sky130_fd_sc_hd__xor2_2
XFILLER_3_55 VGND VGND VPWR VPWR sky130_fd_sc_hd__fill_1
XFILLER_122_295 VPWR VGND VPWR VGND sky130_ef_sc_hd__decap_12
XFILLER_110_435 VGND VGND VPWR VPWR sky130_fd_sc_hd__decap_4
XFILLER_96_658 VGND VGND VPWR VPWR sky130_fd_sc_hd__fill_1
XFILLER_95_146 VPWR VGND VPWR VGND sky130_ef_sc_hd__decap_12
X_11059_ _03909_ _03939_ VGND VGND VPWR VPWR _03940_ sky130_fd_sc_hd__and2b_1
XFILLER_37_725 VGND VGND VPWR VPWR sky130_fd_sc_hd__decap_3
XFILLER_64_533 VGND VGND VPWR VPWR sky130_fd_sc_hd__fill_2
XTAP_TAPCELL_ROW_65_1209 VGND VPWR sky130_fd_sc_hd__tapvpwrvgnd_1
XFILLER_44_290 VGND VGND VPWR VPWR sky130_fd_sc_hd__decap_4
XFILLER_32_441 VGND VGND VPWR VPWR sky130_fd_sc_hd__decap_6
X_08270_ _00999_ _01004_ VGND VGND VPWR VPWR _01005_ sky130_fd_sc_hd__xnor2_1
XTAP_TAPCELL_ROW_22_609 VGND VPWR sky130_fd_sc_hd__tapvpwrvgnd_1
X_07221_ _06511_ VGND VGND VPWR VPWR _06512_ sky130_fd_sc_hd__inv_2
XFILLER_20_658 VGND VGND VPWR VPWR sky130_fd_sc_hd__fill_1
X_07152_ _05669_ _05691_ _05680_ VGND VGND VPWR VPWR _06444_ sky130_fd_sc_hd__o21bai_1
XFILLER_20_669 VGND VGND VPWR VPWR sky130_fd_sc_hd__decap_3
XFILLER_9_681 VGND VGND VPWR VPWR sky130_fd_sc_hd__fill_1
XFILLER_133_505 VPWR VGND VPWR VGND sky130_ef_sc_hd__decap_12
X_07083_ _06372_ _06373_ VGND VGND VPWR VPWR _06375_ sky130_fd_sc_hd__xnor2_1
XFILLER_114_730 VGND VGND VPWR VPWR sky130_fd_sc_hd__fill_1
XFILLER_113_262 VGND VGND VPWR VPWR sky130_fd_sc_hd__decap_6
XFILLER_101_424 VGND VGND VPWR VPWR sky130_fd_sc_hd__decap_4
XFILLER_99_485 VGND VGND VPWR VPWR sky130_fd_sc_hd__decap_8
XFILLER_59_316 VGND VGND VPWR VPWR sky130_fd_sc_hd__fill_1
X_07985_ _06588_ _00721_ VGND VGND VPWR VPWR _00722_ sky130_fd_sc_hd__xnor2_1
X_09724_ _02485_ _02486_ VGND VGND VPWR VPWR _02487_ sky130_fd_sc_hd__and2b_1
X_06936_ _03707_ _04807_ _04818_ VGND VGND VPWR VPWR _04829_ sky130_fd_sc_hd__nand3_2
XFILLER_86_168 VGND VGND VPWR VPWR sky130_fd_sc_hd__fill_1
XTAP_TAPCELL_ROW_2_323 VGND VPWR sky130_fd_sc_hd__tapvpwrvgnd_1
XFILLER_103_23 VGND VGND VPWR VPWR sky130_fd_sc_hd__fill_2
X_06867_ net470 net607 _03992_ _04003_ VGND VGND VPWR VPWR _04079_ sky130_fd_sc_hd__o2bb2a_1
X_09655_ _02400_ _02409_ VGND VGND VPWR VPWR _02411_ sky130_fd_sc_hd__xnor2_1
XFILLER_67_393 VPWR VGND VPWR VGND sky130_ef_sc_hd__decap_12
X_08606_ _01161_ _01333_ VGND VGND VPWR VPWR _01335_ sky130_fd_sc_hd__nor2_1
XFILLER_82_363 VGND VGND VPWR VPWR sky130_fd_sc_hd__fill_1
X_06798_ _03259_ _03314_ VGND VGND VPWR VPWR _03325_ sky130_fd_sc_hd__xnor2_1
X_09586_ net447 _01822_ _01824_ _02150_ VGND VGND VPWR VPWR _02337_ sky130_fd_sc_hd__a2bb2o_1
XFILLER_82_396 VGND VGND VPWR VPWR sky130_fd_sc_hd__decap_8
XFILLER_63_27 VGND VGND VPWR VPWR sky130_fd_sc_hd__decap_4
XFILLER_27_279 VGND VGND VPWR VPWR sky130_fd_sc_hd__fill_1
X_08537_ _01263_ _01264_ _01262_ VGND VGND VPWR VPWR _01266_ sky130_fd_sc_hd__o21bai_1
X_08468_ _01195_ _01196_ VGND VGND VPWR VPWR _01197_ sky130_fd_sc_hd__nor2_1
XFILLER_51_783 VGND VGND VPWR VPWR sky130_fd_sc_hd__fill_1
XFILLER_11_603 VPWR VGND VPWR VGND sky130_ef_sc_hd__decap_12
X_07419_ _00139_ _00159_ VGND VGND VPWR VPWR _00160_ sky130_fd_sc_hd__nand2b_1
X_08399_ _01097_ _01127_ VGND VGND VPWR VPWR _01129_ sky130_fd_sc_hd__xnor2_1
X_10430_ _03127_ _03250_ VGND VGND VPWR VPWR _03252_ sky130_fd_sc_hd__or2_1
XFILLER_7_629 VPWR VGND VPWR VGND sky130_ef_sc_hd__decap_12
XFILLER_136_343 VGND VGND VPWR VPWR sky130_fd_sc_hd__decap_3
XFILLER_10_179 VGND VGND VPWR VPWR sky130_fd_sc_hd__fill_2
XFILLER_136_365 VGND VGND VPWR VPWR sky130_fd_sc_hd__fill_2
XTAP_TAPCELL_ROW_131_2133 VGND VPWR sky130_fd_sc_hd__tapvpwrvgnd_1
XTAP_TAPCELL_ROW_131_2122 VGND VPWR sky130_fd_sc_hd__tapvpwrvgnd_1
XFILLER_128_53 VPWR VGND VPWR VGND sky130_ef_sc_hd__decap_12
X_10361_ _03045_ _03048_ _03044_ VGND VGND VPWR VPWR _03178_ sky130_fd_sc_hd__o21bai_1
XFILLER_12_64 VPWR VGND VPWR VGND sky130_ef_sc_hd__decap_12
XFILLER_128_97 VPWR VGND VPWR VGND sky130_ef_sc_hd__decap_12
X_10292_ net495 net655 _03101_ _03100_ _02931_ VGND VGND VPWR VPWR _03102_ sky130_fd_sc_hd__a32o_1
X_12100_ _05069_ _05070_ _05061_ VGND VGND VPWR VPWR _05072_ sky130_fd_sc_hd__a21o_1
XFILLER_2_301 VGND VGND VPWR VPWR sky130_fd_sc_hd__decap_6
X_13080_ net412 _05386_ _06142_ VGND VGND VPWR VPWR _06143_ sky130_fd_sc_hd__o21a_1
X_12031_ net269 net285 _04995_ VGND VGND VPWR VPWR _04997_ sky130_fd_sc_hd__nand3_1
XFILLER_5_3 VPWR VGND VPWR VGND sky130_ef_sc_hd__decap_12
XFILLER_2_345 VPWR VGND VPWR VGND sky130_ef_sc_hd__decap_12
XFILLER_105_785 VPWR VGND VPWR VGND sky130_ef_sc_hd__decap_12
XFILLER_104_273 VGND VGND VPWR VPWR sky130_fd_sc_hd__decap_8
XFILLER_77_113 VGND VGND VPWR VPWR sky130_fd_sc_hd__decap_6
XFILLER_2_389 VPWR VGND VPWR VGND sky130_ef_sc_hd__decap_12
XFILLER_120_733 VGND VGND VPWR VPWR sky130_fd_sc_hd__fill_2
XFILLER_78_669 VGND VGND VPWR VPWR sky130_fd_sc_hd__decap_8
Xfanout660 net111 VGND VGND VPWR VPWR net660 sky130_fd_sc_hd__buf_2
Xfanout693 net10 VGND VGND VPWR VPWR net693 sky130_fd_sc_hd__dlymetal6s2s_1
Xfanout671 net11 VGND VGND VPWR VPWR net671 sky130_fd_sc_hd__buf_4
Xfanout682 net101 VGND VGND VPWR VPWR net682 sky130_fd_sc_hd__buf_2
XFILLER_65_319 VPWR VGND VPWR VGND sky130_ef_sc_hd__decap_12
XTAP_TAPCELL_ROW_129_2095 VGND VPWR sky130_fd_sc_hd__tapvpwrvgnd_1
XFILLER_92_138 VGND VGND VPWR VPWR sky130_fd_sc_hd__fill_2
XFILLER_58_393 VPWR VGND VPWR VGND sky130_ef_sc_hd__decap_12
X_12933_ _05970_ _05981_ VGND VGND VPWR VPWR _05982_ sky130_fd_sc_hd__nor2_1
XFILLER_19_725 VGND VGND VPWR VPWR sky130_fd_sc_hd__decap_3
XFILLER_61_503 VGND VGND VPWR VPWR sky130_fd_sc_hd__fill_1
XFILLER_18_257 VGND VGND VPWR VPWR sky130_fd_sc_hd__fill_1
XFILLER_73_396 VGND VGND VPWR VPWR sky130_fd_sc_hd__decap_4
XFILLER_46_599 VPWR VGND VPWR VGND sky130_ef_sc_hd__decap_12
X_12864_ _05772_ _05791_ _05789_ VGND VGND VPWR VPWR _05907_ sky130_fd_sc_hd__a21oi_1
XFILLER_61_569 VGND VGND VPWR VPWR sky130_fd_sc_hd__fill_2
XFILLER_61_558 VGND VGND VPWR VPWR sky130_fd_sc_hd__fill_2
X_11815_ net698 net515 net366 net364 VGND VGND VPWR VPWR _04761_ sky130_fd_sc_hd__and4_1
X_12795_ _05829_ _05830_ VGND VGND VPWR VPWR _05831_ sky130_fd_sc_hd__nand2_1
X_11746_ _04683_ _04684_ VGND VGND VPWR VPWR _04685_ sky130_fd_sc_hd__nor2_1
XTAP_TAPCELL_ROW_60_1139 VGND VPWR sky130_fd_sc_hd__tapvpwrvgnd_1
XTAP_TAPCELL_ROW_60_1128 VGND VPWR sky130_fd_sc_hd__tapvpwrvgnd_1
XFILLER_41_293 VPWR VGND VPWR VGND sky130_ef_sc_hd__decap_12
X_11677_ _04609_ _04610_ VGND VGND VPWR VPWR _04612_ sky130_fd_sc_hd__nand2_1
X_13416_ clknet_3_6__leaf_clk _00056_ _00126_ VGND VGND VPWR VPWR net215 sky130_fd_sc_hd__dfrtp_1
XTAP_TAPCELL_ROW_116_1917 VGND VPWR sky130_fd_sc_hd__tapvpwrvgnd_1
X_10628_ _03466_ _03468_ VGND VGND VPWR VPWR _03469_ sky130_fd_sc_hd__and2b_1
XFILLER_127_376 VGND VGND VPWR VPWR sky130_fd_sc_hd__decap_3
X_13347_ net398 VGND VGND VPWR VPWR _00121_ sky130_fd_sc_hd__inv_2
XFILLER_115_505 VPWR VGND VPWR VGND sky130_ef_sc_hd__decap_12
X_10559_ net467 net153 VGND VGND VPWR VPWR _03393_ sky130_fd_sc_hd__and2b_1
XFILLER_127_398 VGND VGND VPWR VPWR sky130_fd_sc_hd__decap_6
X_13278_ _06245_ _06264_ _06263_ VGND VGND VPWR VPWR _06358_ sky130_fd_sc_hd__a21oi_1
XFILLER_5_161 VGND VGND VPWR VPWR sky130_fd_sc_hd__decap_6
X_12229_ net250 _04914_ net677 net500 _04901_ VGND VGND VPWR VPWR _05213_ sky130_fd_sc_hd__o2111a_1
XFILLER_123_582 VGND VGND VPWR VPWR sky130_fd_sc_hd__decap_6
XFILLER_111_711 VGND VGND VPWR VPWR sky130_fd_sc_hd__fill_1
XFILLER_38_3 VGND VGND VPWR VPWR sky130_fd_sc_hd__fill_2
XFILLER_111_777 VGND VGND VPWR VPWR sky130_fd_sc_hd__decap_6
XFILLER_96_477 VGND VGND VPWR VPWR sky130_fd_sc_hd__fill_2
X_07770_ net385 net383 net309 net287 VGND VGND VPWR VPWR _00509_ sky130_fd_sc_hd__and4_1
X_06721_ _02338_ _02468_ VGND VGND VPWR VPWR _02490_ sky130_fd_sc_hd__or2_1
XFILLER_49_393 VGND VGND VPWR VPWR sky130_fd_sc_hd__decap_4
XFILLER_49_371 VGND VGND VPWR VPWR sky130_fd_sc_hd__fill_2
XFILLER_64_341 VPWR VGND VPWR VGND sky130_ef_sc_hd__decap_12
X_09440_ net786 net324 VGND VGND VPWR VPWR _02179_ sky130_fd_sc_hd__and2b_1
XFILLER_24_216 VGND VGND VPWR VPWR sky130_fd_sc_hd__decap_4
XFILLER_25_739 VGND VGND VPWR VPWR sky130_fd_sc_hd__fill_2
X_09371_ _01931_ _01936_ _02102_ VGND VGND VPWR VPWR _02103_ sky130_fd_sc_hd__a21oi_1
X_08322_ _00831_ _00949_ _00830_ VGND VGND VPWR VPWR _01056_ sky130_fd_sc_hd__a21bo_1
XTAP_TAPCELL_ROW_35_778 VGND VPWR sky130_fd_sc_hd__tapvpwrvgnd_1
XTAP_TAPCELL_ROW_35_789 VGND VPWR sky130_fd_sc_hd__tapvpwrvgnd_1
X_08253_ _00915_ _00917_ VGND VGND VPWR VPWR _00988_ sky130_fd_sc_hd__and2b_1
XFILLER_20_433 VPWR VGND VPWR VGND sky130_ef_sc_hd__decap_12
XFILLER_32_293 VGND VGND VPWR VPWR sky130_fd_sc_hd__decap_3
X_07204_ _06216_ _06237_ _06494_ _06495_ VGND VGND VPWR VPWR _06496_ sky130_fd_sc_hd__a211o_4
X_08184_ _00892_ _00919_ VGND VGND VPWR VPWR _00920_ sky130_fd_sc_hd__nor2_1
XFILLER_20_477 VGND VGND VPWR VPWR sky130_fd_sc_hd__decap_8
X_07135_ _06418_ _06425_ VGND VGND VPWR VPWR _06427_ sky130_fd_sc_hd__xor2_1
XFILLER_133_335 VGND VGND VPWR VPWR sky130_fd_sc_hd__fill_1
X_07066_ _06216_ _06226_ _05079_ VGND VGND VPWR VPWR _06248_ sky130_fd_sc_hd__a21o_1
XFILLER_102_755 VGND VGND VPWR VPWR sky130_fd_sc_hd__fill_1
XFILLER_101_232 VPWR VGND VPWR VGND sky130_ef_sc_hd__decap_12
XFILLER_59_113 VGND VGND VPWR VPWR sky130_fd_sc_hd__decap_6
X_07968_ _00574_ _00571_ _00570_ VGND VGND VPWR VPWR _00706_ sky130_fd_sc_hd__a21oi_2
XFILLER_75_617 VGND VGND VPWR VPWR sky130_fd_sc_hd__fill_2
X_09707_ _01949_ _02324_ _02329_ VGND VGND VPWR VPWR _02469_ sky130_fd_sc_hd__or3_1
X_06919_ _04505_ _04589_ _02813_ VGND VGND VPWR VPWR _04643_ sky130_fd_sc_hd__a21oi_1
XFILLER_74_138 VGND VGND VPWR VPWR sky130_fd_sc_hd__fill_2
XFILLER_114_77 VGND VGND VPWR VPWR sky130_fd_sc_hd__decap_6
X_07899_ _00518_ _00529_ _00517_ VGND VGND VPWR VPWR _00637_ sky130_fd_sc_hd__a21oi_1
XFILLER_74_26 VGND VGND VPWR VPWR sky130_fd_sc_hd__fill_2
XFILLER_83_694 VGND VGND VPWR VPWR sky130_fd_sc_hd__decap_8
XFILLER_70_300 VGND VGND VPWR VPWR sky130_fd_sc_hd__decap_8
X_09638_ _02384_ _02391_ VGND VGND VPWR VPWR _02394_ sky130_fd_sc_hd__xnor2_1
X_09569_ _02304_ _02318_ VGND VGND VPWR VPWR _02319_ sky130_fd_sc_hd__xnor2_2
XFILLER_130_65 VPWR VGND VPWR VGND sky130_ef_sc_hd__decap_12
XFILLER_70_377 VGND VGND VPWR VPWR sky130_fd_sc_hd__decap_4
X_11600_ _04481_ _04489_ _04488_ VGND VGND VPWR VPWR _04530_ sky130_fd_sc_hd__a21bo_1
X_12580_ _05594_ _05595_ VGND VGND VPWR VPWR _05597_ sky130_fd_sc_hd__xnor2_1
X_11531_ _04453_ _04454_ VGND VGND VPWR VPWR _04455_ sky130_fd_sc_hd__xor2_1
XFILLER_23_260 VGND VGND VPWR VPWR sky130_fd_sc_hd__fill_1
XFILLER_24_794 VPWR VGND VPWR VGND sky130_ef_sc_hd__decap_12
X_11462_ net247 _04379_ VGND VGND VPWR VPWR _04380_ sky130_fd_sc_hd__nand2_1
XFILLER_109_365 VGND VGND VPWR VPWR sky130_fd_sc_hd__decap_6
X_10413_ net495 net653 net651 net503 VGND VGND VPWR VPWR _03233_ sky130_fd_sc_hd__a22o_1
X_11393_ _02109_ net286 net343 net342 VGND VGND VPWR VPWR _04304_ sky130_fd_sc_hd__and4_1
X_13201_ _06166_ _06273_ VGND VGND VPWR VPWR _06275_ sky130_fd_sc_hd__and2_1
X_10344_ _03127_ _03128_ _03157_ _03158_ VGND VGND VPWR VPWR _03159_ sky130_fd_sc_hd__nor4_4
X_13132_ _06163_ _06199_ VGND VGND VPWR VPWR _06200_ sky130_fd_sc_hd__xnor2_1
XFILLER_124_368 VPWR VGND VPWR VGND sky130_ef_sc_hd__decap_12
XTAP_TAPCELL_ROW_111_1847 VGND VPWR sky130_fd_sc_hd__tapvpwrvgnd_1
X_10275_ _03082_ _03058_ VGND VGND VPWR VPWR _03083_ sky130_fd_sc_hd__and2b_1
XTAP_TAPCELL_ROW_57_1090 VGND VPWR sky130_fd_sc_hd__tapvpwrvgnd_1
X_13063_ _06114_ _06123_ VGND VGND VPWR VPWR _06124_ sky130_fd_sc_hd__and2b_1
XFILLER_3_665 VGND VGND VPWR VPWR sky130_fd_sc_hd__decap_6
XFILLER_2_153 VPWR VGND VPWR VGND sky130_ef_sc_hd__decap_12
XFILLER_105_582 VGND VGND VPWR VPWR sky130_fd_sc_hd__decap_3
X_12014_ _04975_ _04976_ _04978_ VGND VGND VPWR VPWR _04979_ sky130_fd_sc_hd__nand3_4
XFILLER_2_197 VPWR VGND VPWR VGND sky130_ef_sc_hd__decap_12
XFILLER_78_477 VGND VGND VPWR VPWR sky130_fd_sc_hd__decap_8
Xfanout490 net491 VGND VGND VPWR VPWR net490 sky130_fd_sc_hd__buf_2
XFILLER_19_511 VGND VGND VPWR VPWR sky130_fd_sc_hd__decap_3
XFILLER_19_522 VGND VGND VPWR VPWR sky130_fd_sc_hd__decap_8
XFILLER_19_577 VGND VGND VPWR VPWR sky130_fd_sc_hd__decap_3
X_12916_ _05960_ _05961_ VGND VGND VPWR VPWR _05963_ sky130_fd_sc_hd__xnor2_1
XFILLER_34_525 VGND VGND VPWR VPWR sky130_fd_sc_hd__fill_1
X_12847_ _05778_ _05787_ _05785_ VGND VGND VPWR VPWR _05889_ sky130_fd_sc_hd__a21oi_1
XTAP_TAPCELL_ROW_122_1998 VGND VPWR sky130_fd_sc_hd__tapvpwrvgnd_1
X_12778_ _05300_ _05485_ _05656_ VGND VGND VPWR VPWR _05814_ sky130_fd_sc_hd__or3b_4
XFILLER_15_783 VGND VGND VPWR VPWR sky130_fd_sc_hd__fill_1
XTAP_TAPCELL_ROW_32_737 VGND VPWR sky130_fd_sc_hd__tapvpwrvgnd_1
XTAP_TAPCELL_ROW_32_748 VGND VPWR sky130_fd_sc_hd__tapvpwrvgnd_1
X_11729_ net536 net529 net674 net672 VGND VGND VPWR VPWR _04667_ sky130_fd_sc_hd__and4_1
XFILLER_14_293 VGND VGND VPWR VPWR sky130_fd_sc_hd__decap_4
XTAP_TAPCELL_ROW_12_461 VGND VPWR sky130_fd_sc_hd__tapvpwrvgnd_1
XFILLER_116_803 VGND VGND VPWR VPWR sky130_fd_sc_hd__decap_8
XFILLER_89_709 VPWR VGND VPWR VGND sky130_ef_sc_hd__decap_12
XTAP_TAPCELL_ROW_73_1319 VGND VPWR sky130_fd_sc_hd__tapvpwrvgnd_1
X_08940_ _01509_ _01665_ VGND VGND VPWR VPWR _01666_ sky130_fd_sc_hd__or2_1
X_08871_ _01595_ _01596_ VGND VGND VPWR VPWR _01597_ sky130_fd_sc_hd__nand2b_1
XFILLER_69_444 VGND VGND VPWR VPWR sky130_fd_sc_hd__decap_4
X_07822_ _00325_ _00417_ _00416_ VGND VGND VPWR VPWR _00561_ sky130_fd_sc_hd__a21bo_1
XFILLER_84_403 VPWR VGND VPWR VGND sky130_ef_sc_hd__decap_12
XFILLER_57_617 VGND VGND VPWR VPWR sky130_fd_sc_hd__decap_8
XFILLER_97_797 VGND VGND VPWR VPWR sky130_fd_sc_hd__decap_6
XFILLER_57_639 VGND VGND VPWR VPWR sky130_fd_sc_hd__decap_4
XFILLER_56_138 VGND VGND VPWR VPWR sky130_fd_sc_hd__fill_2
X_07753_ _00482_ _00491_ VGND VGND VPWR VPWR _00492_ sky130_fd_sc_hd__xnor2_1
XFILLER_56_149 VGND VGND VPWR VPWR sky130_fd_sc_hd__decap_8
X_06704_ net394 VGND VGND VPWR VPWR _00064_ sky130_fd_sc_hd__inv_2
X_07684_ _00268_ _00270_ _00422_ _00423_ VGND VGND VPWR VPWR _00424_ sky130_fd_sc_hd__o211ai_2
XFILLER_37_363 VGND VGND VPWR VPWR sky130_fd_sc_hd__fill_1
X_09423_ _02129_ _02159_ VGND VGND VPWR VPWR _02160_ sky130_fd_sc_hd__and2b_1
XFILLER_80_642 VGND VGND VPWR VPWR sky130_fd_sc_hd__fill_2
XFILLER_64_171 VGND VGND VPWR VPWR sky130_fd_sc_hd__fill_1
XFILLER_44_29 VGND VGND VPWR VPWR sky130_fd_sc_hd__fill_2
X_09354_ _01962_ _01964_ _02082_ VGND VGND VPWR VPWR _02084_ sky130_fd_sc_hd__and3_1
XFILLER_80_664 VGND VGND VPWR VPWR sky130_fd_sc_hd__decap_8
XFILLER_13_709 VPWR VGND VPWR VGND sky130_ef_sc_hd__decap_12
X_08305_ _00989_ _01011_ _01012_ _01015_ VGND VGND VPWR VPWR _01039_ sky130_fd_sc_hd__a31oi_1
XFILLER_33_580 VPWR VGND VPWR VGND sky130_ef_sc_hd__decap_12
X_09285_ _02007_ _02008_ VGND VGND VPWR VPWR _02009_ sky130_fd_sc_hd__nor2_1
XFILLER_21_753 VGND VGND VPWR VPWR sky130_fd_sc_hd__decap_4
X_08236_ _00969_ _00970_ VGND VGND VPWR VPWR _00971_ sky130_fd_sc_hd__nand2_1
XFILLER_60_39 VGND VGND VPWR VPWR sky130_fd_sc_hd__fill_2
XFILLER_21_797 VPWR VGND VPWR VGND sky130_ef_sc_hd__decap_12
X_08167_ _00780_ _00902_ VGND VGND VPWR VPWR _00903_ sky130_fd_sc_hd__xnor2_1
XTAP_TAPCELL_ROW_99_1680 VGND VPWR sky130_fd_sc_hd__tapvpwrvgnd_1
XFILLER_20_285 VGND VGND VPWR VPWR sky130_fd_sc_hd__fill_1
XFILLER_109_44 VPWR VGND VPWR VGND sky130_ef_sc_hd__decap_12
X_07118_ net685 net498 net505 net683 VGND VGND VPWR VPWR _06410_ sky130_fd_sc_hd__nand4_1
XFILLER_109_99 VGND VGND VPWR VPWR sky130_fd_sc_hd__fill_2
X_08098_ net374 net287 _02142_ net309 VGND VGND VPWR VPWR _00834_ sky130_fd_sc_hd__o2bb2a_1
XFILLER_134_699 VGND VGND VPWR VPWR sky130_fd_sc_hd__fill_1
X_07049_ _06030_ _06008_ _05822_ VGND VGND VPWR VPWR _06063_ sky130_fd_sc_hd__o21a_1
XFILLER_0_613 VGND VGND VPWR VPWR sky130_fd_sc_hd__decap_3
XFILLER_88_742 VGND VGND VPWR VPWR sky130_fd_sc_hd__decap_4
XFILLER_87_230 VPWR VGND VPWR VGND sky130_ef_sc_hd__decap_12
X_10060_ _02846_ _02847_ VGND VGND VPWR VPWR _02849_ sky130_fd_sc_hd__nand2_1
XFILLER_0_657 VPWR VGND VPWR VGND sky130_ef_sc_hd__decap_12
XFILLER_102_574 VPWR VGND VPWR VGND sky130_ef_sc_hd__decap_12
XFILLER_87_274 VGND VGND VPWR VPWR sky130_fd_sc_hd__decap_6
XTAP_TAPCELL_ROW_126_2065 VGND VPWR sky130_fd_sc_hd__tapvpwrvgnd_1
XTAP_TAPCELL_ROW_126_2054 VGND VPWR sky130_fd_sc_hd__tapvpwrvgnd_1
XFILLER_47_138 VPWR VGND VPWR VGND sky130_ef_sc_hd__decap_12
XFILLER_90_428 VPWR VGND VPWR VGND sky130_ef_sc_hd__decap_12
XFILLER_90_406 VGND VGND VPWR VPWR sky130_fd_sc_hd__decap_8
XFILLER_18_85 VPWR VGND VPWR VGND sky130_ef_sc_hd__decap_12
XFILLER_28_363 VGND VGND VPWR VPWR sky130_fd_sc_hd__fill_1
X_10962_ _03831_ _03832_ _03654_ _03656_ VGND VGND VPWR VPWR _03834_ sky130_fd_sc_hd__a211o_1
XFILLER_43_333 VGND VGND VPWR VPWR sky130_fd_sc_hd__decap_3
X_12701_ net449 net145 VGND VGND VPWR VPWR _05729_ sky130_fd_sc_hd__and2b_1
XFILLER_70_141 VGND VGND VPWR VPWR sky130_fd_sc_hd__fill_1
XFILLER_16_569 VGND VGND VPWR VPWR sky130_fd_sc_hd__decap_8
X_10893_ _03755_ _03756_ _03757_ VGND VGND VPWR VPWR _03758_ sky130_fd_sc_hd__and3_1
X_12632_ _05307_ _05652_ _05653_ VGND VGND VPWR VPWR _05654_ sky130_fd_sc_hd__nand3_1
XFILLER_129_416 VGND VGND VPWR VPWR sky130_fd_sc_hd__fill_1
XFILLER_129_405 VGND VGND VPWR VPWR sky130_fd_sc_hd__fill_1
XFILLER_8_713 VPWR VGND VPWR VGND sky130_ef_sc_hd__decap_12
X_12563_ _05544_ _05576_ VGND VGND VPWR VPWR _05578_ sky130_fd_sc_hd__xnor2_1
XFILLER_129_449 VPWR VGND VPWR VGND sky130_ef_sc_hd__decap_12
X_11514_ _04434_ _04321_ VGND VGND VPWR VPWR _04436_ sky130_fd_sc_hd__and2b_1
XFILLER_7_223 VGND VGND VPWR VPWR sky130_fd_sc_hd__fill_1
X_12494_ _05500_ _05501_ VGND VGND VPWR VPWR _05502_ sky130_fd_sc_hd__xnor2_1
XFILLER_8_757 VPWR VGND VPWR VGND sky130_ef_sc_hd__decap_12
X_11445_ _04358_ _04359_ VGND VGND VPWR VPWR _04361_ sky130_fd_sc_hd__xnor2_1
X_11376_ _04284_ _04285_ VGND VGND VPWR VPWR _04286_ sky130_fd_sc_hd__nor2_1
XFILLER_112_305 VGND VGND VPWR VPWR sky130_fd_sc_hd__decap_3
X_10327_ net332 net352 net351 net354 VGND VGND VPWR VPWR _03141_ sky130_fd_sc_hd__a22oi_2
X_13115_ _05524_ _06180_ VGND VGND VPWR VPWR _06181_ sky130_fd_sc_hd__xnor2_1
XFILLER_79_720 VGND VGND VPWR VPWR sky130_fd_sc_hd__fill_1
X_10258_ _02886_ _03064_ VGND VGND VPWR VPWR _03065_ sky130_fd_sc_hd__nand2_1
X_13046_ _06100_ _06104_ VGND VGND VPWR VPWR _06105_ sky130_fd_sc_hd__nand2_1
XFILLER_3_473 VPWR VGND VPWR VGND sky130_ef_sc_hd__decap_12
XFILLER_94_701 VGND VGND VPWR VPWR sky130_fd_sc_hd__decap_6
XFILLER_79_764 VGND VGND VPWR VPWR sky130_fd_sc_hd__decap_3
X_10189_ net903 _02988_ _02986_ VGND VGND VPWR VPWR _02990_ sky130_fd_sc_hd__a21oi_2
XFILLER_66_447 VGND VGND VPWR VPWR sky130_fd_sc_hd__decap_6
XTAP_TAPCELL_ROW_37_807 VGND VPWR sky130_fd_sc_hd__tapvpwrvgnd_1
XFILLER_81_428 VGND VGND VPWR VPWR sky130_fd_sc_hd__fill_1
XFILLER_75_91 VGND VGND VPWR VPWR sky130_fd_sc_hd__decap_8
XFILLER_53_108 VGND VGND VPWR VPWR sky130_fd_sc_hd__decap_4
XTAP_TAPCELL_ROW_37_818 VGND VPWR sky130_fd_sc_hd__tapvpwrvgnd_1
XFILLER_74_491 VGND VGND VPWR VPWR sky130_fd_sc_hd__fill_1
XFILLER_62_664 VGND VGND VPWR VPWR sky130_fd_sc_hd__decap_4
XFILLER_62_653 VGND VGND VPWR VPWR sky130_fd_sc_hd__fill_2
XFILLER_61_141 VGND VGND VPWR VPWR sky130_fd_sc_hd__fill_1
XTAP_TAPCELL_ROW_17_531 VGND VPWR sky130_fd_sc_hd__tapvpwrvgnd_1
X_09070_ _01477_ _01628_ _01626_ VGND VGND VPWR VPWR _01795_ sky130_fd_sc_hd__o21a_1
X_08021_ net435 _00184_ _00186_ _00676_ VGND VGND VPWR VPWR _00758_ sky130_fd_sc_hd__a2bb2o_1
XPHY_EDGE_ROW_123_Right_123 VGND VGND VPWR VPWR sky130_fd_sc_hd__decap_3
XFILLER_116_699 VGND VGND VPWR VPWR sky130_fd_sc_hd__fill_1
XFILLER_115_165 VGND VGND VPWR VPWR sky130_fd_sc_hd__decap_3
XFILLER_89_517 VGND VGND VPWR VPWR sky130_fd_sc_hd__decap_3
X_09972_ _02737_ _02755_ VGND VGND VPWR VPWR _02756_ sky130_fd_sc_hd__xnor2_1
XFILLER_103_327 VGND VGND VPWR VPWR sky130_fd_sc_hd__decap_4
X_08923_ net479 net634 VGND VGND VPWR VPWR _01649_ sky130_fd_sc_hd__nand2_4
XFILLER_39_18 VGND VGND VPWR VPWR sky130_fd_sc_hd__fill_1
XFILLER_97_561 VGND VGND VPWR VPWR sky130_fd_sc_hd__decap_8
XFILLER_130_179 VPWR VGND VPWR VGND sky130_ef_sc_hd__decap_12
X_08854_ _01362_ _01364_ _01579_ _01580_ VGND VGND VPWR VPWR _01581_ sky130_fd_sc_hd__o211a_1
XFILLER_29_105 VGND VGND VPWR VPWR sky130_fd_sc_hd__fill_2
X_08785_ _01510_ _01511_ VGND VGND VPWR VPWR _01512_ sky130_fd_sc_hd__xnor2_1
X_07805_ _00368_ _00543_ VGND VGND VPWR VPWR _00544_ sky130_fd_sc_hd__xnor2_1
XFILLER_57_447 VGND VGND VPWR VPWR sky130_fd_sc_hd__fill_1
X_07736_ _00438_ _00473_ VGND VGND VPWR VPWR _00475_ sky130_fd_sc_hd__xnor2_1
XFILLER_84_266 VPWR VGND VPWR VGND sky130_ef_sc_hd__decap_12
XFILLER_25_311 VPWR VGND VPWR VGND sky130_ef_sc_hd__decap_12
XFILLER_37_193 VGND VGND VPWR VPWR sky130_fd_sc_hd__fill_2
X_07667_ _00246_ _00248_ _00405_ _00406_ VGND VGND VPWR VPWR _00407_ sky130_fd_sc_hd__o211a_1
XFILLER_52_141 VGND VGND VPWR VPWR sky130_fd_sc_hd__decap_3
X_09406_ net494 net628 _01973_ _01975_ VGND VGND VPWR VPWR _02141_ sky130_fd_sc_hd__a31o_1
X_07598_ _02066_ _02087_ _00334_ _00336_ VGND VGND VPWR VPWR _00338_ sky130_fd_sc_hd__or4b_1
XFILLER_80_472 VGND VGND VPWR VPWR sky130_fd_sc_hd__decap_4
XFILLER_53_697 VGND VGND VPWR VPWR sky130_fd_sc_hd__decap_8
XFILLER_13_539 VGND VGND VPWR VPWR sky130_fd_sc_hd__decap_3
X_09337_ _02063_ _02064_ _01898_ _01900_ VGND VGND VPWR VPWR _02067_ sky130_fd_sc_hd__a211o_1
X_09268_ _01819_ _01828_ _01827_ VGND VGND VPWR VPWR _01992_ sky130_fd_sc_hd__a21oi_1
XFILLER_21_561 VPWR VGND VPWR VGND sky130_ef_sc_hd__decap_12
X_08219_ _00838_ _00840_ _00852_ VGND VGND VPWR VPWR _00954_ sky130_fd_sc_hd__o21a_1
X_09199_ _01796_ _01798_ VGND VGND VPWR VPWR _01923_ sky130_fd_sc_hd__nand2_1
XFILLER_5_727 VGND VGND VPWR VPWR sky130_fd_sc_hd__fill_1
XFILLER_107_655 VGND VGND VPWR VPWR sky130_fd_sc_hd__decap_4
X_11230_ _03974_ _03976_ _03973_ VGND VGND VPWR VPWR _04127_ sky130_fd_sc_hd__o21ba_1
XFILLER_136_53 VGND VGND VPWR VPWR sky130_fd_sc_hd__decap_3
XFILLER_106_165 VGND VGND VPWR VPWR sky130_fd_sc_hd__fill_2
XFILLER_20_53 VGND VGND VPWR VPWR sky130_fd_sc_hd__decap_4
XFILLER_20_64 VGND VGND VPWR VPWR sky130_fd_sc_hd__fill_2
X_11161_ net247 _04049_ VGND VGND VPWR VPWR _04051_ sky130_fd_sc_hd__xnor2_1
XFILLER_121_102 VGND VGND VPWR VPWR sky130_fd_sc_hd__decap_4
XFILLER_96_24 VGND VGND VPWR VPWR sky130_fd_sc_hd__fill_1
X_10112_ _02902_ _02903_ VGND VGND VPWR VPWR _02905_ sky130_fd_sc_hd__xnor2_1
XFILLER_0_421 VGND VGND VPWR VPWR sky130_fd_sc_hd__fill_2
XFILLER_136_97 VPWR VGND VPWR VGND sky130_ef_sc_hd__decap_12
X_11092_ net433 net559 VGND VGND VPWR VPWR _03976_ sky130_fd_sc_hd__nand2_1
XFILLER_76_734 VPWR VGND VPWR VGND sky130_ef_sc_hd__decap_12
XFILLER_75_200 VGND VGND VPWR VPWR sky130_fd_sc_hd__decap_8
X_10043_ net450 net579 _02828_ VGND VGND VPWR VPWR _02830_ sky130_fd_sc_hd__and3_1
XFILLER_75_244 VGND VGND VPWR VPWR sky130_fd_sc_hd__decap_6
XFILLER_29_73 VPWR VGND VPWR VGND sky130_ef_sc_hd__decap_12
XFILLER_90_203 VGND VGND VPWR VPWR sky130_fd_sc_hd__fill_1
XFILLER_75_277 VGND VGND VPWR VPWR sky130_fd_sc_hd__decap_3
XFILLER_29_683 VGND VGND VPWR VPWR sky130_fd_sc_hd__decap_3
XFILLER_90_236 VGND VGND VPWR VPWR sky130_fd_sc_hd__fill_2
X_11994_ _04787_ _04789_ _04956_ _04954_ VGND VGND VPWR VPWR _04957_ sky130_fd_sc_hd__a211oi_4
XTAP_TAPCELL_ROW_106_1779 VGND VPWR sky130_fd_sc_hd__tapvpwrvgnd_1
X_10945_ _03812_ _03813_ _03805_ VGND VGND VPWR VPWR _03815_ sky130_fd_sc_hd__a21o_1
XFILLER_44_686 VPWR VGND VPWR VGND sky130_ef_sc_hd__decap_12
X_10876_ _03698_ _03737_ VGND VGND VPWR VPWR _03739_ sky130_fd_sc_hd__xnor2_1
X_12615_ _05632_ _05633_ _05453_ _05455_ VGND VGND VPWR VPWR _05635_ sky130_fd_sc_hd__a211o_1
XFILLER_129_213 VGND VGND VPWR VPWR sky130_fd_sc_hd__decap_8
XTAP_TAPCELL_ROW_42_876 VGND VPWR sky130_fd_sc_hd__tapvpwrvgnd_1
XTAP_TAPCELL_ROW_42_887 VGND VPWR sky130_fd_sc_hd__tapvpwrvgnd_1
X_12546_ _05555_ _05556_ _05557_ VGND VGND VPWR VPWR _05559_ sky130_fd_sc_hd__a21o_1
X_12477_ _05482_ _05483_ VGND VGND VPWR VPWR _05485_ sky130_fd_sc_hd__or2_4
XANTENNA_4 _02077_ VGND VGND VPWR VPWR sky130_fd_sc_hd__diode_2
X_11428_ net408 _02251_ _03396_ VGND VGND VPWR VPWR _04343_ sky130_fd_sc_hd__o21ai_1
XFILLER_113_614 VGND VGND VPWR VPWR sky130_fd_sc_hd__fill_2
XFILLER_6_77 VGND VGND VPWR VPWR sky130_fd_sc_hd__decap_6
X_11359_ _04264_ _04266_ VGND VGND VPWR VPWR _04268_ sky130_fd_sc_hd__xor2_1
XFILLER_113_647 VPWR VGND VPWR VGND sky130_ef_sc_hd__decap_12
XFILLER_112_113 VPWR VGND VPWR VGND sky130_ef_sc_hd__decap_12
XFILLER_4_793 VPWR VGND VPWR VGND sky130_ef_sc_hd__decap_12
XFILLER_3_281 VPWR VGND VPWR VGND sky130_ef_sc_hd__decap_12
XFILLER_79_561 VGND VGND VPWR VPWR sky130_fd_sc_hd__decap_4
X_13029_ _06086_ _06087_ VGND VGND VPWR VPWR _06088_ sky130_fd_sc_hd__nor2_1
XFILLER_94_553 VGND VGND VPWR VPWR sky130_fd_sc_hd__decap_3
XFILLER_94_531 VGND VGND VPWR VPWR sky130_fd_sc_hd__fill_1
XFILLER_67_778 VGND VGND VPWR VPWR sky130_fd_sc_hd__fill_1
XFILLER_66_244 VGND VGND VPWR VPWR sky130_fd_sc_hd__decap_4
XFILLER_39_447 VGND VGND VPWR VPWR sky130_fd_sc_hd__fill_1
XFILLER_94_575 VGND VGND VPWR VPWR sky130_fd_sc_hd__decap_8
Xrebuffer27 _06641_ VGND VGND VPWR VPWR net727 sky130_fd_sc_hd__dlygate4sd1_1
XFILLER_82_737 VGND VGND VPWR VPWR sky130_fd_sc_hd__decap_3
X_08570_ _01297_ _01294_ _01298_ VGND VGND VPWR VPWR _01299_ sky130_fd_sc_hd__or3_4
Xrebuffer16 net715 VGND VGND VPWR VPWR net716 sky130_fd_sc_hd__dlymetal6s2s_1
X_07521_ _00261_ VGND VGND VPWR VPWR _00262_ sky130_fd_sc_hd__inv_2
XFILLER_81_225 VPWR VGND VPWR VGND sky130_ef_sc_hd__decap_12
Xrebuffer38 net735 VGND VGND VPWR VPWR net738 sky130_fd_sc_hd__dlymetal6s2s_1
Xrebuffer49 net822 VGND VGND VPWR VPWR net749 sky130_fd_sc_hd__clkbuf_2
XFILLER_19_182 VPWR VGND VPWR VGND sky130_ef_sc_hd__decap_12
XFILLER_34_130 VGND VGND VPWR VPWR sky130_fd_sc_hd__decap_4
X_07452_ _00192_ _00191_ VGND VGND VPWR VPWR _00193_ sky130_fd_sc_hd__nand2b_1
XTAP_TAPCELL_ROW_81_1429 VGND VPWR sky130_fd_sc_hd__tapvpwrvgnd_1
XFILLER_35_697 VGND VGND VPWR VPWR sky130_fd_sc_hd__decap_8
X_07383_ net668 net304 _02131_ net687 VGND VGND VPWR VPWR _06673_ sky130_fd_sc_hd__o2bb2a_1
XFILLER_50_667 VGND VGND VPWR VPWR sky130_fd_sc_hd__fill_2
XFILLER_50_645 VGND VGND VPWR VPWR sky130_fd_sc_hd__decap_3
X_09122_ net422 net552 _01844_ _01845_ VGND VGND VPWR VPWR _01847_ sky130_fd_sc_hd__nand4_1
XFILLER_41_19 VGND VGND VPWR VPWR sky130_fd_sc_hd__decap_4
Xrebuffer117 net816 VGND VGND VPWR VPWR net817 sky130_fd_sc_hd__dlygate4sd1_1
XFILLER_135_205 VPWR VGND VPWR VGND sky130_ef_sc_hd__decap_12
X_09053_ _01492_ _01622_ _01624_ _01619_ VGND VGND VPWR VPWR _01778_ sky130_fd_sc_hd__o2bb2a_1
Xrebuffer139 net429 VGND VGND VPWR VPWR net839 sky130_fd_sc_hd__buf_2
XFILLER_135_249 VPWR VGND VPWR VGND sky130_ef_sc_hd__decap_12
X_08004_ _00732_ _00740_ VGND VGND VPWR VPWR _00741_ sky130_fd_sc_hd__xnor2_1
Xmax_cap240 _01890_ VGND VGND VPWR VPWR net240 sky130_fd_sc_hd__clkbuf_2
X_09955_ _02649_ _02671_ _02647_ VGND VGND VPWR VPWR _02737_ sky130_fd_sc_hd__a21o_1
X_08906_ _01629_ _01630_ VGND VGND VPWR VPWR _01632_ sky130_fd_sc_hd__nor2_1
X_09886_ _02558_ _02560_ _02662_ VGND VGND VPWR VPWR _02663_ sky130_fd_sc_hd__a21oi_1
XFILLER_66_27 VGND VGND VPWR VPWR sky130_fd_sc_hd__fill_1
XFILLER_57_200 VGND VGND VPWR VPWR sky130_fd_sc_hd__fill_2
XFILLER_106_89 VGND VGND VPWR VPWR sky130_fd_sc_hd__fill_1
XFILLER_85_553 VGND VGND VPWR VPWR sky130_fd_sc_hd__decap_6
X_08837_ _01545_ _01562_ _01563_ VGND VGND VPWR VPWR _01564_ sky130_fd_sc_hd__and3_1
XFILLER_57_222 VGND VGND VPWR VPWR sky130_fd_sc_hd__fill_2
XTAP_TAPCELL_ROW_123_2013 VGND VPWR sky130_fd_sc_hd__tapvpwrvgnd_1
XFILLER_45_417 VGND VGND VPWR VPWR sky130_fd_sc_hd__decap_4
X_08768_ net523 net126 VGND VGND VPWR VPWR _01495_ sky130_fd_sc_hd__nand2_1
XFILLER_122_77 VGND VGND VPWR VPWR sky130_fd_sc_hd__fill_1
X_07719_ _00143_ _00147_ VGND VGND VPWR VPWR _00458_ sky130_fd_sc_hd__nor2_2
XFILLER_82_37 VGND VGND VPWR VPWR sky130_fd_sc_hd__fill_1
X_08699_ _01407_ net885 _01426_ VGND VGND VPWR VPWR _01427_ sky130_fd_sc_hd__nor3_2
XFILLER_81_792 VGND VGND VPWR VPWR sky130_fd_sc_hd__decap_8
XTAP_TAPCELL_ROW_0_284 VGND VPWR sky130_fd_sc_hd__tapvpwrvgnd_1
XTAP_TAPCELL_ROW_0_295 VGND VPWR sky130_fd_sc_hd__tapvpwrvgnd_1
X_10730_ _03578_ _03579_ VGND VGND VPWR VPWR _03580_ sky130_fd_sc_hd__and2_1
X_10661_ _03324_ _03503_ VGND VGND VPWR VPWR _03505_ sky130_fd_sc_hd__xor2_1
XFILLER_13_358 VGND VGND VPWR VPWR sky130_fd_sc_hd__decap_3
XFILLER_15_75 VGND VGND VPWR VPWR sky130_fd_sc_hd__decap_6
XFILLER_40_166 VGND VGND VPWR VPWR sky130_fd_sc_hd__decap_8
X_12400_ _05366_ _05399_ VGND VGND VPWR VPWR _05400_ sky130_fd_sc_hd__and2b_1
XFILLER_41_678 VGND VGND VPWR VPWR sky130_fd_sc_hd__decap_8
X_13380_ clknet_3_5__leaf_clk _00026_ _00090_ VGND VGND VPWR VPWR net179 sky130_fd_sc_hd__dfrtp_1
X_10592_ net401 net580 net577 net409 VGND VGND VPWR VPWR _03429_ sky130_fd_sc_hd__a22oi_1
X_12331_ net640 net79 VGND VGND VPWR VPWR _05324_ sky130_fd_sc_hd__nand2_1
XTAP_TAPCELL_ROW_134_2175 VGND VPWR sky130_fd_sc_hd__tapvpwrvgnd_1
XTAP_TAPCELL_ROW_134_2164 VGND VPWR sky130_fd_sc_hd__tapvpwrvgnd_1
X_12262_ net359 net334 net44 net367 VGND VGND VPWR VPWR _05249_ sky130_fd_sc_hd__nand4_1
XFILLER_135_783 VGND VGND VPWR VPWR sky130_fd_sc_hd__fill_1
XFILLER_107_441 VGND VGND VPWR VPWR sky130_fd_sc_hd__fill_1
X_11213_ _03925_ _03938_ _03936_ VGND VGND VPWR VPWR _04108_ sky130_fd_sc_hd__o21ai_1
X_12193_ _05011_ _05172_ VGND VGND VPWR VPWR _05173_ sky130_fd_sc_hd__xor2_1
XTAP_TAPCELL_ROW_52_1019 VGND VPWR sky130_fd_sc_hd__tapvpwrvgnd_1
XFILLER_1_741 VPWR VGND VPWR VGND sky130_ef_sc_hd__decap_12
X_11144_ _04029_ _04030_ _04031_ VGND VGND VPWR VPWR _04032_ sky130_fd_sc_hd__or3_1
XFILLER_0_251 VGND VGND VPWR VPWR sky130_fd_sc_hd__fill_1
XFILLER_1_785 VPWR VGND VPWR VGND sky130_ef_sc_hd__decap_12
X_11075_ net755 net343 VGND VGND VPWR VPWR _03957_ sky130_fd_sc_hd__nand2_1
Xinput130 w30[0] VGND VGND VPWR VPWR net130 sky130_fd_sc_hd__clkbuf_1
X_10026_ net686 net282 net280 net266 VGND VGND VPWR VPWR _02812_ sky130_fd_sc_hd__a22oi_1
Xinput141 w31[3] VGND VGND VPWR VPWR net141 sky130_fd_sc_hd__clkbuf_2
Xinput152 w32[6] VGND VGND VPWR VPWR net152 sky130_fd_sc_hd__buf_1
XTAP_TAPCELL_ROW_108_1808 VGND VPWR sky130_fd_sc_hd__tapvpwrvgnd_1
XFILLER_49_778 VGND VGND VPWR VPWR sky130_fd_sc_hd__decap_3
XFILLER_63_225 VPWR VGND VPWR VGND sky130_ef_sc_hd__decap_12
XFILLER_48_299 VGND VGND VPWR VPWR sky130_fd_sc_hd__fill_2
XTAP_TAPCELL_ROW_47_957 VGND VPWR sky130_fd_sc_hd__tapvpwrvgnd_1
XTAP_TAPCELL_ROW_47_946 VGND VPWR sky130_fd_sc_hd__tapvpwrvgnd_1
X_11977_ net735 net44 VGND VGND VPWR VPWR _04939_ sky130_fd_sc_hd__nand2_1
XFILLER_16_141 VPWR VGND VPWR VGND sky130_ef_sc_hd__decap_12
XFILLER_72_792 VGND VGND VPWR VPWR sky130_fd_sc_hd__decap_4
XFILLER_72_781 VGND VGND VPWR VPWR sky130_fd_sc_hd__decap_8
XFILLER_44_461 VGND VGND VPWR VPWR sky130_fd_sc_hd__decap_3
XTAP_TAPCELL_ROW_27_670 VGND VPWR sky130_fd_sc_hd__tapvpwrvgnd_1
X_10928_ _03787_ _03796_ VGND VGND VPWR VPWR _03797_ sky130_fd_sc_hd__xnor2_1
XFILLER_72_92 VGND VGND VPWR VPWR sky130_fd_sc_hd__decap_3
XFILLER_31_155 VGND VGND VPWR VPWR sky130_fd_sc_hd__fill_1
X_10859_ net566 _03546_ _03541_ VGND VGND VPWR VPWR _03721_ sky130_fd_sc_hd__a21oi_1
XTAP_TAPCELL_ROW_119_1959 VGND VPWR sky130_fd_sc_hd__tapvpwrvgnd_1
XFILLER_117_205 VGND VGND VPWR VPWR sky130_fd_sc_hd__decap_4
X_12529_ _05540_ _05496_ VGND VGND VPWR VPWR _05541_ sky130_fd_sc_hd__nand2b_1
XFILLER_133_709 VPWR VGND VPWR VGND sky130_ef_sc_hd__decap_12
XFILLER_117_249 VGND VGND VPWR VPWR sky130_fd_sc_hd__fill_1
XFILLER_68_3 VPWR VGND VPWR VGND sky130_ef_sc_hd__decap_12
XTAP_TAPCELL_ROW_78_1380 VGND VPWR sky130_fd_sc_hd__tapvpwrvgnd_1
XFILLER_99_634 VGND VGND VPWR VPWR sky130_fd_sc_hd__fill_1
XFILLER_98_111 VGND VGND VPWR VPWR sky130_fd_sc_hd__decap_8
XTAP_TAPCELL_ROW_78_1391 VGND VPWR sky130_fd_sc_hd__tapvpwrvgnd_1
Xfanout319 net68 VGND VGND VPWR VPWR net319 sky130_fd_sc_hd__dlymetal6s2s_1
Xfanout308 net311 VGND VGND VPWR VPWR net308 sky130_fd_sc_hd__buf_2
X_06952_ _04927_ _04938_ _04982_ VGND VGND VPWR VPWR _05003_ sky130_fd_sc_hd__a21o_1
X_09740_ _02368_ _02369_ _02504_ VGND VGND VPWR VPWR _02505_ sky130_fd_sc_hd__a21oi_1
XFILLER_98_188 VGND VGND VPWR VPWR sky130_fd_sc_hd__decap_8
XFILLER_86_317 VGND VGND VPWR VPWR sky130_fd_sc_hd__fill_2
.ends

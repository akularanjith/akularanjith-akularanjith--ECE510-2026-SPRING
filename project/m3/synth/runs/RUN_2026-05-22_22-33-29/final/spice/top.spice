* NGSPICE file created from top.ext - technology: sky130A

* Black-box entry subcircuit for sky130_fd_sc_hd__tapvpwrvgnd_1 abstract view
.subckt sky130_fd_sc_hd__tapvpwrvgnd_1 VGND VPWR
.ends

* Black-box entry subcircuit for sky130_fd_sc_hd__dfxtp_1 abstract view
.subckt sky130_fd_sc_hd__dfxtp_1 CLK D VGND VNB VPB VPWR Q
.ends

* Black-box entry subcircuit for sky130_fd_sc_hd__nor3_1 abstract view
.subckt sky130_fd_sc_hd__nor3_1 A B C VGND VNB VPB VPWR Y
.ends

* Black-box entry subcircuit for sky130_ef_sc_hd__decap_12 abstract view
.subckt sky130_ef_sc_hd__decap_12 VPWR VGND VPB VNB
.ends

* Black-box entry subcircuit for sky130_fd_sc_hd__buf_2 abstract view
.subckt sky130_fd_sc_hd__buf_2 A VGND VNB VPB VPWR X
.ends

* Black-box entry subcircuit for sky130_fd_sc_hd__decap_8 abstract view
.subckt sky130_fd_sc_hd__decap_8 VGND VNB VPB VPWR
.ends

* Black-box entry subcircuit for sky130_fd_sc_hd__fill_2 abstract view
.subckt sky130_fd_sc_hd__fill_2 VGND VNB VPB VPWR
.ends

* Black-box entry subcircuit for sky130_fd_sc_hd__fill_1 abstract view
.subckt sky130_fd_sc_hd__fill_1 VGND VNB VPB VPWR
.ends

* Black-box entry subcircuit for sky130_fd_sc_hd__or2_1 abstract view
.subckt sky130_fd_sc_hd__or2_1 A B VGND VNB VPB VPWR X
.ends

* Black-box entry subcircuit for sky130_fd_sc_hd__o211a_1 abstract view
.subckt sky130_fd_sc_hd__o211a_1 A1 A2 B1 C1 VGND VNB VPB VPWR X
.ends

* Black-box entry subcircuit for sky130_fd_sc_hd__clkbuf_1 abstract view
.subckt sky130_fd_sc_hd__clkbuf_1 A VGND VNB VPB VPWR X
.ends

* Black-box entry subcircuit for sky130_fd_sc_hd__a2bb2o_1 abstract view
.subckt sky130_fd_sc_hd__a2bb2o_1 A1_N A2_N B1 B2 VGND VNB VPB VPWR X
.ends

* Black-box entry subcircuit for sky130_fd_sc_hd__and4_1 abstract view
.subckt sky130_fd_sc_hd__and4_1 A B C D VGND VNB VPB VPWR X
.ends

* Black-box entry subcircuit for sky130_fd_sc_hd__and2b_1 abstract view
.subckt sky130_fd_sc_hd__and2b_1 A_N B VGND VNB VPB VPWR X
.ends

* Black-box entry subcircuit for sky130_fd_sc_hd__decap_4 abstract view
.subckt sky130_fd_sc_hd__decap_4 VGND VNB VPB VPWR
.ends

* Black-box entry subcircuit for sky130_fd_sc_hd__nor2_1 abstract view
.subckt sky130_fd_sc_hd__nor2_1 A B VGND VNB VPB VPWR Y
.ends

* Black-box entry subcircuit for sky130_fd_sc_hd__or3_1 abstract view
.subckt sky130_fd_sc_hd__or3_1 A B C VGND VNB VPB VPWR X
.ends

* Black-box entry subcircuit for sky130_fd_sc_hd__decap_6 abstract view
.subckt sky130_fd_sc_hd__decap_6 VGND VNB VPB VPWR
.ends

* Black-box entry subcircuit for sky130_fd_sc_hd__or3b_1 abstract view
.subckt sky130_fd_sc_hd__or3b_1 A B C_N VGND VNB VPB VPWR X
.ends

* Black-box entry subcircuit for sky130_fd_sc_hd__nand2_1 abstract view
.subckt sky130_fd_sc_hd__nand2_1 A B VGND VNB VPB VPWR Y
.ends

* Black-box entry subcircuit for sky130_fd_sc_hd__o221a_1 abstract view
.subckt sky130_fd_sc_hd__o221a_1 A1 A2 B1 B2 C1 VGND VNB VPB VPWR X
.ends

* Black-box entry subcircuit for sky130_fd_sc_hd__a21oi_1 abstract view
.subckt sky130_fd_sc_hd__a21oi_1 A1 A2 B1 VGND VNB VPB VPWR Y
.ends

* Black-box entry subcircuit for sky130_fd_sc_hd__a211oi_1 abstract view
.subckt sky130_fd_sc_hd__a211oi_1 A1 A2 B1 C1 VGND VNB VPB VPWR Y
.ends

* Black-box entry subcircuit for sky130_fd_sc_hd__decap_3 abstract view
.subckt sky130_fd_sc_hd__decap_3 VGND VNB VPB VPWR
.ends

* Black-box entry subcircuit for sky130_fd_sc_hd__a21o_1 abstract view
.subckt sky130_fd_sc_hd__a21o_1 A1 A2 B1 VGND VNB VPB VPWR X
.ends

* Black-box entry subcircuit for sky130_fd_sc_hd__o21ba_1 abstract view
.subckt sky130_fd_sc_hd__o21ba_1 A1 A2 B1_N VGND VNB VPB VPWR X
.ends

* Black-box entry subcircuit for sky130_fd_sc_hd__o21ai_1 abstract view
.subckt sky130_fd_sc_hd__o21ai_1 A1 A2 B1 VGND VNB VPB VPWR Y
.ends

* Black-box entry subcircuit for sky130_fd_sc_hd__o211ai_1 abstract view
.subckt sky130_fd_sc_hd__o211ai_1 A1 A2 B1 C1 VGND VNB VPB VPWR Y
.ends

* Black-box entry subcircuit for sky130_fd_sc_hd__clkbuf_16 abstract view
.subckt sky130_fd_sc_hd__clkbuf_16 A VGND VNB VPB VPWR X
.ends

* Black-box entry subcircuit for sky130_fd_sc_hd__xnor2_1 abstract view
.subckt sky130_fd_sc_hd__xnor2_1 A B VGND VNB VPB VPWR Y
.ends

* Black-box entry subcircuit for sky130_fd_sc_hd__and4b_1 abstract view
.subckt sky130_fd_sc_hd__and4b_1 A_N B C D VGND VNB VPB VPWR X
.ends

* Black-box entry subcircuit for sky130_fd_sc_hd__a31o_1 abstract view
.subckt sky130_fd_sc_hd__a31o_1 A1 A2 A3 B1 VGND VNB VPB VPWR X
.ends

* Black-box entry subcircuit for sky130_fd_sc_hd__o2111ai_1 abstract view
.subckt sky130_fd_sc_hd__o2111ai_1 A1 A2 B1 C1 D1 VGND VNB VPB VPWR Y
.ends

* Black-box entry subcircuit for sky130_fd_sc_hd__o41a_1 abstract view
.subckt sky130_fd_sc_hd__o41a_1 A1 A2 A3 A4 B1 VGND VNB VPB VPWR X
.ends

* Black-box entry subcircuit for sky130_fd_sc_hd__and2_1 abstract view
.subckt sky130_fd_sc_hd__and2_1 A B VGND VNB VPB VPWR X
.ends

* Black-box entry subcircuit for sky130_fd_sc_hd__nor3b_1 abstract view
.subckt sky130_fd_sc_hd__nor3b_1 A B C_N VGND VNB VPB VPWR Y
.ends

* Black-box entry subcircuit for sky130_fd_sc_hd__xor2_1 abstract view
.subckt sky130_fd_sc_hd__xor2_1 A B VGND VNB VPB VPWR X
.ends

* Black-box entry subcircuit for sky130_fd_sc_hd__o2bb2a_1 abstract view
.subckt sky130_fd_sc_hd__o2bb2a_1 A1_N A2_N B1 B2 VGND VNB VPB VPWR X
.ends

* Black-box entry subcircuit for sky130_fd_sc_hd__dlygate4sd3_1 abstract view
.subckt sky130_fd_sc_hd__dlygate4sd3_1 A VGND VNB VPB VPWR X
.ends

* Black-box entry subcircuit for sky130_fd_sc_hd__o21bai_1 abstract view
.subckt sky130_fd_sc_hd__o21bai_1 A1 A2 B1_N VGND VNB VPB VPWR Y
.ends

* Black-box entry subcircuit for sky130_fd_sc_hd__a311o_1 abstract view
.subckt sky130_fd_sc_hd__a311o_1 A1 A2 A3 B1 C1 VGND VNB VPB VPWR X
.ends

* Black-box entry subcircuit for sky130_fd_sc_hd__buf_1 abstract view
.subckt sky130_fd_sc_hd__buf_1 A VGND VNB VPB VPWR X
.ends

* Black-box entry subcircuit for sky130_fd_sc_hd__a21bo_1 abstract view
.subckt sky130_fd_sc_hd__a21bo_1 A1 A2 B1_N VGND VNB VPB VPWR X
.ends

* Black-box entry subcircuit for sky130_fd_sc_hd__and3_1 abstract view
.subckt sky130_fd_sc_hd__and3_1 A B C VGND VNB VPB VPWR X
.ends

* Black-box entry subcircuit for sky130_fd_sc_hd__o21a_1 abstract view
.subckt sky130_fd_sc_hd__o21a_1 A1 A2 B1 VGND VNB VPB VPWR X
.ends

* Black-box entry subcircuit for sky130_fd_sc_hd__a22oi_1 abstract view
.subckt sky130_fd_sc_hd__a22oi_1 A1 A2 B1 B2 VGND VNB VPB VPWR Y
.ends

* Black-box entry subcircuit for sky130_fd_sc_hd__nand3_2 abstract view
.subckt sky130_fd_sc_hd__nand3_2 A B C VGND VNB VPB VPWR Y
.ends

* Black-box entry subcircuit for sky130_fd_sc_hd__clkbuf_2 abstract view
.subckt sky130_fd_sc_hd__clkbuf_2 A VGND VNB VPB VPWR X
.ends

* Black-box entry subcircuit for sky130_fd_sc_hd__a22o_1 abstract view
.subckt sky130_fd_sc_hd__a22o_1 A1 A2 B1 B2 VGND VNB VPB VPWR X
.ends

* Black-box entry subcircuit for sky130_fd_sc_hd__clkinv_2 abstract view
.subckt sky130_fd_sc_hd__clkinv_2 A VGND VNB VPB VPWR Y
.ends

* Black-box entry subcircuit for sky130_fd_sc_hd__dlymetal6s2s_1 abstract view
.subckt sky130_fd_sc_hd__dlymetal6s2s_1 A VGND VNB VPB VPWR X
.ends

* Black-box entry subcircuit for sky130_fd_sc_hd__inv_2 abstract view
.subckt sky130_fd_sc_hd__inv_2 A VGND VNB VPB VPWR Y
.ends

* Black-box entry subcircuit for sky130_fd_sc_hd__clkbuf_4 abstract view
.subckt sky130_fd_sc_hd__clkbuf_4 A VGND VNB VPB VPWR X
.ends

* Black-box entry subcircuit for sky130_fd_sc_hd__nand3_1 abstract view
.subckt sky130_fd_sc_hd__nand3_1 A B C VGND VNB VPB VPWR Y
.ends

* Black-box entry subcircuit for sky130_fd_sc_hd__nand4_1 abstract view
.subckt sky130_fd_sc_hd__nand4_1 A B C D VGND VNB VPB VPWR Y
.ends

* Black-box entry subcircuit for sky130_fd_sc_hd__and3b_1 abstract view
.subckt sky130_fd_sc_hd__and3b_1 A_N B C VGND VNB VPB VPWR X
.ends

* Black-box entry subcircuit for sky130_fd_sc_hd__a32o_1 abstract view
.subckt sky130_fd_sc_hd__a32o_1 A1 A2 A3 B1 B2 VGND VNB VPB VPWR X
.ends

* Black-box entry subcircuit for sky130_fd_sc_hd__and4_2 abstract view
.subckt sky130_fd_sc_hd__and4_2 A B C D VGND VNB VPB VPWR X
.ends

* Black-box entry subcircuit for sky130_fd_sc_hd__a21o_2 abstract view
.subckt sky130_fd_sc_hd__a21o_2 A1 A2 B1 VGND VNB VPB VPWR X
.ends

* Black-box entry subcircuit for sky130_fd_sc_hd__buf_4 abstract view
.subckt sky130_fd_sc_hd__buf_4 A VGND VNB VPB VPWR X
.ends

* Black-box entry subcircuit for sky130_fd_sc_hd__and4bb_1 abstract view
.subckt sky130_fd_sc_hd__and4bb_1 A_N B_N C D VGND VNB VPB VPWR X
.ends

* Black-box entry subcircuit for sky130_fd_sc_hd__mux2_1 abstract view
.subckt sky130_fd_sc_hd__mux2_1 A0 A1 S VGND VNB VPB VPWR X
.ends

* Black-box entry subcircuit for sky130_fd_sc_hd__a211o_1 abstract view
.subckt sky130_fd_sc_hd__a211o_1 A1 A2 B1 C1 VGND VNB VPB VPWR X
.ends

* Black-box entry subcircuit for sky130_fd_sc_hd__a21boi_1 abstract view
.subckt sky130_fd_sc_hd__a21boi_1 A1 A2 B1_N VGND VNB VPB VPWR Y
.ends

* Black-box entry subcircuit for sky130_fd_sc_hd__nand2b_1 abstract view
.subckt sky130_fd_sc_hd__nand2b_1 A_N B VGND VNB VPB VPWR Y
.ends

* Black-box entry subcircuit for sky130_fd_sc_hd__o211ai_2 abstract view
.subckt sky130_fd_sc_hd__o211ai_2 A1 A2 B1 C1 VGND VNB VPB VPWR Y
.ends

* Black-box entry subcircuit for sky130_fd_sc_hd__or4b_1 abstract view
.subckt sky130_fd_sc_hd__or4b_1 A B C D_N VGND VNB VPB VPWR X
.ends

* Black-box entry subcircuit for sky130_fd_sc_hd__a41o_1 abstract view
.subckt sky130_fd_sc_hd__a41o_1 A1 A2 A3 A4 B1 VGND VNB VPB VPWR X
.ends

* Black-box entry subcircuit for sky130_fd_sc_hd__a221o_1 abstract view
.subckt sky130_fd_sc_hd__a221o_1 A1 A2 B1 B2 C1 VGND VNB VPB VPWR X
.ends

* Black-box entry subcircuit for sky130_fd_sc_hd__xor2_2 abstract view
.subckt sky130_fd_sc_hd__xor2_2 A B VGND VNB VPB VPWR X
.ends

* Black-box entry subcircuit for sky130_fd_sc_hd__o311a_1 abstract view
.subckt sky130_fd_sc_hd__o311a_1 A1 A2 A3 B1 C1 VGND VNB VPB VPWR X
.ends

* Black-box entry subcircuit for sky130_fd_sc_hd__a21oi_2 abstract view
.subckt sky130_fd_sc_hd__a21oi_2 A1 A2 B1 VGND VNB VPB VPWR Y
.ends

* Black-box entry subcircuit for sky130_fd_sc_hd__nand3b_1 abstract view
.subckt sky130_fd_sc_hd__nand3b_1 A_N B C VGND VNB VPB VPWR Y
.ends

* Black-box entry subcircuit for sky130_fd_sc_hd__a22oi_2 abstract view
.subckt sky130_fd_sc_hd__a22oi_2 A1 A2 B1 B2 VGND VNB VPB VPWR Y
.ends

* Black-box entry subcircuit for sky130_fd_sc_hd__a211oi_2 abstract view
.subckt sky130_fd_sc_hd__a211oi_2 A1 A2 B1 C1 VGND VNB VPB VPWR Y
.ends

* Black-box entry subcircuit for sky130_fd_sc_hd__o31a_1 abstract view
.subckt sky130_fd_sc_hd__o31a_1 A1 A2 A3 B1 VGND VNB VPB VPWR X
.ends

* Black-box entry subcircuit for sky130_fd_sc_hd__or4b_2 abstract view
.subckt sky130_fd_sc_hd__or4b_2 A B C D_N VGND VNB VPB VPWR X
.ends

.subckt top VGND VPWR aclk aresetn m_axis_tdata[0] m_axis_tdata[10] m_axis_tdata[11]
+ m_axis_tdata[12] m_axis_tdata[13] m_axis_tdata[14] m_axis_tdata[15] m_axis_tdata[16]
+ m_axis_tdata[17] m_axis_tdata[18] m_axis_tdata[19] m_axis_tdata[1] m_axis_tdata[20]
+ m_axis_tdata[21] m_axis_tdata[22] m_axis_tdata[23] m_axis_tdata[24] m_axis_tdata[25]
+ m_axis_tdata[26] m_axis_tdata[27] m_axis_tdata[28] m_axis_tdata[29] m_axis_tdata[2]
+ m_axis_tdata[30] m_axis_tdata[31] m_axis_tdata[3] m_axis_tdata[4] m_axis_tdata[5]
+ m_axis_tdata[6] m_axis_tdata[7] m_axis_tdata[8] m_axis_tdata[9] m_axis_tlast m_axis_tready
+ m_axis_tvalid s_axis_tdata[0] s_axis_tdata[10] s_axis_tdata[11] s_axis_tdata[12]
+ s_axis_tdata[13] s_axis_tdata[14] s_axis_tdata[15] s_axis_tdata[1] s_axis_tdata[2]
+ s_axis_tdata[3] s_axis_tdata[4] s_axis_tdata[5] s_axis_tdata[6] s_axis_tdata[7]
+ s_axis_tdata[8] s_axis_tdata[9] s_axis_tlast s_axis_tready s_axis_tvalid
XTAP_TAPCELL_ROW_9_148 VGND VPWR sky130_fd_sc_hd__tapvpwrvgnd_1
X_1270_ clknet_2_2__leaf_aclk _0000_ VGND VGND VPWR VPWR net21 sky130_fd_sc_hd__dfxtp_1
XTAP_TAPCELL_ROW_14_172 VGND VPWR sky130_fd_sc_hd__tapvpwrvgnd_1
X_0985_ _0331_ _0362_ _0363_ VGND VGND VPWR VPWR _0364_ sky130_fd_sc_hd__nor3_1
XFILLER_47_29 VPWR VGND VPWR VGND sky130_ef_sc_hd__decap_12
Xfanout105 net107 VGND VGND VPWR VPWR net105 sky130_fd_sc_hd__buf_2
XTAP_TAPCELL_ROW_37_286 VGND VPWR sky130_fd_sc_hd__tapvpwrvgnd_1
XFILLER_27_225 VGND VGND VPWR VPWR sky130_fd_sc_hd__decap_8
XFILLER_6_118 VGND VGND VPWR VPWR sky130_fd_sc_hd__fill_2
XFILLER_12_98 VGND VGND VPWR VPWR sky130_fd_sc_hd__fill_1
XTAP_TAPCELL_ROW_28_242 VGND VPWR sky130_fd_sc_hd__tapvpwrvgnd_1
X_0770_ net29 net68 VGND VGND VPWR VPWR _0170_ sky130_fd_sc_hd__or2_1
X_1253_ net111 net67 _0623_ net102 VGND VGND VPWR VPWR _0046_ sky130_fd_sc_hd__o211a_1
X_1322_ net2 VGND VGND VPWR VPWR net55 sky130_fd_sc_hd__clkbuf_1
X_1184_ net78 _0053_ net91 net76 VGND VGND VPWR VPWR _0557_ sky130_fd_sc_hd__a2bb2o_1
XFILLER_24_217 VPWR VGND VPWR VGND sky130_ef_sc_hd__decap_12
X_0968_ net86 net100 net77 net79 VGND VGND VPWR VPWR _0347_ sky130_fd_sc_hd__and4_1
X_0899_ _0280_ _0279_ VGND VGND VPWR VPWR _0281_ sky130_fd_sc_hd__and2b_1
XFILLER_23_75 VPWR VGND VPWR VGND sky130_ef_sc_hd__decap_12
XFILLER_2_121 VGND VGND VPWR VPWR sky130_fd_sc_hd__decap_4
XFILLER_0_57 VPWR VGND VPWR VGND sky130_ef_sc_hd__decap_12
XTAP_TAPCELL_ROW_31_259 VGND VPWR sky130_fd_sc_hd__tapvpwrvgnd_1
XFILLER_9_55 VGND VGND VPWR VPWR sky130_fd_sc_hd__fill_1
XFILLER_14_272 VGND VGND VPWR VPWR sky130_fd_sc_hd__decap_4
X_0822_ net58 net37 VGND VGND VPWR VPWR _0215_ sky130_fd_sc_hd__or2_1
X_0684_ cnn_mac_wrapper.core_inst.product\[7\] net50 VGND VGND VPWR VPWR _0094_ sky130_fd_sc_hd__or2_1
X_0753_ net62 _0153_ _0154_ net103 VGND VGND VPWR VPWR _0015_ sky130_fd_sc_hd__o211a_1
X_1305_ clknet_2_2__leaf_aclk _0035_ VGND VGND VPWR VPWR cnn_mac_wrapper.core_inst.product\[3\]
+ sky130_fd_sc_hd__dfxtp_1
X_1236_ _0582_ _0605_ VGND VGND VPWR VPWR _0607_ sky130_fd_sc_hd__nor2_1
X_1167_ _0501_ _0504_ _0539_ VGND VGND VPWR VPWR _0541_ sky130_fd_sc_hd__or3_1
XTAP_TAPCELL_ROW_22_215 VGND VPWR sky130_fd_sc_hd__tapvpwrvgnd_1
X_1098_ _0457_ _0472_ _0473_ VGND VGND VPWR VPWR _0474_ sky130_fd_sc_hd__nor3_1
XTAP_TAPCELL_ROW_45_329 VGND VPWR sky130_fd_sc_hd__tapvpwrvgnd_1
XFILLER_18_53 VPWR VGND VPWR VGND sky130_ef_sc_hd__decap_12
XFILLER_34_96 VPWR VGND VPWR VGND sky130_ef_sc_hd__decap_12
XFILLER_34_52 VPWR VGND VPWR VGND sky130_ef_sc_hd__decap_12
XFILLER_34_41 VGND VGND VPWR VPWR sky130_fd_sc_hd__fill_1
XFILLER_11_264 VPWR VGND VPWR VGND sky130_ef_sc_hd__decap_12
XFILLER_38_139 VGND VGND VPWR VPWR sky130_fd_sc_hd__fill_1
XFILLER_38_106 VGND VGND VPWR VPWR sky130_fd_sc_hd__fill_2
XFILLER_46_150 VGND VGND VPWR VPWR sky130_fd_sc_hd__decap_6
X_1021_ _0396_ _0397_ _0336_ VGND VGND VPWR VPWR _0399_ sky130_fd_sc_hd__or3b_1
X_0805_ net57 net35 VGND VGND VPWR VPWR _0200_ sky130_fd_sc_hd__nand2_1
X_0667_ net64 _0078_ _0079_ net106 VGND VGND VPWR VPWR _0004_ sky130_fd_sc_hd__o211a_1
X_0736_ net25 net67 _0138_ _0139_ net102 VGND VGND VPWR VPWR _0013_ sky130_fd_sc_hd__o221a_1
X_1219_ _0581_ _0590_ VGND VGND VPWR VPWR _0591_ sky130_fd_sc_hd__nor2_1
XFILLER_4_238 VPWR VGND VPWR VGND sky130_ef_sc_hd__decap_12
XFILLER_20_65 VPWR VGND VPWR VGND sky130_ef_sc_hd__decap_12
XFILLER_43_164 VGND VGND VPWR VPWR sky130_fd_sc_hd__decap_4
XTAP_TAPCELL_ROW_41_310 VGND VPWR sky130_fd_sc_hd__tapvpwrvgnd_1
XFILLER_13_3 VGND VGND VPWR VPWR sky130_fd_sc_hd__decap_4
XFILLER_34_197 VGND VGND VPWR VPWR sky130_fd_sc_hd__decap_8
XFILLER_34_164 VPWR VGND VPWR VGND sky130_ef_sc_hd__decap_12
X_1004_ net86 net75 net16 VGND VGND VPWR VPWR _0382_ sky130_fd_sc_hd__a21oi_1
X_0719_ net23 net69 VGND VGND VPWR VPWR _0125_ sky130_fd_sc_hd__or2_1
XFILLER_15_87 VPWR VGND VPWR VGND sky130_ef_sc_hd__decap_12
Xoutput42 net42 VGND VGND VPWR VPWR m_axis_tdata[29] sky130_fd_sc_hd__buf_2
XFILLER_31_75 VPWR VGND VPWR VGND sky130_ef_sc_hd__decap_12
Xoutput53 net53 VGND VGND VPWR VPWR m_axis_tlast sky130_fd_sc_hd__buf_2
Xoutput31 net31 VGND VGND VPWR VPWR m_axis_tdata[19] sky130_fd_sc_hd__buf_2
XFILLER_16_197 VGND VGND VPWR VPWR sky130_fd_sc_hd__decap_6
XFILLER_39_223 VGND VGND VPWR VPWR sky130_fd_sc_hd__fill_1
XTAP_TAPCELL_ROW_9_149 VGND VPWR sky130_fd_sc_hd__tapvpwrvgnd_1
XFILLER_42_85 VPWR VGND VPWR VGND sky130_ef_sc_hd__decap_12
XFILLER_9_127 VGND VGND VPWR VPWR sky130_fd_sc_hd__fill_1
XFILLER_3_57 VPWR VGND VPWR VGND sky130_ef_sc_hd__decap_12
X_0984_ _0360_ _0361_ _0326_ _0328_ VGND VGND VPWR VPWR _0363_ sky130_fd_sc_hd__a211oi_1
XTAP_TAPCELL_ROW_14_173 VGND VPWR sky130_fd_sc_hd__tapvpwrvgnd_1
Xfanout106 net107 VGND VGND VPWR VPWR net106 sky130_fd_sc_hd__buf_2
XFILLER_42_218 VPWR VGND VPWR VGND sky130_ef_sc_hd__decap_12
XTAP_TAPCELL_ROW_37_287 VGND VPWR sky130_fd_sc_hd__tapvpwrvgnd_1
XFILLER_35_281 VGND VGND VPWR VPWR sky130_fd_sc_hd__decap_3
XFILLER_27_248 VGND VGND VPWR VPWR sky130_fd_sc_hd__fill_1
XFILLER_12_11 VGND VGND VPWR VPWR sky130_fd_sc_hd__fill_2
XFILLER_12_22 VGND VGND VPWR VPWR sky130_fd_sc_hd__decap_6
XFILLER_12_44 VGND VGND VPWR VPWR sky130_fd_sc_hd__decap_3
XTAP_TAPCELL_ROW_5_130 VGND VPWR sky130_fd_sc_hd__tapvpwrvgnd_1
XFILLER_37_63 VPWR VGND VPWR VGND sky130_ef_sc_hd__decap_12
XFILLER_37_30 VPWR VGND VPWR VGND sky130_ef_sc_hd__decap_12
XTAP_TAPCELL_ROW_28_243 VGND VPWR sky130_fd_sc_hd__tapvpwrvgnd_1
XFILLER_41_262 VPWR VGND VPWR VGND sky130_ef_sc_hd__decap_12
XFILLER_45_6 VPWR VGND VPWR VGND sky130_ef_sc_hd__decap_12
X_1252_ _0621_ _0622_ net63 VGND VGND VPWR VPWR _0623_ sky130_fd_sc_hd__a21o_1
X_1321_ clknet_2_0__leaf_aclk _0051_ VGND VGND VPWR VPWR net54 sky130_fd_sc_hd__dfxtp_1
X_1183_ _0494_ _0531_ VGND VGND VPWR VPWR _0556_ sky130_fd_sc_hd__or2_1
XFILLER_17_281 VGND VGND VPWR VPWR sky130_fd_sc_hd__decap_3
XFILLER_24_229 VPWR VGND VPWR VGND sky130_ef_sc_hd__decap_12
X_0967_ net100 net77 VGND VGND VPWR VPWR _0346_ sky130_fd_sc_hd__nand2_1
X_0898_ _0266_ _0268_ _0267_ VGND VGND VPWR VPWR _0280_ sky130_fd_sc_hd__o21ba_1
XPHY_EDGE_ROW_12_Right_12 VGND VGND VPWR VPWR sky130_fd_sc_hd__decap_3
XTAP_TAPCELL_ROW_2_111 VGND VPWR sky130_fd_sc_hd__tapvpwrvgnd_1
XPHY_EDGE_ROW_21_Right_21 VGND VGND VPWR VPWR sky130_fd_sc_hd__decap_3
XPHY_EDGE_ROW_30_Right_30 VGND VGND VPWR VPWR sky130_fd_sc_hd__decap_3
XFILLER_23_87 VPWR VGND VPWR VGND sky130_ef_sc_hd__decap_12
XFILLER_0_69 VPWR VGND VPWR VGND sky130_ef_sc_hd__decap_12
X_0752_ net27 net68 VGND VGND VPWR VPWR _0154_ sky130_fd_sc_hd__or2_1
XFILLER_9_89 VGND VGND VPWR VPWR sky130_fd_sc_hd__fill_2
X_0821_ _0187_ _0212_ _0213_ VGND VGND VPWR VPWR _0214_ sky130_fd_sc_hd__or3_1
XFILLER_43_3 VGND VGND VPWR VPWR sky130_fd_sc_hd__decap_8
X_0683_ cnn_mac_wrapper.core_inst.product\[7\] net50 VGND VGND VPWR VPWR _0093_ sky130_fd_sc_hd__nand2_1
X_1304_ clknet_2_2__leaf_aclk _0034_ VGND VGND VPWR VPWR cnn_mac_wrapper.core_inst.product\[2\]
+ sky130_fd_sc_hd__dfxtp_1
X_1235_ _0582_ _0605_ VGND VGND VPWR VPWR _0606_ sky130_fd_sc_hd__nand2_1
X_1166_ _0501_ _0504_ _0539_ VGND VGND VPWR VPWR _0540_ sky130_fd_sc_hd__o21ai_1
X_1097_ _0469_ _0470_ _0471_ VGND VGND VPWR VPWR _0473_ sky130_fd_sc_hd__o21ba_1
XFILLER_18_65 VGND VGND VPWR VPWR sky130_fd_sc_hd__decap_4
XFILLER_34_64 VGND VGND VPWR VPWR sky130_fd_sc_hd__decap_6
XFILLER_7_225 VPWR VGND VPWR VGND sky130_ef_sc_hd__decap_12
XFILLER_11_243 VGND VGND VPWR VPWR sky130_fd_sc_hd__decap_6
XFILLER_11_276 VGND VGND VPWR VPWR sky130_fd_sc_hd__decap_4
X_1020_ _0393_ _0395_ _0358_ _0360_ VGND VGND VPWR VPWR _0398_ sky130_fd_sc_hd__o211ai_1
XFILLER_46_195 VGND VGND VPWR VPWR sky130_fd_sc_hd__fill_1
X_0804_ net57 net35 VGND VGND VPWR VPWR _0199_ sky130_fd_sc_hd__or2_1
X_0735_ _0136_ _0137_ net67 VGND VGND VPWR VPWR _0139_ sky130_fd_sc_hd__o21ai_1
X_0666_ net47 net74 VGND VGND VPWR VPWR _0079_ sky130_fd_sc_hd__or2_1
Xclkbuf_2_3__f_aclk clknet_0_aclk VGND VGND VPWR VPWR clknet_2_3__leaf_aclk sky130_fd_sc_hd__clkbuf_16
X_1218_ _0558_ _0589_ VGND VGND VPWR VPWR _0590_ sky130_fd_sc_hd__xnor2_1
X_1149_ net80 net78 net91 net16 VGND VGND VPWR VPWR _0523_ sky130_fd_sc_hd__and4b_1
XFILLER_20_77 VGND VGND VPWR VPWR sky130_fd_sc_hd__decap_6
XFILLER_45_30 VPWR VGND VPWR VGND sky130_ef_sc_hd__decap_12
XFILLER_28_162 VPWR VGND VPWR VGND sky130_ef_sc_hd__decap_12
XFILLER_19_140 VPWR VGND VPWR VGND sky130_ef_sc_hd__decap_12
X_1003_ _0340_ _0380_ VGND VGND VPWR VPWR _0381_ sky130_fd_sc_hd__xnor2_1
XFILLER_34_176 VPWR VGND VPWR VGND sky130_ef_sc_hd__decap_12
XPHY_EDGE_ROW_6_Right_6 VGND VGND VPWR VPWR sky130_fd_sc_hd__decap_3
X_0718_ _0122_ _0123_ VGND VGND VPWR VPWR _0124_ sky130_fd_sc_hd__xnor2_1
X_0649_ cnn_mac_wrapper.core_inst.product\[0\] net21 _0059_ _0058_ VGND VGND VPWR
+ VPWR _0064_ sky130_fd_sc_hd__a31o_1
XFILLER_40_102 VPWR VGND VPWR VGND sky130_ef_sc_hd__decap_12
XFILLER_15_11 VGND VGND VPWR VPWR sky130_fd_sc_hd__decap_3
XFILLER_15_55 VGND VGND VPWR VPWR sky130_fd_sc_hd__fill_1
XFILLER_25_110 VGND VGND VPWR VPWR sky130_fd_sc_hd__fill_2
XFILLER_31_65 VGND VGND VPWR VPWR sky130_fd_sc_hd__decap_3
XFILLER_31_54 VGND VGND VPWR VPWR sky130_fd_sc_hd__fill_2
XFILLER_15_99 VPWR VGND VPWR VGND sky130_ef_sc_hd__decap_12
Xoutput32 net32 VGND VGND VPWR VPWR m_axis_tdata[1] sky130_fd_sc_hd__buf_2
Xoutput21 net21 VGND VGND VPWR VPWR m_axis_tdata[0] sky130_fd_sc_hd__buf_2
Xoutput43 net43 VGND VGND VPWR VPWR m_axis_tdata[2] sky130_fd_sc_hd__buf_2
XFILLER_31_87 VGND VGND VPWR VPWR sky130_fd_sc_hd__decap_6
Xoutput54 net54 VGND VGND VPWR VPWR m_axis_tvalid sky130_fd_sc_hd__buf_2
XFILLER_0_231 VPWR VGND VPWR VGND sky130_ef_sc_hd__decap_12
XFILLER_0_253 VPWR VGND VPWR VGND sky130_ef_sc_hd__decap_12
XFILLER_16_154 VPWR VGND VPWR VGND sky130_ef_sc_hd__decap_12
XFILLER_9_106 VGND VGND VPWR VPWR sky130_fd_sc_hd__decap_6
XFILLER_9_139 VGND VGND VPWR VPWR sky130_fd_sc_hd__decap_3
XFILLER_13_113 VPWR VGND VPWR VGND sky130_ef_sc_hd__decap_12
XFILLER_13_135 VPWR VGND VPWR VGND sky130_ef_sc_hd__decap_12
XFILLER_42_97 VPWR VGND VPWR VGND sky130_ef_sc_hd__decap_12
XFILLER_42_75 VGND VGND VPWR VPWR sky130_fd_sc_hd__decap_8
XFILLER_3_69 VPWR VGND VPWR VGND sky130_ef_sc_hd__decap_12
X_0983_ _0326_ _0328_ _0360_ _0361_ VGND VGND VPWR VPWR _0362_ sky130_fd_sc_hd__o211a_1
XTAP_TAPCELL_ROW_14_174 VGND VPWR sky130_fd_sc_hd__tapvpwrvgnd_1
XFILLER_8_183 VPWR VGND VPWR VGND sky130_ef_sc_hd__decap_12
Xfanout107 net1 VGND VGND VPWR VPWR net107 sky130_fd_sc_hd__buf_2
XTAP_TAPCELL_ROW_37_288 VGND VPWR sky130_fd_sc_hd__tapvpwrvgnd_1
XFILLER_37_75 VPWR VGND VPWR VGND sky130_ef_sc_hd__decap_12
XFILLER_37_42 VGND VGND VPWR VPWR sky130_fd_sc_hd__decap_4
XTAP_TAPCELL_ROW_28_244 VGND VPWR sky130_fd_sc_hd__tapvpwrvgnd_1
XFILLER_41_274 VGND VGND VPWR VPWR sky130_fd_sc_hd__fill_2
X_1320_ clknet_2_0__leaf_aclk _0050_ VGND VGND VPWR VPWR cnn_mac_wrapper.valid_pipe\[0\]
+ sky130_fd_sc_hd__dfxtp_1
XFILLER_38_6 VGND VGND VPWR VPWR sky130_fd_sc_hd__decap_6
X_1251_ _0574_ _0600_ _0601_ _0619_ _0620_ VGND VGND VPWR VPWR _0622_ sky130_fd_sc_hd__o2111ai_1
X_1182_ _0552_ _0553_ VGND VGND VPWR VPWR _0555_ sky130_fd_sc_hd__xnor2_1
XTAP_TAPCELL_ROW_19_200 VGND VPWR sky130_fd_sc_hd__tapvpwrvgnd_1
XFILLER_32_274 VGND VGND VPWR VPWR sky130_fd_sc_hd__decap_6
X_0897_ _0275_ _0278_ VGND VGND VPWR VPWR _0279_ sky130_fd_sc_hd__xnor2_1
X_0966_ net99 net81 VGND VGND VPWR VPWR _0345_ sky130_fd_sc_hd__nand2_1
XTAP_TAPCELL_ROW_2_112 VGND VPWR sky130_fd_sc_hd__tapvpwrvgnd_1
XFILLER_3_3 VPWR VGND VPWR VGND sky130_ef_sc_hd__decap_12
XFILLER_23_99 VPWR VGND VPWR VGND sky130_ef_sc_hd__decap_12
XFILLER_0_15 VPWR VGND VPWR VGND sky130_ef_sc_hd__decap_12
X_0820_ net36 net35 net34 net33 net57 VGND VGND VPWR VPWR _0213_ sky130_fd_sc_hd__o41a_1
X_0751_ _0151_ _0152_ VGND VGND VPWR VPWR _0153_ sky130_fd_sc_hd__xnor2_1
XFILLER_9_57 VPWR VGND VPWR VGND sky130_ef_sc_hd__decap_12
X_1303_ clknet_2_2__leaf_aclk _0033_ VGND VGND VPWR VPWR cnn_mac_wrapper.core_inst.product\[1\]
+ sky130_fd_sc_hd__dfxtp_1
X_0682_ net116 net74 _0092_ net106 VGND VGND VPWR VPWR _0006_ sky130_fd_sc_hd__o211a_1
X_1234_ net75 _0053_ _0583_ VGND VGND VPWR VPWR _0605_ sky130_fd_sc_hd__o21ai_1
X_1165_ _0537_ _0538_ VGND VGND VPWR VPWR _0539_ sky130_fd_sc_hd__and2_1
X_1096_ _0469_ _0470_ _0471_ VGND VGND VPWR VPWR _0472_ sky130_fd_sc_hd__nor3b_1
X_0949_ _0325_ _0327_ _0290_ VGND VGND VPWR VPWR _0329_ sky130_fd_sc_hd__a21o_1
XFILLER_34_21 VGND VGND VPWR VPWR sky130_fd_sc_hd__decap_6
XFILLER_34_10 VGND VGND VPWR VPWR sky130_fd_sc_hd__fill_1
XFILLER_7_237 VGND VGND VPWR VPWR sky130_fd_sc_hd__fill_1
XFILLER_11_211 VGND VGND VPWR VPWR sky130_fd_sc_hd__fill_2
XFILLER_46_141 VGND VGND VPWR VPWR sky130_fd_sc_hd__fill_1
XPHY_EDGE_ROW_28_Left_76 VGND VGND VPWR VPWR sky130_fd_sc_hd__decap_3
X_0665_ _0076_ _0077_ VGND VGND VPWR VPWR _0078_ sky130_fd_sc_hd__xor2_1
X_0803_ net34 net68 _0197_ _0198_ net103 VGND VGND VPWR VPWR _0021_ sky130_fd_sc_hd__o221a_1
X_0734_ _0136_ _0137_ VGND VGND VPWR VPWR _0138_ sky130_fd_sc_hd__and2_1
X_1217_ _0587_ _0588_ VGND VGND VPWR VPWR _0589_ sky130_fd_sc_hd__or2_1
X_1148_ net78 net91 _0053_ net80 VGND VGND VPWR VPWR _0522_ sky130_fd_sc_hd__o2bb2a_1
X_1079_ _0450_ _0453_ VGND VGND VPWR VPWR _0455_ sky130_fd_sc_hd__xor2_1
XFILLER_20_89 VGND VGND VPWR VPWR sky130_fd_sc_hd__fill_1
Xhold10 net45 VGND VGND VPWR VPWR net117 sky130_fd_sc_hd__dlygate4sd3_1
XFILLER_28_174 VPWR VGND VPWR VGND sky130_ef_sc_hd__decap_12
XFILLER_29_54 VGND VGND VPWR VPWR sky130_fd_sc_hd__fill_2
XFILLER_45_42 VGND VGND VPWR VPWR sky130_fd_sc_hd__decap_4
XFILLER_3_251 VGND VGND VPWR VPWR sky130_fd_sc_hd__decap_4
XFILLER_19_152 VPWR VGND VPWR VGND sky130_ef_sc_hd__decap_12
X_1002_ _0378_ _0379_ VGND VGND VPWR VPWR _0380_ sky130_fd_sc_hd__nor2_1
XFILLER_34_188 VGND VGND VPWR VPWR sky130_fd_sc_hd__decap_8
X_0648_ cnn_mac_wrapper.core_inst.product\[2\] net43 VGND VGND VPWR VPWR _0063_ sky130_fd_sc_hd__or2_1
X_0717_ _0111_ _0116_ _0112_ VGND VGND VPWR VPWR _0123_ sky130_fd_sc_hd__o21bai_1
XFILLER_40_114 VPWR VGND VPWR VGND sky130_ef_sc_hd__decap_12
Xoutput44 net44 VGND VGND VPWR VPWR m_axis_tdata[30] sky130_fd_sc_hd__buf_2
Xoutput55 net55 VGND VGND VPWR VPWR s_axis_tready sky130_fd_sc_hd__buf_2
XFILLER_0_243 VGND VGND VPWR VPWR sky130_fd_sc_hd__decap_8
XFILLER_0_265 VPWR VGND VPWR VGND sky130_ef_sc_hd__decap_12
Xoutput33 net33 VGND VGND VPWR VPWR m_axis_tdata[20] sky130_fd_sc_hd__buf_2
Xoutput22 net22 VGND VGND VPWR VPWR m_axis_tdata[10] sky130_fd_sc_hd__buf_2
XFILLER_16_166 VPWR VGND VPWR VGND sky130_ef_sc_hd__decap_12
XFILLER_31_169 VGND VGND VPWR VPWR sky130_fd_sc_hd__decap_4
XFILLER_31_103 VGND VGND VPWR VPWR sky130_fd_sc_hd__decap_8
XFILLER_39_225 VGND VGND VPWR VPWR sky130_fd_sc_hd__fill_2
XPHY_EDGE_ROW_15_Left_63 VGND VGND VPWR VPWR sky130_fd_sc_hd__decap_3
XFILLER_30_180 VGND VGND VPWR VPWR sky130_fd_sc_hd__decap_8
XFILLER_26_11 VGND VGND VPWR VPWR sky130_fd_sc_hd__fill_1
XFILLER_26_22 VGND VGND VPWR VPWR sky130_fd_sc_hd__fill_1
XFILLER_42_54 VPWR VGND VPWR VGND sky130_ef_sc_hd__decap_12
XFILLER_42_43 VGND VGND VPWR VPWR sky130_fd_sc_hd__fill_1
XFILLER_13_125 VGND VGND VPWR VPWR sky130_fd_sc_hd__decap_4
XFILLER_13_147 VPWR VGND VPWR VGND sky130_ef_sc_hd__decap_12
XFILLER_13_169 VGND VGND VPWR VPWR sky130_fd_sc_hd__decap_3
XFILLER_3_15 VPWR VGND VPWR VGND sky130_ef_sc_hd__decap_12
XFILLER_44_283 VGND VGND VPWR VPWR sky130_fd_sc_hd__fill_1
X_0982_ _0358_ _0359_ _0338_ VGND VGND VPWR VPWR _0361_ sky130_fd_sc_hd__a21o_1
XFILLER_8_195 VGND VGND VPWR VPWR sky130_fd_sc_hd__fill_1
XTAP_TAPCELL_ROW_14_175 VGND VPWR sky130_fd_sc_hd__tapvpwrvgnd_1
XFILLER_42_209 VGND VGND VPWR VPWR sky130_fd_sc_hd__decap_6
XTAP_TAPCELL_ROW_37_289 VGND VPWR sky130_fd_sc_hd__tapvpwrvgnd_1
XFILLER_35_261 VGND VGND VPWR VPWR sky130_fd_sc_hd__decap_8
XFILLER_10_139 VGND VGND VPWR VPWR sky130_fd_sc_hd__fill_1
XPHY_EDGE_ROW_0_Left_48 VGND VGND VPWR VPWR sky130_fd_sc_hd__decap_3
XFILLER_12_57 VPWR VGND VPWR VGND sky130_ef_sc_hd__decap_12
XFILLER_37_87 VPWR VGND VPWR VGND sky130_ef_sc_hd__decap_12
XFILLER_37_54 VGND VGND VPWR VPWR sky130_fd_sc_hd__fill_2
XFILLER_26_250 VGND VGND VPWR VPWR sky130_fd_sc_hd__fill_2
XTAP_TAPCELL_ROW_28_245 VGND VPWR sky130_fd_sc_hd__tapvpwrvgnd_1
XFILLER_5_121 VGND VGND VPWR VPWR sky130_fd_sc_hd__fill_2
XTAP_TAPCELL_ROW_11_156 VGND VPWR sky130_fd_sc_hd__tapvpwrvgnd_1
X_1181_ _0552_ _0553_ VGND VGND VPWR VPWR _0554_ sky130_fd_sc_hd__nand2_1
X_1250_ _0571_ _0574_ _0601_ _0619_ _0600_ VGND VGND VPWR VPWR _0621_ sky130_fd_sc_hd__a311o_1
X_0896_ _0276_ _0277_ VGND VGND VPWR VPWR _0278_ sky130_fd_sc_hd__nor2_1
X_0965_ _0339_ _0343_ VGND VGND VPWR VPWR _0344_ sky130_fd_sc_hd__xnor2_1
XTAP_TAPCELL_ROW_2_113 VGND VPWR sky130_fd_sc_hd__tapvpwrvgnd_1
XFILLER_23_231 VPWR VGND VPWR VGND sky130_ef_sc_hd__decap_12
XTAP_TAPCELL_ROW_25_226 VGND VPWR sky130_fd_sc_hd__tapvpwrvgnd_1
XTAP_TAPCELL_ROW_33_270 VGND VPWR sky130_fd_sc_hd__tapvpwrvgnd_1
XFILLER_0_27 VGND VGND VPWR VPWR sky130_fd_sc_hd__fill_1
XFILLER_9_47 VGND VGND VPWR VPWR sky130_fd_sc_hd__decap_8
XFILLER_9_69 VPWR VGND VPWR VGND sky130_ef_sc_hd__decap_12
XFILLER_14_253 VGND VGND VPWR VPWR sky130_fd_sc_hd__fill_2
X_0681_ net74 _0091_ VGND VGND VPWR VPWR _0092_ sky130_fd_sc_hd__nand2_1
Xfanout90 net17 VGND VGND VPWR VPWR net90 sky130_fd_sc_hd__buf_1
X_0750_ _0140_ _0146_ _0141_ VGND VGND VPWR VPWR _0152_ sky130_fd_sc_hd__a21bo_1
X_1302_ clknet_2_2__leaf_aclk _0032_ VGND VGND VPWR VPWR cnn_mac_wrapper.core_inst.product\[0\]
+ sky130_fd_sc_hd__dfxtp_1
X_1233_ cnn_mac_wrapper.core_inst.product\[13\] net67 _0603_ _0604_ net102 VGND VGND
+ VPWR VPWR _0045_ sky130_fd_sc_hd__o221a_1
XFILLER_29_3 VGND VGND VPWR VPWR sky130_fd_sc_hd__fill_1
XTAP_TAPCELL_ROW_47_340 VGND VPWR sky130_fd_sc_hd__tapvpwrvgnd_1
X_1164_ _0527_ _0536_ VGND VGND VPWR VPWR _0538_ sky130_fd_sc_hd__nand2_1
X_1095_ _0421_ _0429_ _0428_ VGND VGND VPWR VPWR _0471_ sky130_fd_sc_hd__a21bo_1
X_0948_ _0290_ _0325_ _0327_ VGND VGND VPWR VPWR _0328_ sky130_fd_sc_hd__and3_1
XFILLER_20_212 VGND VGND VPWR VPWR sky130_fd_sc_hd__decap_3
XFILLER_20_256 VGND VGND VPWR VPWR sky130_fd_sc_hd__fill_1
XFILLER_20_267 VPWR VGND VPWR VGND sky130_ef_sc_hd__decap_12
XTAP_TAPCELL_ROW_30_251 VGND VPWR sky130_fd_sc_hd__tapvpwrvgnd_1
X_0879_ net86 net100 net88 VGND VGND VPWR VPWR _0263_ sky130_fd_sc_hd__and3_1
XFILLER_47_109 VGND VGND VPWR VPWR sky130_fd_sc_hd__decap_3
XPHY_EDGE_ROW_3_Left_51 VGND VGND VPWR VPWR sky130_fd_sc_hd__decap_3
XFILLER_46_197 VGND VGND VPWR VPWR sky130_fd_sc_hd__decap_8
XTAP_TAPCELL_ROW_44_321 VGND VPWR sky130_fd_sc_hd__tapvpwrvgnd_1
X_0802_ _0185_ _0192_ _0195_ net62 VGND VGND VPWR VPWR _0198_ sky130_fd_sc_hd__a31o_1
X_0664_ _0069_ _0070_ _0068_ VGND VGND VPWR VPWR _0077_ sky130_fd_sc_hd__a21bo_1
XFILLER_6_282 VGND VGND VPWR VPWR sky130_fd_sc_hd__fill_2
X_0733_ _0128_ _0132_ _0127_ VGND VGND VPWR VPWR _0137_ sky130_fd_sc_hd__o21a_1
XFILLER_37_120 VPWR VGND VPWR VGND sky130_ef_sc_hd__decap_12
X_1216_ _0584_ _0586_ _0582_ VGND VGND VPWR VPWR _0588_ sky130_fd_sc_hd__a21oi_1
XFILLER_1_81 VPWR VGND VPWR VGND sky130_ef_sc_hd__decap_12
X_1147_ _0493_ _0497_ _0495_ VGND VGND VPWR VPWR _0521_ sky130_fd_sc_hd__o21a_1
X_1078_ _0450_ _0453_ VGND VGND VPWR VPWR _0454_ sky130_fd_sc_hd__and2_1
XPHY_EDGE_ROW_45_Left_93 VGND VGND VPWR VPWR sky130_fd_sc_hd__decap_3
Xhold11 cnn_mac_wrapper.core_inst.product\[11\] VGND VGND VPWR VPWR net118 sky130_fd_sc_hd__dlygate4sd3_1
XFILLER_43_134 VGND VGND VPWR VPWR sky130_fd_sc_hd__fill_1
XFILLER_28_186 VGND VGND VPWR VPWR sky130_fd_sc_hd__decap_6
XFILLER_28_197 VGND VGND VPWR VPWR sky130_fd_sc_hd__fill_2
XFILLER_6_26 VGND VGND VPWR VPWR sky130_fd_sc_hd__fill_2
XFILLER_6_15 VGND VGND VPWR VPWR sky130_fd_sc_hd__decap_4
XFILLER_20_7 VGND VGND VPWR VPWR sky130_fd_sc_hd__fill_1
XFILLER_34_156 VGND VGND VPWR VPWR sky130_fd_sc_hd__fill_1
XFILLER_19_164 VGND VGND VPWR VPWR sky130_fd_sc_hd__decap_4
X_1001_ net97 net80 net79 net99 VGND VGND VPWR VPWR _0379_ sky130_fd_sc_hd__a22oi_1
X_0647_ cnn_mac_wrapper.core_inst.product\[2\] net43 VGND VGND VPWR VPWR _0062_ sky130_fd_sc_hd__nand2_1
X_0716_ _0119_ _0121_ VGND VGND VPWR VPWR _0122_ sky130_fd_sc_hd__nand2_1
XFILLER_40_126 VGND VGND VPWR VPWR sky130_fd_sc_hd__decap_6
XFILLER_15_57 VGND VGND VPWR VPWR sky130_fd_sc_hd__decap_4
XFILLER_25_167 VGND VGND VPWR VPWR sky130_fd_sc_hd__fill_1
XFILLER_31_34 VPWR VGND VPWR VGND sky130_ef_sc_hd__decap_12
Xoutput34 net34 VGND VGND VPWR VPWR m_axis_tdata[21] sky130_fd_sc_hd__buf_2
Xoutput23 net23 VGND VGND VPWR VPWR m_axis_tdata[11] sky130_fd_sc_hd__buf_2
Xoutput45 net45 VGND VGND VPWR VPWR m_axis_tdata[31] sky130_fd_sc_hd__buf_2
XFILLER_0_277 VGND VGND VPWR VPWR sky130_fd_sc_hd__decap_3
XFILLER_16_178 VPWR VGND VPWR VGND sky130_ef_sc_hd__decap_12
XFILLER_47_281 VGND VGND VPWR VPWR sky130_fd_sc_hd__decap_3
XFILLER_11_3 VPWR VGND VPWR VGND sky130_ef_sc_hd__decap_12
XFILLER_22_137 VGND VGND VPWR VPWR sky130_fd_sc_hd__decap_3
XFILLER_45_229 VGND VGND VPWR VPWR sky130_fd_sc_hd__fill_1
XFILLER_13_104 VGND VGND VPWR VPWR sky130_fd_sc_hd__decap_3
XFILLER_26_34 VPWR VGND VPWR VGND sky130_ef_sc_hd__decap_12
XFILLER_42_66 VGND VGND VPWR VPWR sky130_fd_sc_hd__fill_2
XFILLER_13_159 VGND VGND VPWR VPWR sky130_fd_sc_hd__decap_4
XFILLER_21_181 VGND VGND VPWR VPWR sky130_fd_sc_hd__decap_3
XFILLER_3_27 VPWR VGND VPWR VGND sky130_ef_sc_hd__decap_12
XTAP_TAPCELL_ROW_8_141 VGND VPWR sky130_fd_sc_hd__tapvpwrvgnd_1
XFILLER_29_281 VGND VGND VPWR VPWR sky130_fd_sc_hd__decap_3
XFILLER_44_251 VGND VGND VPWR VPWR sky130_fd_sc_hd__fill_1
X_0981_ _0338_ _0358_ _0359_ VGND VGND VPWR VPWR _0360_ sky130_fd_sc_hd__nand3_2
XPHY_EDGE_ROW_32_Left_80 VGND VGND VPWR VPWR sky130_fd_sc_hd__decap_3
XFILLER_8_141 VPWR VGND VPWR VGND sky130_ef_sc_hd__decap_12
XFILLER_12_69 VPWR VGND VPWR VGND sky130_ef_sc_hd__decap_12
XFILLER_37_99 VGND VGND VPWR VPWR sky130_fd_sc_hd__decap_3
XFILLER_5_155 VPWR VGND VPWR VGND sky130_ef_sc_hd__decap_12
XFILLER_5_111 VGND VGND VPWR VPWR sky130_fd_sc_hd__fill_1
XTAP_TAPCELL_ROW_11_157 VGND VPWR sky130_fd_sc_hd__tapvpwrvgnd_1
X_1180_ _0499_ _0532_ _0467_ VGND VGND VPWR VPWR _0553_ sky130_fd_sc_hd__o21ai_1
XFILLER_17_273 VGND VGND VPWR VPWR sky130_fd_sc_hd__decap_3
X_0964_ _0341_ _0342_ VGND VGND VPWR VPWR _0343_ sky130_fd_sc_hd__and2b_1
XFILLER_32_221 VGND VGND VPWR VPWR sky130_fd_sc_hd__decap_4
X_0895_ net85 net101 net82 net87 VGND VGND VPWR VPWR _0277_ sky130_fd_sc_hd__a22oi_1
XTAP_TAPCELL_ROW_2_114 VGND VPWR sky130_fd_sc_hd__tapvpwrvgnd_1
XFILLER_23_243 VPWR VGND VPWR VGND sky130_ef_sc_hd__decap_12
XTAP_TAPCELL_ROW_25_227 VGND VPWR sky130_fd_sc_hd__tapvpwrvgnd_1
XFILLER_23_57 VGND VGND VPWR VPWR sky130_fd_sc_hd__decap_8
XFILLER_2_125 VGND VGND VPWR VPWR sky130_fd_sc_hd__fill_1
Xfanout91 net15 VGND VGND VPWR VPWR net91 sky130_fd_sc_hd__clkbuf_2
Xfanout80 net6 VGND VGND VPWR VPWR net80 sky130_fd_sc_hd__clkbuf_2
X_0680_ _0088_ _0090_ VGND VGND VPWR VPWR _0091_ sky130_fd_sc_hd__xnor2_1
X_1301_ clknet_2_3__leaf_aclk _0031_ VGND VGND VPWR VPWR net45 sky130_fd_sc_hd__dfxtp_1
X_1232_ _0571_ _0574_ _0602_ net63 VGND VGND VPWR VPWR _0604_ sky130_fd_sc_hd__a31o_1
XTAP_TAPCELL_ROW_47_341 VGND VPWR sky130_fd_sc_hd__tapvpwrvgnd_1
X_1163_ _0527_ _0536_ VGND VGND VPWR VPWR _0537_ sky130_fd_sc_hd__or2_1
X_1094_ _0467_ _0468_ _0462_ VGND VGND VPWR VPWR _0470_ sky130_fd_sc_hd__a21oi_1
X_0947_ _0323_ _0324_ _0309_ VGND VGND VPWR VPWR _0327_ sky130_fd_sc_hd__a21o_1
XFILLER_20_279 VGND VGND VPWR VPWR sky130_fd_sc_hd__decap_4
XTAP_TAPCELL_ROW_30_252 VGND VPWR sky130_fd_sc_hd__tapvpwrvgnd_1
X_0878_ net86 net88 net89 net100 VGND VGND VPWR VPWR _0262_ sky130_fd_sc_hd__a22o_1
XFILLER_11_235 VGND VGND VPWR VPWR sky130_fd_sc_hd__decap_3
XFILLER_7_206 VGND VGND VPWR VPWR sky130_fd_sc_hd__fill_2
Xclkload0 clknet_2_1__leaf_aclk VGND VGND VPWR VPWR clkload0/Y sky130_fd_sc_hd__clkinv_2
XFILLER_46_187 VGND VGND VPWR VPWR sky130_fd_sc_hd__decap_8
XTAP_TAPCELL_ROW_44_322 VGND VPWR sky130_fd_sc_hd__tapvpwrvgnd_1
X_0801_ _0185_ _0192_ _0195_ VGND VGND VPWR VPWR _0197_ sky130_fd_sc_hd__a21oi_1
X_0663_ _0074_ _0075_ VGND VGND VPWR VPWR _0076_ sky130_fd_sc_hd__nor2_1
XFILLER_6_250 VGND VGND VPWR VPWR sky130_fd_sc_hd__fill_2
X_0732_ cnn_mac_wrapper.core_inst.product\[13\] net25 VGND VGND VPWR VPWR _0136_ sky130_fd_sc_hd__xor2_1
XFILLER_37_154 VGND VGND VPWR VPWR sky130_fd_sc_hd__decap_6
XFILLER_37_132 VPWR VGND VPWR VGND sky130_ef_sc_hd__decap_12
XFILLER_37_110 VGND VGND VPWR VPWR sky130_fd_sc_hd__fill_2
X_1215_ _0582_ _0584_ _0586_ VGND VGND VPWR VPWR _0587_ sky130_fd_sc_hd__and3_1
X_1146_ _0452_ _0491_ _0490_ VGND VGND VPWR VPWR _0520_ sky130_fd_sc_hd__a21o_1
XFILLER_1_93 VPWR VGND VPWR VGND sky130_ef_sc_hd__decap_12
X_1077_ _0451_ _0452_ VGND VGND VPWR VPWR _0453_ sky130_fd_sc_hd__nor2_1
Xhold12 cnn_mac_wrapper.core_inst.product\[0\] VGND VGND VPWR VPWR net119 sky130_fd_sc_hd__dlygate4sd3_1
XFILLER_3_264 VGND VGND VPWR VPWR sky130_fd_sc_hd__fill_1
XFILLER_10_80 VGND VGND VPWR VPWR sky130_fd_sc_hd__decap_4
X_1000_ net99 net97 net80 net79 VGND VGND VPWR VPWR _0378_ sky130_fd_sc_hd__and4_1
X_0715_ cnn_mac_wrapper.core_inst.product\[11\] net23 VGND VGND VPWR VPWR _0121_ sky130_fd_sc_hd__nand2_1
X_0646_ net65 _0060_ _0061_ net105 VGND VGND VPWR VPWR _0001_ sky130_fd_sc_hd__o211a_1
X_1129_ _0492_ _0503_ VGND VGND VPWR VPWR _0504_ sky130_fd_sc_hd__nor2_1
XFILLER_25_113 VGND VGND VPWR VPWR sky130_fd_sc_hd__decap_6
XFILLER_31_24 VGND VGND VPWR VPWR sky130_fd_sc_hd__fill_1
XFILLER_15_25 VPWR VGND VPWR VGND sky130_ef_sc_hd__decap_12
Xoutput46 net46 VGND VGND VPWR VPWR m_axis_tdata[3] sky130_fd_sc_hd__buf_2
XFILLER_31_57 VGND VGND VPWR VPWR sky130_fd_sc_hd__decap_8
XFILLER_31_46 VGND VGND VPWR VPWR sky130_fd_sc_hd__fill_2
Xoutput35 net35 VGND VGND VPWR VPWR m_axis_tdata[22] sky130_fd_sc_hd__buf_2
Xoutput24 net24 VGND VGND VPWR VPWR m_axis_tdata[12] sky130_fd_sc_hd__buf_2
XFILLER_0_223 VGND VGND VPWR VPWR sky130_fd_sc_hd__fill_1
XPHY_EDGE_ROW_19_Right_19 VGND VGND VPWR VPWR sky130_fd_sc_hd__decap_3
XPHY_EDGE_ROW_28_Right_28 VGND VGND VPWR VPWR sky130_fd_sc_hd__decap_3
XFILLER_39_238 VGND VGND VPWR VPWR sky130_fd_sc_hd__decap_4
XPHY_EDGE_ROW_37_Right_37 VGND VGND VPWR VPWR sky130_fd_sc_hd__decap_3
XFILLER_22_116 VGND VGND VPWR VPWR sky130_fd_sc_hd__decap_4
XFILLER_30_171 VGND VGND VPWR VPWR sky130_fd_sc_hd__fill_1
XPHY_EDGE_ROW_46_Right_46 VGND VGND VPWR VPWR sky130_fd_sc_hd__decap_3
XFILLER_38_282 VGND VGND VPWR VPWR sky130_fd_sc_hd__fill_2
XFILLER_26_46 VPWR VGND VPWR VGND sky130_ef_sc_hd__decap_12
XFILLER_21_160 VGND VGND VPWR VPWR sky130_fd_sc_hd__decap_8
XFILLER_3_39 VPWR VGND VPWR VGND sky130_ef_sc_hd__decap_12
XTAP_TAPCELL_ROW_8_142 VGND VPWR sky130_fd_sc_hd__tapvpwrvgnd_1
X_0980_ _0355_ _0356_ _0357_ VGND VGND VPWR VPWR _0359_ sky130_fd_sc_hd__a21o_1
XFILLER_8_153 VPWR VGND VPWR VGND sky130_ef_sc_hd__decap_12
XFILLER_8_197 VGND VGND VPWR VPWR sky130_fd_sc_hd__decap_8
XFILLER_41_222 VGND VGND VPWR VPWR sky130_fd_sc_hd__fill_2
XFILLER_5_167 VGND VGND VPWR VPWR sky130_fd_sc_hd__fill_1
XTAP_TAPCELL_ROW_11_158 VGND VPWR sky130_fd_sc_hd__tapvpwrvgnd_1
XFILLER_17_241 VPWR VGND VPWR VGND sky130_ef_sc_hd__decap_12
X_0894_ net87 net85 net100 net82 VGND VGND VPWR VPWR _0276_ sky130_fd_sc_hd__and4_1
X_0963_ net83 net98 net96 net84 VGND VGND VPWR VPWR _0342_ sky130_fd_sc_hd__a22o_1
XTAP_TAPCELL_ROW_2_115 VGND VPWR sky130_fd_sc_hd__tapvpwrvgnd_1
XFILLER_23_222 VGND VGND VPWR VPWR sky130_fd_sc_hd__fill_2
XFILLER_23_255 VGND VGND VPWR VPWR sky130_fd_sc_hd__fill_2
XTAP_TAPCELL_ROW_25_228 VGND VPWR sky130_fd_sc_hd__tapvpwrvgnd_1
XFILLER_0_29 VPWR VGND VPWR VGND sky130_ef_sc_hd__decap_12
Xfanout81 net6 VGND VGND VPWR VPWR net81 sky130_fd_sc_hd__dlymetal6s2s_1
Xfanout92 net15 VGND VGND VPWR VPWR net92 sky130_fd_sc_hd__buf_1
XFILLER_9_27 VPWR VGND VPWR VGND sky130_ef_sc_hd__decap_12
XFILLER_14_244 VGND VGND VPWR VPWR sky130_fd_sc_hd__decap_3
Xfanout70 _0054_ VGND VGND VPWR VPWR net70 sky130_fd_sc_hd__dlymetal6s2s_1
X_1300_ clknet_2_3__leaf_aclk _0030_ VGND VGND VPWR VPWR net44 sky130_fd_sc_hd__dfxtp_1
X_1231_ _0571_ _0574_ _0602_ VGND VGND VPWR VPWR _0603_ sky130_fd_sc_hd__a21oi_1
X_1162_ _0533_ _0534_ VGND VGND VPWR VPWR _0536_ sky130_fd_sc_hd__xnor2_1
XTAP_TAPCELL_ROW_47_342 VGND VPWR sky130_fd_sc_hd__tapvpwrvgnd_1
X_1093_ _0462_ _0467_ _0468_ VGND VGND VPWR VPWR _0469_ sky130_fd_sc_hd__and3_1
X_0877_ net119 net71 _0261_ net105 VGND VGND VPWR VPWR _0032_ sky130_fd_sc_hd__o211a_1
X_0946_ _0325_ VGND VGND VPWR VPWR _0326_ sky130_fd_sc_hd__inv_2
XFILLER_9_281 VGND VGND VPWR VPWR sky130_fd_sc_hd__decap_3
XTAP_TAPCELL_ROW_30_253 VGND VPWR sky130_fd_sc_hd__tapvpwrvgnd_1
Xclkload1 clknet_2_3__leaf_aclk VGND VGND VPWR VPWR clkload1/X sky130_fd_sc_hd__clkbuf_4
XFILLER_34_79 VGND VGND VPWR VPWR sky130_fd_sc_hd__decap_4
XFILLER_1_3 VPWR VGND VPWR VGND sky130_ef_sc_hd__decap_12
XFILLER_46_100 VPWR VGND VPWR VGND sky130_ef_sc_hd__decap_12
XFILLER_46_177 VGND VGND VPWR VPWR sky130_fd_sc_hd__fill_2
XTAP_TAPCELL_ROW_44_323 VGND VPWR sky130_fd_sc_hd__tapvpwrvgnd_1
XFILLER_6_262 VGND VGND VPWR VPWR sky130_fd_sc_hd__decap_4
X_0800_ _0195_ VGND VGND VPWR VPWR _0196_ sky130_fd_sc_hd__inv_2
X_0731_ net24 net70 _0135_ net102 VGND VGND VPWR VPWR _0012_ sky130_fd_sc_hd__o211a_1
X_0662_ cnn_mac_wrapper.core_inst.product\[4\] net47 VGND VGND VPWR VPWR _0075_ sky130_fd_sc_hd__nor2_1
XFILLER_37_188 VGND VGND VPWR VPWR sky130_fd_sc_hd__decap_4
XFILLER_37_144 VGND VGND VPWR VPWR sky130_fd_sc_hd__fill_2
X_1214_ net76 _0053_ _0583_ VGND VGND VPWR VPWR _0586_ sky130_fd_sc_hd__or3_1
X_1145_ _0514_ _0516_ _0513_ VGND VGND VPWR VPWR _0519_ sky130_fd_sc_hd__a21oi_1
X_1076_ net84 net82 net91 net16 VGND VGND VPWR VPWR _0452_ sky130_fd_sc_hd__and4b_1
X_0929_ _0291_ _0299_ _0298_ VGND VGND VPWR VPWR _0309_ sky130_fd_sc_hd__o21bai_1
XFILLER_20_26 VGND VGND VPWR VPWR sky130_fd_sc_hd__fill_2
Xhold13 net51 VGND VGND VPWR VPWR net120 sky130_fd_sc_hd__dlygate4sd3_1
XFILLER_29_57 VGND VGND VPWR VPWR sky130_fd_sc_hd__decap_8
XFILLER_45_78 VGND VGND VPWR VPWR sky130_fd_sc_hd__fill_2
XFILLER_3_276 VGND VGND VPWR VPWR sky130_fd_sc_hd__decap_4
XFILLER_19_111 VGND VGND VPWR VPWR sky130_fd_sc_hd__fill_1
XFILLER_19_133 VGND VGND VPWR VPWR sky130_fd_sc_hd__fill_2
X_0645_ net32 net72 VGND VGND VPWR VPWR _0061_ sky130_fd_sc_hd__or2_1
X_0714_ cnn_mac_wrapper.core_inst.product\[11\] net23 VGND VGND VPWR VPWR _0120_ sky130_fd_sc_hd__and2_1
XFILLER_15_37 VPWR VGND VPWR VGND sky130_ef_sc_hd__decap_12
X_1128_ _0501_ _0502_ VGND VGND VPWR VPWR _0503_ sky130_fd_sc_hd__or2_1
XFILLER_25_169 VPWR VGND VPWR VGND sky130_ef_sc_hd__decap_12
X_1059_ _0416_ _0433_ _0434_ VGND VGND VPWR VPWR _0436_ sky130_fd_sc_hd__nand3_1
Xoutput47 net47 VGND VGND VPWR VPWR m_axis_tdata[4] sky130_fd_sc_hd__buf_2
Xoutput25 net25 VGND VGND VPWR VPWR m_axis_tdata[13] sky130_fd_sc_hd__buf_2
Xoutput36 net36 VGND VGND VPWR VPWR m_axis_tdata[23] sky130_fd_sc_hd__buf_2
XFILLER_31_117 VPWR VGND VPWR VGND sky130_ef_sc_hd__decap_12
XFILLER_21_91 VGND VGND VPWR VPWR sky130_fd_sc_hd__fill_2
XTAP_TAPCELL_ROW_17_186 VGND VPWR sky130_fd_sc_hd__tapvpwrvgnd_1
XFILLER_42_35 VGND VGND VPWR VPWR sky130_fd_sc_hd__decap_8
XFILLER_26_58 VPWR VGND VPWR VGND sky130_ef_sc_hd__decap_12
XFILLER_21_194 VGND VGND VPWR VPWR sky130_fd_sc_hd__fill_1
XTAP_TAPCELL_ROW_8_143 VGND VPWR sky130_fd_sc_hd__tapvpwrvgnd_1
XFILLER_44_253 VPWR VGND VPWR VGND sky130_ef_sc_hd__decap_12
XFILLER_36_209 VPWR VGND VPWR VGND sky130_ef_sc_hd__decap_12
XFILLER_29_261 VGND VGND VPWR VPWR sky130_fd_sc_hd__fill_2
XFILLER_12_183 VPWR VGND VPWR VGND sky130_ef_sc_hd__decap_12
XFILLER_8_165 VGND VGND VPWR VPWR sky130_fd_sc_hd__decap_4
XPHY_EDGE_ROW_19_Left_67 VGND VGND VPWR VPWR sky130_fd_sc_hd__decap_3
XFILLER_10_109 VPWR VGND VPWR VGND sky130_ef_sc_hd__decap_12
XFILLER_18_209 VPWR VGND VPWR VGND sky130_ef_sc_hd__decap_12
XFILLER_26_220 VGND VGND VPWR VPWR sky130_fd_sc_hd__decap_6
XTAP_TAPCELL_ROW_36_281 VGND VPWR sky130_fd_sc_hd__tapvpwrvgnd_1
XFILLER_5_113 VGND VGND VPWR VPWR sky130_fd_sc_hd__decap_8
XTAP_TAPCELL_ROW_11_159 VGND VPWR sky130_fd_sc_hd__tapvpwrvgnd_1
XFILLER_17_253 VPWR VGND VPWR VGND sky130_ef_sc_hd__decap_12
X_0893_ net88 net99 VGND VGND VPWR VPWR _0275_ sky130_fd_sc_hd__nand2_1
X_0962_ net84 net83 net98 net96 VGND VGND VPWR VPWR _0341_ sky130_fd_sc_hd__and4_1
XFILLER_23_15 VPWR VGND VPWR VGND sky130_ef_sc_hd__decap_12
XFILLER_23_37 VGND VGND VPWR VPWR sky130_fd_sc_hd__decap_3
XTAP_TAPCELL_ROW_25_229 VGND VPWR sky130_fd_sc_hd__tapvpwrvgnd_1
XFILLER_14_212 VGND VGND VPWR VPWR sky130_fd_sc_hd__fill_1
Xfanout82 net5 VGND VGND VPWR VPWR net82 sky130_fd_sc_hd__buf_2
Xfanout71 net72 VGND VGND VPWR VPWR net71 sky130_fd_sc_hd__clkbuf_2
Xfanout60 net61 VGND VGND VPWR VPWR net60 sky130_fd_sc_hd__clkbuf_1
XFILLER_9_39 VGND VGND VPWR VPWR sky130_fd_sc_hd__decap_4
XFILLER_13_81 VGND VGND VPWR VPWR sky130_fd_sc_hd__fill_1
Xfanout93 net14 VGND VGND VPWR VPWR net93 sky130_fd_sc_hd__buf_2
XTAP_TAPCELL_ROW_47_343 VGND VPWR sky130_fd_sc_hd__tapvpwrvgnd_1
X_1230_ _0600_ _0601_ VGND VGND VPWR VPWR _0602_ sky130_fd_sc_hd__and2b_1
X_1161_ _0533_ _0534_ VGND VGND VPWR VPWR _0535_ sky130_fd_sc_hd__nand2_1
X_1092_ _0422_ _0426_ _0464_ _0465_ VGND VGND VPWR VPWR _0468_ sky130_fd_sc_hd__nand4_1
X_0945_ _0309_ _0323_ _0324_ VGND VGND VPWR VPWR _0325_ sky130_fd_sc_hd__nand3_1
X_0876_ net86 net89 net66 VGND VGND VPWR VPWR _0261_ sky130_fd_sc_hd__a21o_1
XTAP_TAPCELL_ROW_30_254 VGND VPWR sky130_fd_sc_hd__tapvpwrvgnd_1
XTAP_TAPCELL_ROW_21_210 VGND VPWR sky130_fd_sc_hd__tapvpwrvgnd_1
XFILLER_46_112 VPWR VGND VPWR VGND sky130_ef_sc_hd__decap_12
XTAP_TAPCELL_ROW_44_324 VGND VPWR sky130_fd_sc_hd__tapvpwrvgnd_1
X_0661_ cnn_mac_wrapper.core_inst.product\[4\] net47 VGND VGND VPWR VPWR _0074_ sky130_fd_sc_hd__and2_1
X_0730_ _0133_ _0134_ net62 VGND VGND VPWR VPWR _0135_ sky130_fd_sc_hd__a21o_1
X_1213_ _0583_ _0052_ net16 VGND VGND VPWR VPWR _0585_ sky130_fd_sc_hd__and3b_1
XFILLER_27_3 VGND VGND VPWR VPWR sky130_fd_sc_hd__decap_3
XFILLER_1_51 VGND VGND VPWR VPWR sky130_fd_sc_hd__decap_4
X_1075_ net82 net91 _0053_ net84 VGND VGND VPWR VPWR _0451_ sky130_fd_sc_hd__o2bb2a_1
X_1144_ net70 _0517_ _0518_ VGND VGND VPWR VPWR _0042_ sky130_fd_sc_hd__a21oi_1
X_0928_ net110 net72 _0308_ net107 VGND VGND VPWR VPWR _0036_ sky130_fd_sc_hd__o211a_1
X_0859_ _0241_ _0243_ _0246_ VGND VGND VPWR VPWR _0247_ sky130_fd_sc_hd__a21oi_1
XFILLER_28_123 VPWR VGND VPWR VGND sky130_ef_sc_hd__decap_12
Xhold14 net52 VGND VGND VPWR VPWR net121 sky130_fd_sc_hd__dlygate4sd3_1
XPHY_EDGE_ROW_7_Left_55 VGND VGND VPWR VPWR sky130_fd_sc_hd__decap_3
XFILLER_3_211 VPWR VGND VPWR VGND sky130_ef_sc_hd__decap_12
XFILLER_34_126 VGND VGND VPWR VPWR sky130_fd_sc_hd__decap_4
X_0644_ _0057_ _0059_ VGND VGND VPWR VPWR _0060_ sky130_fd_sc_hd__xnor2_1
X_0713_ cnn_mac_wrapper.core_inst.product\[11\] net23 VGND VGND VPWR VPWR _0119_ sky130_fd_sc_hd__or2_1
XFILLER_15_49 VGND VGND VPWR VPWR sky130_fd_sc_hd__decap_6
X_1127_ _0466_ _0469_ _0500_ VGND VGND VPWR VPWR _0502_ sky130_fd_sc_hd__nor3_1
XFILLER_25_137 VPWR VGND VPWR VGND sky130_ef_sc_hd__decap_12
X_1058_ _0416_ _0433_ _0434_ VGND VGND VPWR VPWR _0435_ sky130_fd_sc_hd__and3_1
Xoutput48 net48 VGND VGND VPWR VPWR m_axis_tdata[5] sky130_fd_sc_hd__buf_2
XPHY_EDGE_ROW_1_Right_1 VGND VGND VPWR VPWR sky130_fd_sc_hd__decap_3
Xoutput26 net26 VGND VGND VPWR VPWR m_axis_tdata[14] sky130_fd_sc_hd__buf_2
XFILLER_0_225 VGND VGND VPWR VPWR sky130_fd_sc_hd__fill_2
Xoutput37 net37 VGND VGND VPWR VPWR m_axis_tdata[24] sky130_fd_sc_hd__buf_2
XFILLER_31_129 VPWR VGND VPWR VGND sky130_ef_sc_hd__decap_12
XFILLER_39_207 VGND VGND VPWR VPWR sky130_fd_sc_hd__fill_1
XTAP_TAPCELL_ROW_17_187 VGND VPWR sky130_fd_sc_hd__tapvpwrvgnd_1
XFILLER_22_129 VGND VGND VPWR VPWR sky130_fd_sc_hd__decap_8
XFILLER_7_50 VGND VGND VPWR VPWR sky130_fd_sc_hd__decap_6
XFILLER_15_181 VPWR VGND VPWR VGND sky130_ef_sc_hd__decap_12
XFILLER_7_83 VGND VGND VPWR VPWR sky130_fd_sc_hd__decap_4
XFILLER_13_129 VGND VGND VPWR VPWR sky130_fd_sc_hd__fill_1
XTAP_TAPCELL_ROW_8_144 VGND VPWR sky130_fd_sc_hd__tapvpwrvgnd_1
XFILLER_44_265 VPWR VGND VPWR VGND sky130_ef_sc_hd__decap_12
XFILLER_32_80 VGND VGND VPWR VPWR sky130_fd_sc_hd__decap_4
XFILLER_12_195 VGND VGND VPWR VPWR sky130_fd_sc_hd__fill_1
XFILLER_41_202 VPWR VGND VPWR VGND sky130_ef_sc_hd__decap_12
XTAP_TAPCELL_ROW_36_282 VGND VPWR sky130_fd_sc_hd__tapvpwrvgnd_1
XFILLER_5_103 VGND VGND VPWR VPWR sky130_fd_sc_hd__decap_8
XPHY_EDGE_ROW_36_Left_84 VGND VGND VPWR VPWR sky130_fd_sc_hd__decap_3
XFILLER_5_169 VPWR VGND VPWR VGND sky130_ef_sc_hd__decap_12
XFILLER_17_221 VGND VGND VPWR VPWR sky130_fd_sc_hd__decap_3
XFILLER_17_265 VGND VGND VPWR VPWR sky130_fd_sc_hd__decap_8
XPHY_EDGE_ROW_20_Left_68 VGND VGND VPWR VPWR sky130_fd_sc_hd__decap_3
X_0961_ net82 net96 VGND VGND VPWR VPWR _0340_ sky130_fd_sc_hd__nand2_1
X_0892_ net66 _0273_ _0274_ net105 VGND VGND VPWR VPWR _0034_ sky130_fd_sc_hd__o211a_1
XFILLER_23_202 VPWR VGND VPWR VGND sky130_ef_sc_hd__decap_12
XFILLER_23_27 VGND VGND VPWR VPWR sky130_fd_sc_hd__fill_2
Xfanout72 _0054_ VGND VGND VPWR VPWR net72 sky130_fd_sc_hd__clkbuf_2
Xfanout83 net5 VGND VGND VPWR VPWR net83 sky130_fd_sc_hd__dlymetal6s2s_1
Xfanout94 net14 VGND VGND VPWR VPWR net94 sky130_fd_sc_hd__buf_1
Xfanout61 cnn_mac_wrapper.core_inst.product\[15\] VGND VGND VPWR VPWR net61 sky130_fd_sc_hd__clkbuf_2
XTAP_TAPCELL_ROW_0_96 VGND VPWR sky130_fd_sc_hd__tapvpwrvgnd_1
XTAP_TAPCELL_ROW_47_344 VGND VPWR sky130_fd_sc_hd__tapvpwrvgnd_1
X_1091_ _0466_ VGND VGND VPWR VPWR _0467_ sky130_fd_sc_hd__inv_2
X_1160_ _0498_ _0499_ _0467_ VGND VGND VPWR VPWR _0534_ sky130_fd_sc_hd__o21ai_1
X_0944_ _0316_ _0317_ _0322_ VGND VGND VPWR VPWR _0324_ sky130_fd_sc_hd__a21o_1
X_0875_ net117 net74 _0259_ _0260_ net107 VGND VGND VPWR VPWR _0031_ sky130_fd_sc_hd__o221a_1
XTAP_TAPCELL_ROW_30_255 VGND VPWR sky130_fd_sc_hd__tapvpwrvgnd_1
XFILLER_18_16 VPWR VGND VPWR VGND sky130_ef_sc_hd__decap_12
X_1289_ clknet_2_1__leaf_aclk _0019_ VGND VGND VPWR VPWR net31 sky130_fd_sc_hd__dfxtp_1
XFILLER_11_216 VGND VGND VPWR VPWR sky130_fd_sc_hd__decap_8
XFILLER_46_124 VPWR VGND VPWR VGND sky130_ef_sc_hd__decap_12
XTAP_TAPCELL_ROW_44_325 VGND VPWR sky130_fd_sc_hd__tapvpwrvgnd_1
X_0660_ net113 net71 _0073_ net105 VGND VGND VPWR VPWR _0003_ sky130_fd_sc_hd__o211a_1
XFILLER_41_6 VGND VGND VPWR VPWR sky130_fd_sc_hd__decap_8
XFILLER_37_113 VGND VGND VPWR VPWR sky130_fd_sc_hd__fill_2
X_1212_ net76 _0053_ _0583_ VGND VGND VPWR VPWR _0584_ sky130_fd_sc_hd__o21ai_1
XFILLER_37_179 VGND VGND VPWR VPWR sky130_fd_sc_hd__fill_1
X_1074_ net82 net93 _0419_ _0418_ net95 VGND VGND VPWR VPWR _0450_ sky130_fd_sc_hd__a32o_1
X_1143_ net108 net67 net102 VGND VGND VPWR VPWR _0518_ sky130_fd_sc_hd__o21ai_1
XPHY_EDGE_ROW_23_Left_71 VGND VGND VPWR VPWR sky130_fd_sc_hd__decap_3
X_0927_ _0306_ _0307_ net71 VGND VGND VPWR VPWR _0308_ sky130_fd_sc_hd__o21ai_1
X_0858_ net59 net42 VGND VGND VPWR VPWR _0246_ sky130_fd_sc_hd__xor2_1
X_0789_ _0184_ _0185_ VGND VGND VPWR VPWR _0186_ sky130_fd_sc_hd__nand2_1
Xhold15 cnn_mac_wrapper.valid_pipe\[0\] VGND VGND VPWR VPWR net122 sky130_fd_sc_hd__dlygate4sd3_1
XFILLER_28_135 VGND VGND VPWR VPWR sky130_fd_sc_hd__decap_4
XTAP_TAPCELL_ROW_41_306 VGND VPWR sky130_fd_sc_hd__tapvpwrvgnd_1
XFILLER_3_223 VGND VGND VPWR VPWR sky130_fd_sc_hd__fill_1
XFILLER_19_113 VPWR VGND VPWR VGND sky130_ef_sc_hd__decap_12
XFILLER_34_149 VGND VGND VPWR VPWR sky130_fd_sc_hd__fill_2
XFILLER_34_138 VGND VGND VPWR VPWR sky130_fd_sc_hd__fill_2
XFILLER_19_81 VPWR VGND VPWR VGND sky130_ef_sc_hd__decap_12
XFILLER_35_91 VGND VGND VPWR VPWR sky130_fd_sc_hd__fill_2
X_0643_ cnn_mac_wrapper.core_inst.product\[1\] net32 VGND VGND VPWR VPWR _0059_ sky130_fd_sc_hd__xor2_1
X_0712_ net62 _0117_ _0118_ net103 VGND VGND VPWR VPWR _0010_ sky130_fd_sc_hd__o211a_1
X_1126_ _0466_ _0469_ _0500_ VGND VGND VPWR VPWR _0501_ sky130_fd_sc_hd__o21a_1
XFILLER_25_149 VPWR VGND VPWR VGND sky130_ef_sc_hd__decap_12
X_1057_ _0430_ _0431_ _0432_ VGND VGND VPWR VPWR _0434_ sky130_fd_sc_hd__a21o_1
Xoutput49 net49 VGND VGND VPWR VPWR m_axis_tdata[6] sky130_fd_sc_hd__buf_2
Xoutput27 net27 VGND VGND VPWR VPWR m_axis_tdata[15] sky130_fd_sc_hd__buf_2
Xoutput38 net38 VGND VGND VPWR VPWR m_axis_tdata[25] sky130_fd_sc_hd__buf_2
XFILLER_16_127 VGND VGND VPWR VPWR sky130_fd_sc_hd__fill_2
XFILLER_15_193 VGND VGND VPWR VPWR sky130_fd_sc_hd__fill_1
XTAP_TAPCELL_ROW_17_188 VGND VPWR sky130_fd_sc_hd__tapvpwrvgnd_1
XFILLER_30_141 VGND VGND VPWR VPWR sky130_fd_sc_hd__fill_1
XPHY_EDGE_ROW_15_Right_15 VGND VGND VPWR VPWR sky130_fd_sc_hd__decap_3
XPHY_EDGE_ROW_24_Right_24 VGND VGND VPWR VPWR sky130_fd_sc_hd__decap_3
XFILLER_26_27 VGND VGND VPWR VPWR sky130_fd_sc_hd__fill_1
X_1109_ _0482_ _0483_ net66 VGND VGND VPWR VPWR _0485_ sky130_fd_sc_hd__a21o_1
XFILLER_42_26 VGND VGND VPWR VPWR sky130_fd_sc_hd__fill_2
XFILLER_21_130 VGND VGND VPWR VPWR sky130_fd_sc_hd__decap_8
XPHY_EDGE_ROW_33_Right_33 VGND VGND VPWR VPWR sky130_fd_sc_hd__decap_3
XTAP_TAPCELL_ROW_8_145 VGND VPWR sky130_fd_sc_hd__tapvpwrvgnd_1
XFILLER_44_277 VGND VGND VPWR VPWR sky130_fd_sc_hd__decap_6
XPHY_EDGE_ROW_42_Right_42 VGND VGND VPWR VPWR sky130_fd_sc_hd__decap_3
XFILLER_12_141 VPWR VGND VPWR VGND sky130_ef_sc_hd__decap_12
XFILLER_12_29 VGND VGND VPWR VPWR sky130_fd_sc_hd__decap_8
XTAP_TAPCELL_ROW_5_126 VGND VPWR sky130_fd_sc_hd__tapvpwrvgnd_1
XFILLER_41_225 VPWR VGND VPWR VGND sky130_ef_sc_hd__decap_12
XFILLER_41_214 VGND VGND VPWR VPWR sky130_fd_sc_hd__decap_8
XTAP_TAPCELL_ROW_36_283 VGND VPWR sky130_fd_sc_hd__tapvpwrvgnd_1
X_0960_ net88 net94 VGND VGND VPWR VPWR _0339_ sky130_fd_sc_hd__nand2_1
XFILLER_32_258 VGND VGND VPWR VPWR sky130_fd_sc_hd__fill_1
X_0891_ cnn_mac_wrapper.core_inst.product\[2\] net71 VGND VGND VPWR VPWR _0274_ sky130_fd_sc_hd__or2_1
XFILLER_4_85 VPWR VGND VPWR VGND sky130_ef_sc_hd__decap_12
XFILLER_4_41 VGND VGND VPWR VPWR sky130_fd_sc_hd__decap_8
XFILLER_23_214 VGND VGND VPWR VPWR sky130_fd_sc_hd__decap_8
Xfanout73 _0054_ VGND VGND VPWR VPWR net73 sky130_fd_sc_hd__buf_2
XFILLER_9_19 VGND VGND VPWR VPWR sky130_fd_sc_hd__fill_1
Xfanout62 net63 VGND VGND VPWR VPWR net62 sky130_fd_sc_hd__clkbuf_4
Xfanout84 net4 VGND VGND VPWR VPWR net84 sky130_fd_sc_hd__clkbuf_2
Xfanout95 net13 VGND VGND VPWR VPWR net95 sky130_fd_sc_hd__buf_2
XFILLER_36_9 VGND VGND VPWR VPWR sky130_fd_sc_hd__decap_6
XTAP_TAPCELL_ROW_0_97 VGND VPWR sky130_fd_sc_hd__tapvpwrvgnd_1
XTAP_TAPCELL_ROW_47_345 VGND VPWR sky130_fd_sc_hd__tapvpwrvgnd_1
X_1090_ net86 net100 net99 net9 VGND VGND VPWR VPWR _0466_ sky130_fd_sc_hd__and4_2
X_0874_ _0256_ _0257_ _0258_ net65 VGND VGND VPWR VPWR _0260_ sky130_fd_sc_hd__a31o_1
X_0943_ _0316_ _0317_ _0322_ VGND VGND VPWR VPWR _0323_ sky130_fd_sc_hd__nand3_1
XFILLER_20_239 VPWR VGND VPWR VGND sky130_ef_sc_hd__decap_12
X_1288_ clknet_2_1__leaf_aclk _0018_ VGND VGND VPWR VPWR net30 sky130_fd_sc_hd__dfxtp_1
XFILLER_34_27 VGND VGND VPWR VPWR sky130_fd_sc_hd__fill_1
XFILLER_46_136 VGND VGND VPWR VPWR sky130_fd_sc_hd__decap_4
XFILLER_24_93 VPWR VGND VPWR VGND sky130_ef_sc_hd__decap_12
XFILLER_10_283 VGND VGND VPWR VPWR sky130_fd_sc_hd__fill_1
XFILLER_34_6 VGND VGND VPWR VPWR sky130_fd_sc_hd__decap_4
X_1211_ net91 net75 VGND VGND VPWR VPWR _0583_ sky130_fd_sc_hd__nand2_1
X_1142_ _0514_ _0516_ VGND VGND VPWR VPWR _0517_ sky130_fd_sc_hd__xnor2_1
X_1073_ net64 _0448_ _0449_ net105 VGND VGND VPWR VPWR _0040_ sky130_fd_sc_hd__o211a_1
X_0926_ _0304_ _0305_ _0286_ VGND VGND VPWR VPWR _0307_ sky130_fd_sc_hd__a21oi_1
X_0857_ net123 net73 _0245_ net106 VGND VGND VPWR VPWR _0028_ sky130_fd_sc_hd__o211a_1
XFILLER_20_29 VPWR VGND VPWR VGND sky130_ef_sc_hd__decap_12
Xhold16 net41 VGND VGND VPWR VPWR net123 sky130_fd_sc_hd__dlygate4sd3_1
X_0788_ net57 net33 VGND VGND VPWR VPWR _0185_ sky130_fd_sc_hd__nand2_1
XFILLER_43_128 VGND VGND VPWR VPWR sky130_fd_sc_hd__decap_6
XFILLER_36_180 VPWR VGND VPWR VGND sky130_ef_sc_hd__decap_12
XTAP_TAPCELL_ROW_41_307 VGND VPWR sky130_fd_sc_hd__tapvpwrvgnd_1
XFILLER_19_125 VGND VGND VPWR VPWR sky130_fd_sc_hd__decap_8
XFILLER_19_93 VPWR VGND VPWR VGND sky130_ef_sc_hd__decap_12
XFILLER_19_169 VPWR VGND VPWR VGND sky130_ef_sc_hd__decap_12
X_0711_ net22 net69 VGND VGND VPWR VPWR _0118_ sky130_fd_sc_hd__or2_1
X_0642_ cnn_mac_wrapper.core_inst.product\[1\] net32 VGND VGND VPWR VPWR _0058_ sky130_fd_sc_hd__and2_1
X_1125_ _0498_ _0499_ VGND VGND VPWR VPWR _0500_ sky130_fd_sc_hd__xor2_1
X_1056_ _0430_ _0431_ _0432_ VGND VGND VPWR VPWR _0433_ sky130_fd_sc_hd__nand3_2
X_0909_ net18 net90 net98 net96 VGND VGND VPWR VPWR _0290_ sky130_fd_sc_hd__and4_1
Xoutput39 net39 VGND VGND VPWR VPWR m_axis_tdata[26] sky130_fd_sc_hd__buf_2
Xoutput28 net28 VGND VGND VPWR VPWR m_axis_tdata[16] sky130_fd_sc_hd__buf_2
XFILLER_16_117 VGND VGND VPWR VPWR sky130_fd_sc_hd__fill_1
XFILLER_16_139 VGND VGND VPWR VPWR sky130_fd_sc_hd__fill_1
XFILLER_21_83 VGND VGND VPWR VPWR sky130_fd_sc_hd__decap_4
XFILLER_47_253 VPWR VGND VPWR VGND sky130_ef_sc_hd__decap_12
XTAP_TAPCELL_ROW_17_189 VGND VPWR sky130_fd_sc_hd__tapvpwrvgnd_1
XFILLER_30_153 VGND VGND VPWR VPWR sky130_fd_sc_hd__decap_4
XFILLER_30_197 VGND VGND VPWR VPWR sky130_fd_sc_hd__fill_2
X_1108_ _0482_ _0483_ VGND VGND VPWR VPWR _0484_ sky130_fd_sc_hd__nor2_1
X_1039_ _0408_ _0414_ VGND VGND VPWR VPWR _0416_ sky130_fd_sc_hd__xnor2_1
XFILLER_44_245 VGND VGND VPWR VPWR sky130_fd_sc_hd__decap_6
XFILLER_12_120 VPWR VGND VPWR VGND sky130_ef_sc_hd__decap_12
XFILLER_12_153 VPWR VGND VPWR VGND sky130_ef_sc_hd__decap_12
XTAP_TAPCELL_ROW_13_170 VGND VPWR sky130_fd_sc_hd__tapvpwrvgnd_1
XFILLER_7_190 VGND VGND VPWR VPWR sky130_fd_sc_hd__decap_8
XTAP_TAPCELL_ROW_5_127 VGND VPWR sky130_fd_sc_hd__tapvpwrvgnd_1
XFILLER_41_237 VPWR VGND VPWR VGND sky130_ef_sc_hd__decap_12
XTAP_TAPCELL_ROW_36_284 VGND VPWR sky130_fd_sc_hd__tapvpwrvgnd_1
XFILLER_26_267 VPWR VGND VPWR VGND sky130_ef_sc_hd__decap_12
XTAP_TAPCELL_ROW_27_240 VGND VPWR sky130_fd_sc_hd__tapvpwrvgnd_1
X_0890_ _0271_ _0272_ VGND VGND VPWR VPWR _0273_ sky130_fd_sc_hd__nor2_1
XFILLER_43_92 VGND VGND VPWR VPWR sky130_fd_sc_hd__decap_3
XFILLER_43_81 VGND VGND VPWR VPWR sky130_fd_sc_hd__decap_6
XFILLER_4_182 VPWR VGND VPWR VGND sky130_ef_sc_hd__decap_12
XTAP_TAPCELL_ROW_10_151 VGND VPWR sky130_fd_sc_hd__tapvpwrvgnd_1
XFILLER_4_97 VPWR VGND VPWR VGND sky130_ef_sc_hd__decap_12
XFILLER_4_64 VPWR VGND VPWR VGND sky130_ef_sc_hd__decap_12
XFILLER_31_281 VGND VGND VPWR VPWR sky130_fd_sc_hd__decap_3
Xfanout85 net4 VGND VGND VPWR VPWR net85 sky130_fd_sc_hd__buf_1
Xfanout74 _0054_ VGND VGND VPWR VPWR net74 sky130_fd_sc_hd__dlymetal6s2s_1
Xfanout63 _0055_ VGND VGND VPWR VPWR net63 sky130_fd_sc_hd__buf_2
XTAP_TAPCELL_ROW_24_221 VGND VPWR sky130_fd_sc_hd__tapvpwrvgnd_1
Xfanout96 net13 VGND VGND VPWR VPWR net96 sky130_fd_sc_hd__dlymetal6s2s_1
XFILLER_38_81 VGND VGND VPWR VPWR sky130_fd_sc_hd__decap_3
XTAP_TAPCELL_ROW_0_98 VGND VPWR sky130_fd_sc_hd__tapvpwrvgnd_1
XFILLER_1_185 VPWR VGND VPWR VGND sky130_ef_sc_hd__decap_12
X_0873_ _0257_ _0258_ _0256_ VGND VGND VPWR VPWR _0259_ sky130_fd_sc_hd__a21oi_1
X_0942_ _0320_ _0321_ VGND VGND VPWR VPWR _0322_ sky130_fd_sc_hd__nor2_1
XFILLER_13_281 VGND VGND VPWR VPWR sky130_fd_sc_hd__decap_3
X_1287_ clknet_2_1__leaf_aclk _0017_ VGND VGND VPWR VPWR net29 sky130_fd_sc_hd__dfxtp_1
XFILLER_18_29 VGND VGND VPWR VPWR sky130_fd_sc_hd__decap_6
XFILLER_10_251 VGND VGND VPWR VPWR sky130_fd_sc_hd__fill_1
XFILLER_40_93 VGND VGND VPWR VPWR sky130_fd_sc_hd__decap_3
XFILLER_40_60 VGND VGND VPWR VPWR sky130_fd_sc_hd__fill_1
X_1072_ cnn_mac_wrapper.core_inst.product\[8\] net72 VGND VGND VPWR VPWR _0449_ sky130_fd_sc_hd__or2_1
X_1210_ net93 net75 _0528_ _0494_ VGND VGND VPWR VPWR _0582_ sky130_fd_sc_hd__a31o_1
X_1141_ _0446_ _0447_ _0482_ _0515_ VGND VGND VPWR VPWR _0516_ sky130_fd_sc_hd__a31o_1
X_0925_ _0286_ _0304_ _0305_ VGND VGND VPWR VPWR _0306_ sky130_fd_sc_hd__and3_1
X_0856_ _0243_ _0244_ net64 VGND VGND VPWR VPWR _0245_ sky130_fd_sc_hd__a21o_1
X_0787_ net57 net33 VGND VGND VPWR VPWR _0184_ sky130_fd_sc_hd__or2_1
Xhold17 cnn_mac_wrapper.core_inst.product\[6\] VGND VGND VPWR VPWR net124 sky130_fd_sc_hd__dlygate4sd3_1
XFILLER_29_28 VPWR VGND VPWR VGND sky130_ef_sc_hd__decap_12
XFILLER_36_192 VGND VGND VPWR VPWR sky130_fd_sc_hd__decap_4
XFILLER_28_148 VGND VGND VPWR VPWR sky130_fd_sc_hd__fill_1
XTAP_TAPCELL_ROW_41_308 VGND VPWR sky130_fd_sc_hd__tapvpwrvgnd_1
XFILLER_3_258 VGND VGND VPWR VPWR sky130_fd_sc_hd__decap_6
XFILLER_10_41 VPWR VGND VPWR VGND sky130_ef_sc_hd__decap_12
XFILLER_10_85 VPWR VGND VPWR VGND sky130_ef_sc_hd__decap_12
XFILLER_19_50 VGND VGND VPWR VPWR sky130_fd_sc_hd__decap_6
XFILLER_42_195 VGND VGND VPWR VPWR sky130_fd_sc_hd__fill_1
X_0641_ net65 _0057_ _0056_ net105 VGND VGND VPWR VPWR _0000_ sky130_fd_sc_hd__o211a_1
X_0710_ _0113_ _0116_ VGND VGND VPWR VPWR _0117_ sky130_fd_sc_hd__xnor2_1
XFILLER_25_3 VPWR VGND VPWR VGND sky130_ef_sc_hd__decap_12
X_1124_ _0424_ _0463_ _0466_ VGND VGND VPWR VPWR _0499_ sky130_fd_sc_hd__a21o_2
X_1055_ _0381_ _0387_ _0386_ VGND VGND VPWR VPWR _0432_ sky130_fd_sc_hd__a21bo_1
XFILLER_31_18 VGND VGND VPWR VPWR sky130_fd_sc_hd__decap_3
X_0908_ net18 net98 net95 net90 VGND VGND VPWR VPWR _0289_ sky130_fd_sc_hd__a22oi_1
XFILLER_0_217 VGND VGND VPWR VPWR sky130_fd_sc_hd__decap_6
Xoutput29 net29 VGND VGND VPWR VPWR m_axis_tdata[17] sky130_fd_sc_hd__buf_2
X_0839_ _0218_ _0222_ _0229_ VGND VGND VPWR VPWR _0230_ sky130_fd_sc_hd__a21o_1
XFILLER_24_195 VGND VGND VPWR VPWR sky130_fd_sc_hd__fill_1
XFILLER_21_73 VGND VGND VPWR VPWR sky130_fd_sc_hd__fill_2
XFILLER_47_265 VPWR VGND VPWR VGND sky130_ef_sc_hd__decap_12
XFILLER_30_121 VPWR VGND VPWR VGND sky130_ef_sc_hd__decap_12
XFILLER_30_165 VGND VGND VPWR VPWR sky130_fd_sc_hd__decap_6
XFILLER_7_97 VGND VGND VPWR VPWR sky130_fd_sc_hd__fill_1
XPHY_EDGE_ROW_5_Right_5 VGND VGND VPWR VPWR sky130_fd_sc_hd__decap_3
XFILLER_21_110 VGND VGND VPWR VPWR sky130_fd_sc_hd__fill_2
X_1038_ _0408_ _0414_ VGND VGND VPWR VPWR _0415_ sky130_fd_sc_hd__and2b_1
X_1107_ _0446_ _0447_ _0444_ VGND VGND VPWR VPWR _0483_ sky130_fd_sc_hd__a21oi_1
XFILLER_12_132 VGND VGND VPWR VPWR sky130_fd_sc_hd__decap_8
XFILLER_12_165 VPWR VGND VPWR VGND sky130_ef_sc_hd__decap_12
XFILLER_8_169 VGND VGND VPWR VPWR sky130_fd_sc_hd__fill_1
XTAP_TAPCELL_ROW_5_128 VGND VPWR sky130_fd_sc_hd__tapvpwrvgnd_1
XFILLER_41_249 VGND VGND VPWR VPWR sky130_fd_sc_hd__decap_6
XTAP_TAPCELL_ROW_36_285 VGND VPWR sky130_fd_sc_hd__tapvpwrvgnd_1
XFILLER_26_279 VGND VGND VPWR VPWR sky130_fd_sc_hd__fill_1
XFILLER_32_205 VGND VGND VPWR VPWR sky130_fd_sc_hd__fill_1
XFILLER_27_50 VGND VGND VPWR VPWR sky130_fd_sc_hd__decap_6
XFILLER_40_282 VGND VGND VPWR VPWR sky130_fd_sc_hd__fill_2
XFILLER_4_194 VGND VGND VPWR VPWR sky130_fd_sc_hd__fill_2
XFILLER_4_76 VGND VGND VPWR VPWR sky130_fd_sc_hd__decap_8
XTAP_TAPCELL_ROW_10_152 VGND VPWR sky130_fd_sc_hd__tapvpwrvgnd_1
XTAP_TAPCELL_ROW_33_266 VGND VPWR sky130_fd_sc_hd__tapvpwrvgnd_1
XFILLER_31_260 VPWR VGND VPWR VGND sky130_ef_sc_hd__decap_12
XFILLER_2_109 VPWR VGND VPWR VGND sky130_ef_sc_hd__decap_12
XFILLER_14_227 VPWR VGND VPWR VGND sky130_ef_sc_hd__decap_12
Xfanout97 net12 VGND VGND VPWR VPWR net97 sky130_fd_sc_hd__buf_2
Xfanout86 net3 VGND VGND VPWR VPWR net86 sky130_fd_sc_hd__buf_2
Xfanout64 net66 VGND VGND VPWR VPWR net64 sky130_fd_sc_hd__clkbuf_4
XTAP_TAPCELL_ROW_24_222 VGND VPWR sky130_fd_sc_hd__tapvpwrvgnd_1
Xfanout75 net9 VGND VGND VPWR VPWR net75 sky130_fd_sc_hd__buf_4
XTAP_TAPCELL_ROW_47_336 VGND VPWR sky130_fd_sc_hd__tapvpwrvgnd_1
XFILLER_38_93 VGND VGND VPWR VPWR sky130_fd_sc_hd__decap_3
XTAP_TAPCELL_ROW_0_99 VGND VPWR sky130_fd_sc_hd__tapvpwrvgnd_1
XFILLER_1_164 VGND VGND VPWR VPWR sky130_fd_sc_hd__decap_4
XFILLER_1_197 VGND VGND VPWR VPWR sky130_fd_sc_hd__decap_4
X_0941_ net89 net94 _0318_ _0319_ VGND VGND VPWR VPWR _0321_ sky130_fd_sc_hd__o2bb2a_1
X_0872_ net60 net45 VGND VGND VPWR VPWR _0258_ sky130_fd_sc_hd__nand2_1
XFILLER_9_275 VGND VGND VPWR VPWR sky130_fd_sc_hd__fill_1
X_1286_ clknet_2_0__leaf_aclk _0016_ VGND VGND VPWR VPWR net28 sky130_fd_sc_hd__dfxtp_1
XFILLER_34_29 VPWR VGND VPWR VGND sky130_ef_sc_hd__decap_12
XFILLER_40_83 VGND VGND VPWR VPWR sky130_fd_sc_hd__fill_1
XFILLER_1_55 VGND VGND VPWR VPWR sky130_fd_sc_hd__fill_1
X_1140_ _0444_ _0480_ _0481_ VGND VGND VPWR VPWR _0515_ sky130_fd_sc_hd__o21a_1
X_1071_ _0446_ _0447_ VGND VGND VPWR VPWR _0448_ sky130_fd_sc_hd__xor2_1
X_0924_ _0301_ _0302_ VGND VGND VPWR VPWR _0305_ sky130_fd_sc_hd__or2_1
X_0855_ _0239_ _0242_ VGND VGND VPWR VPWR _0244_ sky130_fd_sc_hd__or2_1
X_0786_ net31 net68 _0182_ _0183_ net104 VGND VGND VPWR VPWR _0019_ sky130_fd_sc_hd__o221a_1
Xhold18 cnn_mac_wrapper.last_pipe\[0\] VGND VGND VPWR VPWR net125 sky130_fd_sc_hd__dlygate4sd3_1
XTAP_TAPCELL_ROW_41_309 VGND VPWR sky130_fd_sc_hd__tapvpwrvgnd_1
X_1269_ net102 _0634_ VGND VGND VPWR VPWR _0051_ sky130_fd_sc_hd__and2_1
XFILLER_10_53 VGND VGND VPWR VPWR sky130_fd_sc_hd__decap_8
XFILLER_10_97 VPWR VGND VPWR VGND sky130_ef_sc_hd__decap_12
XFILLER_34_108 VGND VGND VPWR VPWR sky130_fd_sc_hd__decap_4
XFILLER_19_105 VGND VGND VPWR VPWR sky130_fd_sc_hd__decap_6
XFILLER_42_141 VPWR VGND VPWR VGND sky130_ef_sc_hd__decap_12
X_0640_ cnn_mac_wrapper.core_inst.product\[0\] net21 VGND VGND VPWR VPWR _0057_ sky130_fd_sc_hd__nand2_1
XFILLER_18_3 VGND VGND VPWR VPWR sky130_fd_sc_hd__decap_6
XPHY_EDGE_ROW_27_Left_75 VGND VGND VPWR VPWR sky130_fd_sc_hd__decap_3
XPHY_EDGE_ROW_11_Left_59 VGND VGND VPWR VPWR sky130_fd_sc_hd__decap_3
X_1123_ _0496_ _0497_ VGND VGND VPWR VPWR _0498_ sky130_fd_sc_hd__xor2_1
X_1054_ _0428_ _0429_ _0421_ VGND VGND VPWR VPWR _0431_ sky130_fd_sc_hd__a21o_1
XFILLER_25_119 VGND VGND VPWR VPWR sky130_fd_sc_hd__fill_1
X_0907_ net109 net71 _0288_ net107 VGND VGND VPWR VPWR _0035_ sky130_fd_sc_hd__o211a_1
XFILLER_33_196 VGND VGND VPWR VPWR sky130_fd_sc_hd__decap_4
Xclkbuf_2_2__f_aclk clknet_0_aclk VGND VGND VPWR VPWR clknet_2_2__leaf_aclk sky130_fd_sc_hd__clkbuf_16
X_0769_ _0167_ _0168_ VGND VGND VPWR VPWR _0169_ sky130_fd_sc_hd__xor2_1
X_0838_ net38 net37 net59 VGND VGND VPWR VPWR _0229_ sky130_fd_sc_hd__o21a_1
XFILLER_24_141 VPWR VGND VPWR VGND sky130_ef_sc_hd__decap_12
XFILLER_21_96 VGND VGND VPWR VPWR sky130_fd_sc_hd__decap_8
XFILLER_47_277 VGND VGND VPWR VPWR sky130_fd_sc_hd__decap_3
XFILLER_30_133 VGND VGND VPWR VPWR sky130_fd_sc_hd__decap_3
XFILLER_7_87 VGND VGND VPWR VPWR sky130_fd_sc_hd__fill_1
X_1106_ _0480_ _0481_ VGND VGND VPWR VPWR _0482_ sky130_fd_sc_hd__and2b_1
X_1037_ _0409_ _0412_ VGND VGND VPWR VPWR _0414_ sky130_fd_sc_hd__xnor2_1
XFILLER_21_188 VGND VGND VPWR VPWR sky130_fd_sc_hd__decap_6
XFILLER_29_200 VPWR VGND VPWR VGND sky130_ef_sc_hd__decap_12
XPHY_EDGE_ROW_11_Right_11 VGND VGND VPWR VPWR sky130_fd_sc_hd__decap_3
XFILLER_16_85 VPWR VGND VPWR VGND sky130_ef_sc_hd__decap_12
XPHY_EDGE_ROW_20_Right_20 VGND VGND VPWR VPWR sky130_fd_sc_hd__decap_3
XFILLER_35_225 VPWR VGND VPWR VGND sky130_ef_sc_hd__decap_12
XTAP_TAPCELL_ROW_5_129 VGND VPWR sky130_fd_sc_hd__tapvpwrvgnd_1
XFILLER_37_18 VGND VGND VPWR VPWR sky130_fd_sc_hd__fill_2
XPHY_EDGE_ROW_14_Left_62 VGND VGND VPWR VPWR sky130_fd_sc_hd__decap_3
XFILLER_40_250 VGND VGND VPWR VPWR sky130_fd_sc_hd__fill_2
XTAP_TAPCELL_ROW_10_153 VGND VPWR sky130_fd_sc_hd__tapvpwrvgnd_1
XTAP_TAPCELL_ROW_33_267 VGND VPWR sky130_fd_sc_hd__tapvpwrvgnd_1
XFILLER_31_272 VGND VGND VPWR VPWR sky130_fd_sc_hd__decap_4
XTAP_TAPCELL_ROW_1_110 VGND VPWR sky130_fd_sc_hd__tapvpwrvgnd_1
XFILLER_14_239 VGND VGND VPWR VPWR sky130_fd_sc_hd__fill_1
XTAP_TAPCELL_ROW_24_223 VGND VPWR sky130_fd_sc_hd__tapvpwrvgnd_1
Xfanout98 net12 VGND VGND VPWR VPWR net98 sky130_fd_sc_hd__dlymetal6s2s_1
Xfanout87 net3 VGND VGND VPWR VPWR net87 sky130_fd_sc_hd__clkbuf_2
Xfanout65 net66 VGND VGND VPWR VPWR net65 sky130_fd_sc_hd__dlymetal6s2s_1
XFILLER_13_20 VPWR VGND VPWR VGND sky130_ef_sc_hd__decap_12
XFILLER_13_86 VPWR VGND VPWR VGND sky130_ef_sc_hd__decap_12
Xfanout76 net77 VGND VGND VPWR VPWR net76 sky130_fd_sc_hd__buf_2
XFILLER_22_272 VGND VGND VPWR VPWR sky130_fd_sc_hd__decap_8
XTAP_TAPCELL_ROW_47_337 VGND VPWR sky130_fd_sc_hd__tapvpwrvgnd_1
XFILLER_38_61 VPWR VGND VPWR VGND sky130_ef_sc_hd__decap_12
X_0940_ _0318_ _0319_ net89 net93 VGND VGND VPWR VPWR _0320_ sky130_fd_sc_hd__and4bb_1
X_0871_ net60 net45 VGND VGND VPWR VPWR _0257_ sky130_fd_sc_hd__or2_1
X_1285_ clknet_2_0__leaf_aclk _0015_ VGND VGND VPWR VPWR net27 sky130_fd_sc_hd__dfxtp_1
XPHY_EDGE_ROW_41_Left_89 VGND VGND VPWR VPWR sky130_fd_sc_hd__decap_3
XFILLER_39_180 VGND VGND VPWR VPWR sky130_fd_sc_hd__fill_1
XFILLER_40_73 VGND VGND VPWR VPWR sky130_fd_sc_hd__fill_1
XFILLER_10_231 VGND VGND VPWR VPWR sky130_fd_sc_hd__fill_1
XFILLER_10_253 VPWR VGND VPWR VGND sky130_ef_sc_hd__decap_12
X_1070_ _0402_ _0405_ _0403_ VGND VGND VPWR VPWR _0447_ sky130_fd_sc_hd__a21o_1
X_0923_ _0301_ _0302_ VGND VGND VPWR VPWR _0304_ sky130_fd_sc_hd__nand2_1
X_0854_ _0239_ _0242_ VGND VGND VPWR VPWR _0243_ sky130_fd_sc_hd__nand2_1
X_0785_ _0172_ _0177_ _0181_ net62 VGND VGND VPWR VPWR _0183_ sky130_fd_sc_hd__a31o_1
XFILLER_45_18 VPWR VGND VPWR VGND sky130_ef_sc_hd__decap_12
X_1268_ net54 cnn_mac_wrapper.valid_pipe\[0\] net2 VGND VGND VPWR VPWR _0634_ sky130_fd_sc_hd__mux2_1
XFILLER_28_139 VGND VGND VPWR VPWR sky130_fd_sc_hd__fill_1
XFILLER_43_109 VGND VGND VPWR VPWR sky130_fd_sc_hd__decap_3
X_1199_ _0569_ _0570_ VGND VGND VPWR VPWR _0572_ sky130_fd_sc_hd__xor2_1
XFILLER_42_197 VPWR VGND VPWR VGND sky130_ef_sc_hd__decap_12
XFILLER_42_153 VPWR VGND VPWR VGND sky130_ef_sc_hd__decap_12
XPHY_EDGE_ROW_2_Left_50 VGND VGND VPWR VPWR sky130_fd_sc_hd__decap_3
XFILLER_32_6 VPWR VGND VPWR VGND sky130_ef_sc_hd__decap_12
XFILLER_2_282 VGND VGND VPWR VPWR sky130_fd_sc_hd__fill_2
X_1122_ net78 net93 VGND VGND VPWR VPWR _0497_ sky130_fd_sc_hd__nand2_1
XFILLER_33_120 VGND VGND VPWR VPWR sky130_fd_sc_hd__decap_3
X_1053_ _0421_ _0428_ _0429_ VGND VGND VPWR VPWR _0430_ sky130_fd_sc_hd__nand3_1
X_0906_ _0286_ _0287_ net71 VGND VGND VPWR VPWR _0288_ sky130_fd_sc_hd__o21ai_1
X_0837_ _0227_ VGND VGND VPWR VPWR _0228_ sky130_fd_sc_hd__inv_2
X_0768_ _0160_ _0163_ _0162_ VGND VGND VPWR VPWR _0168_ sky130_fd_sc_hd__a21o_1
X_0699_ _0105_ _0106_ VGND VGND VPWR VPWR _0107_ sky130_fd_sc_hd__and2b_1
XFILLER_16_109 VGND VGND VPWR VPWR sky130_fd_sc_hd__decap_8
XPHY_EDGE_ROW_44_Left_92 VGND VGND VPWR VPWR sky130_fd_sc_hd__decap_3
XFILLER_24_153 VPWR VGND VPWR VGND sky130_ef_sc_hd__decap_12
XFILLER_47_245 VGND VGND VPWR VPWR sky130_fd_sc_hd__decap_3
XFILLER_15_164 VGND VGND VPWR VPWR sky130_fd_sc_hd__decap_4
XFILLER_7_77 VGND VGND VPWR VPWR sky130_fd_sc_hd__decap_3
X_1105_ _0478_ _0479_ _0438_ _0440_ VGND VGND VPWR VPWR _0481_ sky130_fd_sc_hd__a211o_1
XTAP_TAPCELL_ROW_16_181 VGND VPWR sky130_fd_sc_hd__tapvpwrvgnd_1
X_1036_ _0412_ _0409_ VGND VGND VPWR VPWR _0413_ sky130_fd_sc_hd__and2b_1
XFILLER_29_212 VPWR VGND VPWR VGND sky130_ef_sc_hd__decap_12
XFILLER_16_42 VGND VGND VPWR VPWR sky130_fd_sc_hd__decap_8
XFILLER_32_85 VPWR VGND VPWR VGND sky130_ef_sc_hd__decap_12
XFILLER_32_41 VGND VGND VPWR VPWR sky130_fd_sc_hd__decap_6
XFILLER_8_138 VGND VGND VPWR VPWR sky130_fd_sc_hd__fill_2
XFILLER_12_112 VGND VGND VPWR VPWR sky130_fd_sc_hd__fill_1
XFILLER_16_97 VPWR VGND VPWR VGND sky130_ef_sc_hd__decap_12
XFILLER_35_237 VPWR VGND VPWR VGND sky130_ef_sc_hd__decap_12
XFILLER_43_281 VGND VGND VPWR VPWR sky130_fd_sc_hd__decap_3
X_1019_ _0393_ _0395_ _0358_ _0360_ VGND VGND VPWR VPWR _0397_ sky130_fd_sc_hd__o211a_1
XFILLER_27_30 VGND VGND VPWR VPWR sky130_fd_sc_hd__fill_1
XFILLER_25_281 VGND VGND VPWR VPWR sky130_fd_sc_hd__decap_3
XFILLER_4_141 VPWR VGND VPWR VGND sky130_ef_sc_hd__decap_12
XTAP_TAPCELL_ROW_10_154 VGND VPWR sky130_fd_sc_hd__tapvpwrvgnd_1
XTAP_TAPCELL_ROW_33_268 VGND VPWR sky130_fd_sc_hd__tapvpwrvgnd_1
XTAP_TAPCELL_ROW_24_224 VGND VPWR sky130_fd_sc_hd__tapvpwrvgnd_1
Xfanout99 net11 VGND VGND VPWR VPWR net99 sky130_fd_sc_hd__buf_2
Xfanout66 _0055_ VGND VGND VPWR VPWR net66 sky130_fd_sc_hd__clkbuf_2
XFILLER_13_32 VGND VGND VPWR VPWR sky130_fd_sc_hd__decap_4
XFILLER_13_98 VGND VGND VPWR VPWR sky130_fd_sc_hd__decap_3
Xfanout88 net18 VGND VGND VPWR VPWR net88 sky130_fd_sc_hd__buf_2
Xfanout77 net8 VGND VGND VPWR VPWR net77 sky130_fd_sc_hd__clkbuf_2
XFILLER_8_3 VGND VGND VPWR VPWR sky130_fd_sc_hd__decap_8
XFILLER_1_111 VGND VGND VPWR VPWR sky130_fd_sc_hd__fill_1
XFILLER_1_155 VGND VGND VPWR VPWR sky130_fd_sc_hd__decap_6
XTAP_TAPCELL_ROW_47_338 VGND VPWR sky130_fd_sc_hd__tapvpwrvgnd_1
XFILLER_38_73 VGND VGND VPWR VPWR sky130_fd_sc_hd__decap_8
X_0870_ _0250_ _0253_ _0249_ VGND VGND VPWR VPWR _0256_ sky130_fd_sc_hd__a21boi_1
X_1284_ clknet_2_1__leaf_aclk _0014_ VGND VGND VPWR VPWR net26 sky130_fd_sc_hd__dfxtp_1
X_0999_ _0369_ _0375_ VGND VGND VPWR VPWR _0377_ sky130_fd_sc_hd__xor2_1
XFILLER_40_85 VGND VGND VPWR VPWR sky130_fd_sc_hd__decap_8
XFILLER_10_265 VPWR VGND VPWR VGND sky130_ef_sc_hd__decap_12
XFILLER_1_57 VPWR VGND VPWR VGND sky130_ef_sc_hd__decap_12
X_0922_ _0281_ _0283_ _0301_ VGND VGND VPWR VPWR _0303_ sky130_fd_sc_hd__o21a_1
X_0853_ _0240_ _0241_ VGND VGND VPWR VPWR _0242_ sky130_fd_sc_hd__and2_1
X_0784_ _0172_ _0177_ _0181_ VGND VGND VPWR VPWR _0182_ sky130_fd_sc_hd__a21oi_1
Xinput1 aresetn VGND VGND VPWR VPWR net1 sky130_fd_sc_hd__buf_1
X_1267_ net67 _0633_ net102 VGND VGND VPWR VPWR _0050_ sky130_fd_sc_hd__o21a_1
X_1198_ _0569_ _0570_ VGND VGND VPWR VPWR _0571_ sky130_fd_sc_hd__nand2b_1
XFILLER_3_239 VPWR VGND VPWR VGND sky130_ef_sc_hd__decap_12
XFILLER_10_11 VGND VGND VPWR VPWR sky130_fd_sc_hd__fill_2
XFILLER_42_121 VPWR VGND VPWR VGND sky130_ef_sc_hd__decap_12
XFILLER_35_63 VGND VGND VPWR VPWR sky130_fd_sc_hd__fill_1
XFILLER_35_30 VGND VGND VPWR VPWR sky130_fd_sc_hd__decap_8
XFILLER_42_165 VPWR VGND VPWR VGND sky130_ef_sc_hd__decap_12
X_1121_ net76 _0494_ _0493_ VGND VGND VPWR VPWR _0496_ sky130_fd_sc_hd__a21oi_1
X_1052_ _0425_ _0426_ _0427_ VGND VGND VPWR VPWR _0429_ sky130_fd_sc_hd__a21o_1
XFILLER_33_154 VPWR VGND VPWR VGND sky130_ef_sc_hd__decap_12
XFILLER_18_195 VGND VGND VPWR VPWR sky130_fd_sc_hd__fill_1
X_0905_ _0271_ _0285_ VGND VGND VPWR VPWR _0287_ sky130_fd_sc_hd__nor2_1
X_0767_ net58 net29 VGND VGND VPWR VPWR _0167_ sky130_fd_sc_hd__xor2_1
X_0836_ _0225_ _0226_ VGND VGND VPWR VPWR _0227_ sky130_fd_sc_hd__nand2_1
XFILLER_0_209 VGND VGND VPWR VPWR sky130_fd_sc_hd__decap_4
X_0698_ cnn_mac_wrapper.core_inst.product\[9\] net52 VGND VGND VPWR VPWR _0106_ sky130_fd_sc_hd__nand2_1
X_1319_ clknet_2_0__leaf_aclk _0049_ VGND VGND VPWR VPWR net53 sky130_fd_sc_hd__dfxtp_1
XFILLER_24_165 VPWR VGND VPWR VGND sky130_ef_sc_hd__decap_12
XFILLER_30_157 VGND VGND VPWR VPWR sky130_fd_sc_hd__fill_1
XFILLER_23_3 VPWR VGND VPWR VGND sky130_ef_sc_hd__decap_12
XFILLER_38_213 VGND VGND VPWR VPWR sky130_fd_sc_hd__decap_3
X_1035_ _0410_ _0411_ VGND VGND VPWR VPWR _0412_ sky130_fd_sc_hd__or2_1
X_1104_ _0438_ _0440_ _0478_ _0479_ VGND VGND VPWR VPWR _0480_ sky130_fd_sc_hd__o211a_1
XTAP_TAPCELL_ROW_16_182 VGND VPWR sky130_fd_sc_hd__tapvpwrvgnd_1
X_0819_ _0157_ _0159_ _0211_ VGND VGND VPWR VPWR _0212_ sky130_fd_sc_hd__a21oi_1
XFILLER_29_268 VGND VGND VPWR VPWR sky130_fd_sc_hd__decap_3
XFILLER_29_279 VGND VGND VPWR VPWR sky130_fd_sc_hd__fill_1
XTAP_TAPCELL_ROW_39_296 VGND VPWR sky130_fd_sc_hd__tapvpwrvgnd_1
XFILLER_32_97 VPWR VGND VPWR VGND sky130_ef_sc_hd__decap_12
XFILLER_8_106 VPWR VGND VPWR VGND sky130_ef_sc_hd__decap_12
XFILLER_35_249 VGND VGND VPWR VPWR sky130_fd_sc_hd__decap_3
XPHY_EDGE_ROW_9_Right_9 VGND VGND VPWR VPWR sky130_fd_sc_hd__decap_3
XFILLER_34_282 VGND VGND VPWR VPWR sky130_fd_sc_hd__fill_2
X_1018_ _0358_ _0360_ _0393_ _0395_ VGND VGND VPWR VPWR _0396_ sky130_fd_sc_hd__a211oi_1
XFILLER_43_30 VPWR VGND VPWR VGND sky130_ef_sc_hd__decap_12
XFILLER_40_230 VPWR VGND VPWR VGND sky130_ef_sc_hd__decap_12
XFILLER_4_153 VPWR VGND VPWR VGND sky130_ef_sc_hd__decap_12
XTAP_TAPCELL_ROW_10_155 VGND VPWR sky130_fd_sc_hd__tapvpwrvgnd_1
XTAP_TAPCELL_ROW_33_269 VGND VPWR sky130_fd_sc_hd__tapvpwrvgnd_1
Xfanout78 net7 VGND VGND VPWR VPWR net78 sky130_fd_sc_hd__buf_2
XFILLER_22_241 VGND VGND VPWR VPWR sky130_fd_sc_hd__decap_8
Xfanout67 net70 VGND VGND VPWR VPWR net67 sky130_fd_sc_hd__buf_2
XTAP_TAPCELL_ROW_24_225 VGND VPWR sky130_fd_sc_hd__tapvpwrvgnd_1
Xfanout89 net17 VGND VGND VPWR VPWR net89 sky130_fd_sc_hd__clkbuf_2
XFILLER_38_41 VPWR VGND VPWR VGND sky130_ef_sc_hd__decap_12
XTAP_TAPCELL_ROW_47_339 VGND VPWR sky130_fd_sc_hd__tapvpwrvgnd_1
XFILLER_38_85 VGND VGND VPWR VPWR sky130_fd_sc_hd__decap_8
XFILLER_9_223 VGND VGND VPWR VPWR sky130_fd_sc_hd__fill_1
X_1283_ clknet_2_0__leaf_aclk _0013_ VGND VGND VPWR VPWR net25 sky130_fd_sc_hd__dfxtp_1
XTAP_TAPCELL_ROW_21_206 VGND VPWR sky130_fd_sc_hd__tapvpwrvgnd_1
X_0998_ _0369_ _0375_ VGND VGND VPWR VPWR _0376_ sky130_fd_sc_hd__nand2_1
XFILLER_10_277 VGND VGND VPWR VPWR sky130_fd_sc_hd__decap_6
XFILLER_24_43 VGND VGND VPWR VPWR sky130_fd_sc_hd__decap_4
XFILLER_1_69 VPWR VGND VPWR VGND sky130_ef_sc_hd__decap_12
XFILLER_45_185 VGND VGND VPWR VPWR sky130_fd_sc_hd__fill_1
XFILLER_45_130 VGND VGND VPWR VPWR sky130_fd_sc_hd__fill_1
XTAP_TAPCELL_ROW_43_320 VGND VPWR sky130_fd_sc_hd__tapvpwrvgnd_1
X_0921_ _0281_ _0283_ VGND VGND VPWR VPWR _0302_ sky130_fd_sc_hd__or2_1
X_0852_ net59 net41 VGND VGND VPWR VPWR _0241_ sky130_fd_sc_hd__nand2_1
X_0783_ net58 net31 VGND VGND VPWR VPWR _0181_ sky130_fd_sc_hd__xor2_1
XFILLER_5_281 VGND VGND VPWR VPWR sky130_fd_sc_hd__decap_3
XFILLER_36_141 VPWR VGND VPWR VGND sky130_ef_sc_hd__decap_12
X_1266_ net2 net122 VGND VGND VPWR VPWR _0633_ sky130_fd_sc_hd__and2b_1
Xinput2 m_axis_tready VGND VGND VPWR VPWR net2 sky130_fd_sc_hd__buf_2
X_1197_ _0520_ _0541_ _0540_ VGND VGND VPWR VPWR _0570_ sky130_fd_sc_hd__a21bo_1
XFILLER_28_108 VGND VGND VPWR VPWR sky130_fd_sc_hd__decap_6
XFILLER_42_177 VPWR VGND VPWR VGND sky130_ef_sc_hd__decap_12
XFILLER_42_133 VGND VGND VPWR VPWR sky130_fd_sc_hd__decap_6
XTAP_TAPCELL_ROW_40_301 VGND VPWR sky130_fd_sc_hd__tapvpwrvgnd_1
XFILLER_35_86 VGND VGND VPWR VPWR sky130_fd_sc_hd__fill_1
X_1120_ net76 _0494_ VGND VGND VPWR VPWR _0495_ sky130_fd_sc_hd__nand2_1
XFILLER_18_141 VGND VGND VPWR VPWR sky130_fd_sc_hd__fill_2
X_1051_ _0425_ _0426_ _0427_ VGND VGND VPWR VPWR _0428_ sky130_fd_sc_hd__nand3_1
X_0904_ _0271_ _0285_ VGND VGND VPWR VPWR _0286_ sky130_fd_sc_hd__and2_1
XFILLER_33_166 VGND VGND VPWR VPWR sky130_fd_sc_hd__fill_2
X_0766_ net28 net68 _0166_ net103 VGND VGND VPWR VPWR _0016_ sky130_fd_sc_hd__o211a_1
X_0835_ net59 net39 VGND VGND VPWR VPWR _0226_ sky130_fd_sc_hd__nand2_1
X_0697_ cnn_mac_wrapper.core_inst.product\[9\] net52 VGND VGND VPWR VPWR _0105_ sky130_fd_sc_hd__nor2_1
X_1318_ clknet_2_0__leaf_aclk _0048_ VGND VGND VPWR VPWR cnn_mac_wrapper.last_pipe\[0\]
+ sky130_fd_sc_hd__dfxtp_1
X_1249_ _0571_ _0600_ VGND VGND VPWR VPWR _0620_ sky130_fd_sc_hd__or2_1
XFILLER_24_177 VPWR VGND VPWR VGND sky130_ef_sc_hd__decap_12
XFILLER_47_225 VPWR VGND VPWR VGND sky130_ef_sc_hd__decap_12
XFILLER_46_41 VGND VGND VPWR VPWR sky130_fd_sc_hd__decap_8
XFILLER_15_111 VGND VGND VPWR VPWR sky130_fd_sc_hd__fill_1
XFILLER_15_133 VPWR VGND VPWR VGND sky130_ef_sc_hd__decap_12
XFILLER_7_57 VPWR VGND VPWR VGND sky130_ef_sc_hd__decap_12
XFILLER_16_3 VPWR VGND VPWR VGND sky130_ef_sc_hd__decap_12
XFILLER_38_247 VGND VGND VPWR VPWR sky130_fd_sc_hd__fill_2
X_1103_ _0476_ _0477_ _0413_ _0415_ VGND VGND VPWR VPWR _0479_ sky130_fd_sc_hd__a211o_1
X_1034_ net88 net92 net16 net84 VGND VGND VPWR VPWR _0411_ sky130_fd_sc_hd__and4b_1
XTAP_TAPCELL_ROW_16_183 VGND VPWR sky130_fd_sc_hd__tapvpwrvgnd_1
XFILLER_21_169 VPWR VGND VPWR VGND sky130_ef_sc_hd__decap_12
X_0749_ _0149_ _0150_ VGND VGND VPWR VPWR _0151_ sky130_fd_sc_hd__or2_1
X_0818_ _0174_ _0189_ _0210_ VGND VGND VPWR VPWR _0211_ sky130_fd_sc_hd__or3_1
XFILLER_29_225 VPWR VGND VPWR VGND sky130_ef_sc_hd__decap_12
XTAP_TAPCELL_ROW_39_297 VGND VPWR sky130_fd_sc_hd__tapvpwrvgnd_1
XFILLER_8_118 VPWR VGND VPWR VGND sky130_ef_sc_hd__decap_12
XFILLER_16_66 VPWR VGND VPWR VGND sky130_ef_sc_hd__decap_12
XFILLER_32_54 VPWR VGND VPWR VGND sky130_ef_sc_hd__decap_12
XTAP_TAPCELL_ROW_7_140 VGND VPWR sky130_fd_sc_hd__tapvpwrvgnd_1
XFILLER_35_206 VPWR VGND VPWR VGND sky130_ef_sc_hd__decap_12
XFILLER_11_180 VGND VGND VPWR VPWR sky130_fd_sc_hd__fill_1
X_1017_ _0391_ _0392_ _0377_ VGND VGND VPWR VPWR _0395_ sky130_fd_sc_hd__a21oi_1
XTAP_TAPCELL_ROW_4_121 VGND VPWR sky130_fd_sc_hd__tapvpwrvgnd_1
XFILLER_32_209 VPWR VGND VPWR VGND sky130_ef_sc_hd__decap_12
XFILLER_43_42 VPWR VGND VPWR VGND sky130_ef_sc_hd__decap_12
XFILLER_40_242 VGND VGND VPWR VPWR sky130_fd_sc_hd__decap_8
XFILLER_4_165 VPWR VGND VPWR VGND sky130_ef_sc_hd__decap_12
XFILLER_4_121 VPWR VGND VPWR VGND sky130_ef_sc_hd__decap_12
XPHY_EDGE_ROW_18_Left_66 VGND VGND VPWR VPWR sky130_fd_sc_hd__decap_3
Xfanout79 net7 VGND VGND VPWR VPWR net79 sky130_fd_sc_hd__buf_1
Xfanout57 net61 VGND VGND VPWR VPWR net57 sky130_fd_sc_hd__buf_2
Xfanout68 net70 VGND VGND VPWR VPWR net68 sky130_fd_sc_hd__buf_2
XFILLER_22_253 VGND VGND VPWR VPWR sky130_fd_sc_hd__decap_6
XFILLER_1_113 VPWR VGND VPWR VGND sky130_ef_sc_hd__decap_12
XFILLER_38_53 VGND VGND VPWR VPWR sky130_fd_sc_hd__fill_2
XFILLER_9_257 VPWR VGND VPWR VGND sky130_ef_sc_hd__decap_12
X_1282_ clknet_2_0__leaf_aclk _0012_ VGND VGND VPWR VPWR net24 sky130_fd_sc_hd__dfxtp_1
XTAP_TAPCELL_ROW_21_207 VGND VPWR sky130_fd_sc_hd__tapvpwrvgnd_1
X_0997_ _0373_ _0374_ VGND VGND VPWR VPWR _0375_ sky130_fd_sc_hd__nor2_1
XFILLER_39_150 VGND VGND VPWR VPWR sky130_fd_sc_hd__decap_4
XFILLER_39_194 VGND VGND VPWR VPWR sky130_fd_sc_hd__fill_2
XFILLER_40_32 VPWR VGND VPWR VGND sky130_ef_sc_hd__decap_12
XFILLER_6_216 VPWR VGND VPWR VGND sky130_ef_sc_hd__decap_12
XFILLER_10_245 VGND VGND VPWR VPWR sky130_fd_sc_hd__decap_3
XFILLER_24_77 VGND VGND VPWR VPWR sky130_fd_sc_hd__decap_3
XFILLER_1_15 VPWR VGND VPWR VGND sky130_ef_sc_hd__decap_12
XFILLER_45_164 VGND VGND VPWR VPWR sky130_fd_sc_hd__fill_1
X_0920_ _0291_ _0300_ VGND VGND VPWR VPWR _0301_ sky130_fd_sc_hd__xnor2_1
X_0851_ net59 net41 VGND VGND VPWR VPWR _0240_ sky130_fd_sc_hd__or2_1
X_0782_ net63 _0179_ _0180_ net104 VGND VGND VPWR VPWR _0018_ sky130_fd_sc_hd__o211a_1
XFILLER_46_3 VPWR VGND VPWR VGND sky130_ef_sc_hd__decap_12
X_1265_ net102 _0632_ VGND VGND VPWR VPWR _0049_ sky130_fd_sc_hd__and2_1
XPHY_EDGE_ROW_18_Right_18 VGND VGND VPWR VPWR sky130_fd_sc_hd__decap_3
Xinput3 s_axis_tdata[0] VGND VGND VPWR VPWR net3 sky130_fd_sc_hd__clkbuf_1
XFILLER_36_197 VPWR VGND VPWR VGND sky130_ef_sc_hd__decap_12
X_1196_ _0549_ _0567_ VGND VGND VPWR VPWR _0569_ sky130_fd_sc_hd__xnor2_1
XPHY_EDGE_ROW_27_Right_27 VGND VGND VPWR VPWR sky130_fd_sc_hd__decap_3
XPHY_EDGE_ROW_36_Right_36 VGND VGND VPWR VPWR sky130_fd_sc_hd__decap_3
XFILLER_10_68 VPWR VGND VPWR VGND sky130_ef_sc_hd__decap_12
XPHY_EDGE_ROW_45_Right_45 VGND VGND VPWR VPWR sky130_fd_sc_hd__decap_3
XFILLER_42_189 VGND VGND VPWR VPWR sky130_fd_sc_hd__decap_6
XTAP_TAPCELL_ROW_40_302 VGND VPWR sky130_fd_sc_hd__tapvpwrvgnd_1
XFILLER_35_54 VGND VGND VPWR VPWR sky130_fd_sc_hd__fill_2
XFILLER_18_197 VPWR VGND VPWR VGND sky130_ef_sc_hd__decap_12
X_1050_ _0346_ _0382_ _0383_ VGND VGND VPWR VPWR _0427_ sky130_fd_sc_hd__o21bai_1
X_0903_ _0283_ _0284_ VGND VGND VPWR VPWR _0285_ sky130_fd_sc_hd__nor2_1
X_0834_ net59 net39 VGND VGND VPWR VPWR _0225_ sky130_fd_sc_hd__or2_1
X_0696_ net120 net73 _0104_ net106 VGND VGND VPWR VPWR _0008_ sky130_fd_sc_hd__o211a_1
X_0765_ _0164_ _0165_ net63 VGND VGND VPWR VPWR _0166_ sky130_fd_sc_hd__a21o_1
X_1248_ _0617_ _0618_ VGND VGND VPWR VPWR _0619_ sky130_fd_sc_hd__nand2_1
X_1317_ clknet_2_0__leaf_aclk _0047_ VGND VGND VPWR VPWR cnn_mac_wrapper.core_inst.product\[15\]
+ sky130_fd_sc_hd__dfxtp_1
X_1179_ _0499_ _0551_ VGND VGND VPWR VPWR _0552_ sky130_fd_sc_hd__xnor2_1
XFILLER_24_189 VGND VGND VPWR VPWR sky130_fd_sc_hd__decap_6
XFILLER_21_34 VGND VGND VPWR VPWR sky130_fd_sc_hd__fill_1
XFILLER_47_237 VGND VGND VPWR VPWR sky130_fd_sc_hd__decap_8
XFILLER_46_75 VGND VGND VPWR VPWR sky130_fd_sc_hd__fill_1
XPHY_EDGE_ROW_6_Left_54 VGND VGND VPWR VPWR sky130_fd_sc_hd__decap_3
XFILLER_15_145 VGND VGND VPWR VPWR sky130_fd_sc_hd__decap_3
XFILLER_15_156 VGND VGND VPWR VPWR sky130_fd_sc_hd__decap_4
XFILLER_7_69 VGND VGND VPWR VPWR sky130_fd_sc_hd__decap_8
X_1102_ _0413_ _0415_ _0476_ _0477_ VGND VGND VPWR VPWR _0478_ sky130_fd_sc_hd__o211ai_2
XFILLER_30_6 VGND VGND VPWR VPWR sky130_fd_sc_hd__decap_4
X_1033_ net84 net92 _0053_ net88 VGND VGND VPWR VPWR _0410_ sky130_fd_sc_hd__o2bb2a_1
X_0817_ _0186_ _0196_ _0201_ _0206_ VGND VGND VPWR VPWR _0210_ sky130_fd_sc_hd__or4b_1
XTAP_TAPCELL_ROW_16_184 VGND VPWR sky130_fd_sc_hd__tapvpwrvgnd_1
XFILLER_21_148 VPWR VGND VPWR VGND sky130_ef_sc_hd__decap_12
X_0679_ _0081_ _0089_ VGND VGND VPWR VPWR _0090_ sky130_fd_sc_hd__nand2_1
X_0748_ net57 net27 VGND VGND VPWR VPWR _0150_ sky130_fd_sc_hd__and2_1
XTAP_TAPCELL_ROW_39_298 VGND VPWR sky130_fd_sc_hd__tapvpwrvgnd_1
XFILLER_37_281 VGND VGND VPWR VPWR sky130_fd_sc_hd__decap_3
XFILLER_29_237 VPWR VGND VPWR VGND sky130_ef_sc_hd__decap_12
XPHY_EDGE_ROW_0_Right_0 VGND VGND VPWR VPWR sky130_fd_sc_hd__decap_3
XFILLER_12_104 VGND VGND VPWR VPWR sky130_fd_sc_hd__decap_8
XFILLER_16_78 VGND VGND VPWR VPWR sky130_fd_sc_hd__decap_6
XFILLER_35_218 VGND VGND VPWR VPWR sky130_fd_sc_hd__decap_6
XFILLER_19_281 VGND VGND VPWR VPWR sky130_fd_sc_hd__decap_3
X_1016_ _0377_ _0391_ _0392_ VGND VGND VPWR VPWR _0394_ sky130_fd_sc_hd__nand3_1
XTAP_TAPCELL_ROW_4_122 VGND VPWR sky130_fd_sc_hd__tapvpwrvgnd_1
XFILLER_27_22 VGND VGND VPWR VPWR sky130_fd_sc_hd__decap_8
XFILLER_43_54 VGND VGND VPWR VPWR sky130_fd_sc_hd__fill_2
XFILLER_4_177 VGND VGND VPWR VPWR sky130_fd_sc_hd__fill_1
XFILLER_4_133 VGND VGND VPWR VPWR sky130_fd_sc_hd__decap_6
XFILLER_4_15 VPWR VGND VPWR VGND sky130_ef_sc_hd__decap_12
XFILLER_16_251 VGND VGND VPWR VPWR sky130_fd_sc_hd__fill_1
XFILLER_13_57 VPWR VGND VPWR VGND sky130_ef_sc_hd__decap_12
Xfanout58 net61 VGND VGND VPWR VPWR net58 sky130_fd_sc_hd__buf_2
Xfanout69 net70 VGND VGND VPWR VPWR net69 sky130_fd_sc_hd__dlymetal6s2s_1
XFILLER_1_125 VGND VGND VPWR VPWR sky130_fd_sc_hd__decap_6
XFILLER_9_225 VPWR VGND VPWR VGND sky130_ef_sc_hd__decap_12
XFILLER_13_210 VGND VGND VPWR VPWR sky130_fd_sc_hd__fill_1
XPHY_EDGE_ROW_35_Left_83 VGND VGND VPWR VPWR sky130_fd_sc_hd__decap_3
XFILLER_9_269 VGND VGND VPWR VPWR sky130_fd_sc_hd__decap_6
X_1281_ clknet_2_1__leaf_aclk _0011_ VGND VGND VPWR VPWR net23 sky130_fd_sc_hd__dfxtp_1
XTAP_TAPCELL_ROW_21_208 VGND VPWR sky130_fd_sc_hd__tapvpwrvgnd_1
X_0996_ _0371_ _0372_ net89 _0053_ VGND VGND VPWR VPWR _0374_ sky130_fd_sc_hd__o2bb2a_1
XFILLER_5_91 VPWR VGND VPWR VGND sky130_ef_sc_hd__decap_12
XFILLER_40_44 VGND VGND VPWR VPWR sky130_fd_sc_hd__decap_3
XFILLER_6_228 VGND VGND VPWR VPWR sky130_fd_sc_hd__decap_6
XFILLER_6_3 VPWR VGND VPWR VGND sky130_ef_sc_hd__decap_12
XFILLER_1_27 VPWR VGND VPWR VGND sky130_ef_sc_hd__decap_12
X_0850_ _0218_ _0222_ _0228_ _0233_ _0238_ VGND VGND VPWR VPWR _0239_ sky130_fd_sc_hd__a41o_1
X_0781_ net30 net69 VGND VGND VPWR VPWR _0180_ sky130_fd_sc_hd__or2_1
Xinput4 s_axis_tdata[10] VGND VGND VPWR VPWR net4 sky130_fd_sc_hd__buf_1
XFILLER_39_3 VGND VGND VPWR VPWR sky130_fd_sc_hd__fill_1
X_1264_ net53 cnn_mac_wrapper.last_pipe\[0\] net2 VGND VGND VPWR VPWR _0632_ sky130_fd_sc_hd__mux2_1
XFILLER_36_121 VPWR VGND VPWR VGND sky130_ef_sc_hd__decap_12
X_1195_ _0549_ _0567_ VGND VGND VPWR VPWR _0568_ sky130_fd_sc_hd__and2_1
X_0979_ _0355_ _0356_ _0357_ VGND VGND VPWR VPWR _0358_ sky130_fd_sc_hd__nand3_2
XTAP_TAPCELL_ROW_40_303 VGND VPWR sky130_fd_sc_hd__tapvpwrvgnd_1
XFILLER_33_135 VGND VGND VPWR VPWR sky130_fd_sc_hd__decap_8
XFILLER_33_113 VGND VGND VPWR VPWR sky130_fd_sc_hd__fill_1
XFILLER_18_154 VGND VGND VPWR VPWR sky130_fd_sc_hd__decap_3
XFILLER_18_187 VGND VGND VPWR VPWR sky130_fd_sc_hd__decap_8
X_0902_ net90 net98 _0282_ VGND VGND VPWR VPWR _0284_ sky130_fd_sc_hd__a21oi_1
X_0833_ net38 net69 _0223_ _0224_ net104 VGND VGND VPWR VPWR _0025_ sky130_fd_sc_hd__o221a_1
X_0695_ net73 _0103_ VGND VGND VPWR VPWR _0104_ sky130_fd_sc_hd__nand2_1
X_0764_ _0160_ _0163_ VGND VGND VPWR VPWR _0165_ sky130_fd_sc_hd__or2_1
X_1316_ clknet_2_0__leaf_aclk _0046_ VGND VGND VPWR VPWR cnn_mac_wrapper.core_inst.product\[14\]
+ sky130_fd_sc_hd__dfxtp_1
X_1247_ _0594_ _0598_ _0616_ VGND VGND VPWR VPWR _0618_ sky130_fd_sc_hd__or3_1
X_1178_ _0529_ _0550_ VGND VGND VPWR VPWR _0551_ sky130_fd_sc_hd__xnor2_1
XPHY_EDGE_ROW_22_Left_70 VGND VGND VPWR VPWR sky130_fd_sc_hd__decap_3
XFILLER_32_190 VGND VGND VPWR VPWR sky130_fd_sc_hd__decap_6
XFILLER_21_57 VGND VGND VPWR VPWR sky130_fd_sc_hd__decap_8
XFILLER_15_113 VPWR VGND VPWR VGND sky130_ef_sc_hd__decap_12
XFILLER_7_15 VPWR VGND VPWR VGND sky130_ef_sc_hd__decap_12
X_1101_ net56 _0475_ _0433_ _0436_ VGND VGND VPWR VPWR _0477_ sky130_fd_sc_hd__o211ai_2
X_1032_ net82 net95 _0380_ _0378_ VGND VGND VPWR VPWR _0409_ sky130_fd_sc_hd__a31o_1
XTAP_TAPCELL_ROW_16_185 VGND VPWR sky130_fd_sc_hd__tapvpwrvgnd_1
XFILLER_21_138 VGND VGND VPWR VPWR sky130_fd_sc_hd__fill_1
X_0747_ net57 net27 VGND VGND VPWR VPWR _0149_ sky130_fd_sc_hd__nor2_1
X_0816_ net62 _0208_ _0209_ net103 VGND VGND VPWR VPWR _0023_ sky130_fd_sc_hd__o211a_1
X_0678_ cnn_mac_wrapper.core_inst.product\[5\] net48 _0076_ _0077_ _0074_ VGND VGND
+ VPWR VPWR _0089_ sky130_fd_sc_hd__a221o_1
XTAP_TAPCELL_ROW_39_299 VGND VPWR sky130_fd_sc_hd__tapvpwrvgnd_1
XFILLER_29_249 VPWR VGND VPWR VGND sky130_ef_sc_hd__decap_12
XFILLER_43_230 VPWR VGND VPWR VGND sky130_ef_sc_hd__decap_12
XFILLER_28_282 VGND VGND VPWR VPWR sky130_fd_sc_hd__fill_2
XFILLER_7_142 VPWR VGND VPWR VGND sky130_ef_sc_hd__decap_12
XTAP_TAPCELL_ROW_13_166 VGND VPWR sky130_fd_sc_hd__tapvpwrvgnd_1
XFILLER_21_3 VGND VGND VPWR VPWR sky130_fd_sc_hd__decap_8
XFILLER_34_230 VPWR VGND VPWR VGND sky130_ef_sc_hd__decap_12
X_1015_ _0377_ _0391_ _0392_ VGND VGND VPWR VPWR _0393_ sky130_fd_sc_hd__and3_1
XFILLER_26_208 VPWR VGND VPWR VGND sky130_ef_sc_hd__decap_12
XTAP_TAPCELL_ROW_4_123 VGND VPWR sky130_fd_sc_hd__tapvpwrvgnd_1
XFILLER_43_11 VGND VGND VPWR VPWR sky130_fd_sc_hd__fill_2
XTAP_TAPCELL_ROW_35_280 VGND VPWR sky130_fd_sc_hd__tapvpwrvgnd_1
XFILLER_25_252 VGND VGND VPWR VPWR sky130_fd_sc_hd__fill_2
XTAP_TAPCELL_ROW_27_236 VGND VPWR sky130_fd_sc_hd__tapvpwrvgnd_1
XFILLER_27_89 VGND VGND VPWR VPWR sky130_fd_sc_hd__decap_3
XFILLER_4_49 VGND VGND VPWR VPWR sky130_fd_sc_hd__decap_3
XFILLER_4_27 VGND VGND VPWR VPWR sky130_fd_sc_hd__fill_1
XTAP_TAPCELL_ROW_32_261 VGND VPWR sky130_fd_sc_hd__tapvpwrvgnd_1
XFILLER_13_69 VPWR VGND VPWR VGND sky130_ef_sc_hd__decap_12
Xfanout59 net61 VGND VGND VPWR VPWR net59 sky130_fd_sc_hd__clkbuf_4
XFILLER_38_99 VGND VGND VPWR VPWR sky130_fd_sc_hd__fill_1
XFILLER_38_22 VGND VGND VPWR VPWR sky130_fd_sc_hd__decap_6
XFILLER_9_237 VPWR VGND VPWR VGND sky130_ef_sc_hd__decap_12
XFILLER_13_222 VGND VGND VPWR VPWR sky130_fd_sc_hd__fill_2
X_1280_ clknet_2_1__leaf_aclk _0010_ VGND VGND VPWR VPWR net22 sky130_fd_sc_hd__dfxtp_1
XTAP_TAPCELL_ROW_46_331 VGND VPWR sky130_fd_sc_hd__tapvpwrvgnd_1
XTAP_TAPCELL_ROW_21_209 VGND VPWR sky130_fd_sc_hd__tapvpwrvgnd_1
X_0995_ net89 net16 _0371_ _0372_ VGND VGND VPWR VPWR _0373_ sky130_fd_sc_hd__and4b_1
XFILLER_10_203 VPWR VGND VPWR VGND sky130_ef_sc_hd__decap_12
XFILLER_24_57 VPWR VGND VPWR VGND sky130_ef_sc_hd__decap_12
XFILLER_40_67 VGND VGND VPWR VPWR sky130_fd_sc_hd__decap_6
XFILLER_6_207 VGND VGND VPWR VPWR sky130_fd_sc_hd__fill_1
XFILLER_1_39 VPWR VGND VPWR VGND sky130_ef_sc_hd__decap_12
X_0780_ _0177_ _0178_ VGND VGND VPWR VPWR _0179_ sky130_fd_sc_hd__and2_1
Xinput5 s_axis_tdata[11] VGND VGND VPWR VPWR net5 sky130_fd_sc_hd__clkbuf_1
XFILLER_36_133 VGND VGND VPWR VPWR sky130_fd_sc_hd__decap_6
X_1263_ net102 _0631_ VGND VGND VPWR VPWR _0048_ sky130_fd_sc_hd__and2_1
X_1194_ _0565_ _0566_ VGND VGND VPWR VPWR _0567_ sky130_fd_sc_hd__nor2_1
X_0978_ _0317_ _0322_ _0316_ VGND VGND VPWR VPWR _0357_ sky130_fd_sc_hd__a21bo_1
XFILLER_10_26 VGND VGND VPWR VPWR sky130_fd_sc_hd__fill_2
XFILLER_19_57 VPWR VGND VPWR VGND sky130_ef_sc_hd__decap_12
XFILLER_27_155 VGND VGND VPWR VPWR sky130_fd_sc_hd__fill_2
XFILLER_27_166 VGND VGND VPWR VPWR sky130_fd_sc_hd__fill_2
XTAP_TAPCELL_ROW_40_304 VGND VPWR sky130_fd_sc_hd__tapvpwrvgnd_1
XFILLER_33_169 VGND VGND VPWR VPWR sky130_fd_sc_hd__decap_3
X_0901_ net90 net97 _0282_ VGND VGND VPWR VPWR _0283_ sky130_fd_sc_hd__and3_1
X_0763_ _0160_ _0163_ VGND VGND VPWR VPWR _0164_ sky130_fd_sc_hd__nand2_1
X_0832_ _0216_ _0219_ _0222_ net63 VGND VGND VPWR VPWR _0224_ sky130_fd_sc_hd__a31o_1
X_0694_ _0099_ _0102_ VGND VGND VPWR VPWR _0103_ sky130_fd_sc_hd__xnor2_1
X_1315_ clknet_2_0__leaf_aclk _0045_ VGND VGND VPWR VPWR cnn_mac_wrapper.core_inst.product\[13\]
+ sky130_fd_sc_hd__dfxtp_1
X_1246_ _0594_ _0598_ _0616_ VGND VGND VPWR VPWR _0617_ sky130_fd_sc_hd__o21ai_1
X_1177_ net93 net75 VGND VGND VPWR VPWR _0550_ sky130_fd_sc_hd__nand2_1
XFILLER_21_14 VPWR VGND VPWR VGND sky130_ef_sc_hd__decap_12
XFILLER_47_217 VGND VGND VPWR VPWR sky130_fd_sc_hd__decap_3
XFILLER_46_88 VPWR VGND VPWR VGND sky130_ef_sc_hd__decap_12
XFILLER_46_55 VPWR VGND VPWR VGND sky130_ef_sc_hd__decap_12
XFILLER_15_169 VPWR VGND VPWR VGND sky130_ef_sc_hd__decap_12
Xmax_cap56 _0474_ VGND VGND VPWR VPWR net56 sky130_fd_sc_hd__buf_1
XFILLER_7_38 VPWR VGND VPWR VGND sky130_ef_sc_hd__decap_12
XFILLER_7_27 VGND VGND VPWR VPWR sky130_fd_sc_hd__decap_4
XFILLER_23_191 VGND VGND VPWR VPWR sky130_fd_sc_hd__fill_1
XFILLER_46_283 VGND VGND VPWR VPWR sky130_fd_sc_hd__fill_1
XFILLER_38_239 VGND VGND VPWR VPWR sky130_fd_sc_hd__decap_8
X_1100_ _0433_ _0436_ net56 _0475_ VGND VGND VPWR VPWR _0476_ sky130_fd_sc_hd__a211o_1
X_1031_ _0370_ _0373_ VGND VGND VPWR VPWR _0408_ sky130_fd_sc_hd__nor2_1
X_0746_ net62 _0147_ _0148_ net103 VGND VGND VPWR VPWR _0014_ sky130_fd_sc_hd__o211a_1
X_0815_ net36 net68 VGND VGND VPWR VPWR _0209_ sky130_fd_sc_hd__or2_1
X_0677_ _0086_ _0087_ VGND VGND VPWR VPWR _0088_ sky130_fd_sc_hd__nand2b_1
XFILLER_37_261 VPWR VGND VPWR VGND sky130_ef_sc_hd__decap_12
X_1229_ _0565_ _0568_ _0599_ VGND VGND VPWR VPWR _0601_ sky130_fd_sc_hd__o21ai_1
XFILLER_43_242 VPWR VGND VPWR VGND sky130_ef_sc_hd__decap_12
XFILLER_7_198 VGND VGND VPWR VPWR sky130_fd_sc_hd__decap_3
XFILLER_7_154 VPWR VGND VPWR VGND sky130_ef_sc_hd__decap_12
XTAP_TAPCELL_ROW_13_167 VGND VPWR sky130_fd_sc_hd__tapvpwrvgnd_1
XFILLER_14_3 VGND VGND VPWR VPWR sky130_fd_sc_hd__decap_6
XFILLER_34_242 VGND VGND VPWR VPWR sky130_fd_sc_hd__decap_4
X_1014_ _0388_ _0389_ _0390_ VGND VGND VPWR VPWR _0392_ sky130_fd_sc_hd__a21o_1
X_0729_ _0128_ _0132_ VGND VGND VPWR VPWR _0134_ sky130_fd_sc_hd__nand2_1
XTAP_TAPCELL_ROW_4_124 VGND VPWR sky130_fd_sc_hd__tapvpwrvgnd_1
XFILLER_17_209 VPWR VGND VPWR VGND sky130_ef_sc_hd__decap_12
XFILLER_27_57 VPWR VGND VPWR VGND sky130_ef_sc_hd__decap_12
XFILLER_40_223 VGND VGND VPWR VPWR sky130_fd_sc_hd__fill_2
XFILLER_25_275 VGND VGND VPWR VPWR sky130_fd_sc_hd__fill_1
XTAP_TAPCELL_ROW_27_237 VGND VPWR sky130_fd_sc_hd__tapvpwrvgnd_1
XFILLER_16_253 VGND VGND VPWR VPWR sky130_fd_sc_hd__decap_6
XFILLER_16_264 VPWR VGND VPWR VGND sky130_ef_sc_hd__decap_12
XFILLER_31_223 VGND VGND VPWR VPWR sky130_fd_sc_hd__fill_1
XFILLER_22_212 VGND VGND VPWR VPWR sky130_fd_sc_hd__decap_3
XTAP_TAPCELL_ROW_32_262 VGND VPWR sky130_fd_sc_hd__tapvpwrvgnd_1
XFILLER_13_48 VGND VGND VPWR VPWR sky130_fd_sc_hd__decap_8
XFILLER_1_105 VGND VGND VPWR VPWR sky130_fd_sc_hd__decap_6
XFILLER_9_205 VPWR VGND VPWR VGND sky130_ef_sc_hd__decap_12
XFILLER_9_249 VGND VGND VPWR VPWR sky130_fd_sc_hd__decap_4
XFILLER_0_182 VGND VGND VPWR VPWR sky130_fd_sc_hd__decap_3
XTAP_TAPCELL_ROW_46_332 VGND VPWR sky130_fd_sc_hd__tapvpwrvgnd_1
XFILLER_8_282 VGND VGND VPWR VPWR sky130_fd_sc_hd__fill_2
X_0994_ net84 net94 net92 net88 VGND VGND VPWR VPWR _0372_ sky130_fd_sc_hd__a22o_1
XFILLER_39_186 VGND VGND VPWR VPWR sky130_fd_sc_hd__decap_8
XFILLER_10_215 VPWR VGND VPWR VGND sky130_ef_sc_hd__decap_12
XFILLER_10_237 VGND VGND VPWR VPWR sky130_fd_sc_hd__decap_8
XFILLER_24_69 VGND VGND VPWR VPWR sky130_fd_sc_hd__decap_8
XFILLER_40_79 VGND VGND VPWR VPWR sky130_fd_sc_hd__decap_4
XFILLER_45_101 VGND VGND VPWR VPWR sky130_fd_sc_hd__decap_6
XFILLER_5_263 VPWR VGND VPWR VGND sky130_ef_sc_hd__decap_12
Xinput6 s_axis_tdata[12] VGND VGND VPWR VPWR net6 sky130_fd_sc_hd__buf_1
X_1262_ net125 net19 net2 VGND VGND VPWR VPWR _0631_ sky130_fd_sc_hd__mux2_1
X_1193_ _0535_ _0537_ _0564_ VGND VGND VPWR VPWR _0566_ sky130_fd_sc_hd__and3_1
X_0977_ _0353_ _0354_ _0344_ VGND VGND VPWR VPWR _0356_ sky130_fd_sc_hd__a21o_1
XFILLER_19_69 VPWR VGND VPWR VGND sky130_ef_sc_hd__decap_12
XFILLER_35_57 VGND VGND VPWR VPWR sky130_fd_sc_hd__decap_6
XFILLER_27_178 VGND VGND VPWR VPWR sky130_fd_sc_hd__decap_3
XFILLER_27_189 VGND VGND VPWR VPWR sky130_fd_sc_hd__fill_1
XTAP_TAPCELL_ROW_40_305 VGND VPWR sky130_fd_sc_hd__tapvpwrvgnd_1
XPHY_EDGE_ROW_14_Right_14 VGND VGND VPWR VPWR sky130_fd_sc_hd__decap_3
XFILLER_2_244 VGND VGND VPWR VPWR sky130_fd_sc_hd__decap_4
XFILLER_2_222 VGND VGND VPWR VPWR sky130_fd_sc_hd__fill_1
XPHY_EDGE_ROW_23_Right_23 VGND VGND VPWR VPWR sky130_fd_sc_hd__decap_3
X_0900_ _0279_ _0280_ VGND VGND VPWR VPWR _0282_ sky130_fd_sc_hd__xnor2_1
XFILLER_41_181 VGND VGND VPWR VPWR sky130_fd_sc_hd__decap_4
XPHY_EDGE_ROW_32_Right_32 VGND VGND VPWR VPWR sky130_fd_sc_hd__decap_3
X_0762_ _0161_ _0162_ VGND VGND VPWR VPWR _0163_ sky130_fd_sc_hd__nor2_1
X_0831_ _0216_ _0219_ _0222_ VGND VGND VPWR VPWR _0223_ sky130_fd_sc_hd__a21oi_1
X_0693_ _0100_ _0101_ VGND VGND VPWR VPWR _0102_ sky130_fd_sc_hd__and2_1
XPHY_EDGE_ROW_41_Right_41 VGND VGND VPWR VPWR sky130_fd_sc_hd__decap_3
X_1314_ clknet_2_0__leaf_aclk _0044_ VGND VGND VPWR VPWR cnn_mac_wrapper.core_inst.product\[12\]
+ sky130_fd_sc_hd__dfxtp_1
X_1245_ _0613_ _0614_ VGND VGND VPWR VPWR _0616_ sky130_fd_sc_hd__xnor2_1
XFILLER_2_83 VGND VGND VPWR VPWR sky130_fd_sc_hd__fill_1
X_1176_ _0488_ _0526_ _0524_ VGND VGND VPWR VPWR _0549_ sky130_fd_sc_hd__a21bo_1
XFILLER_21_26 VGND VGND VPWR VPWR sky130_fd_sc_hd__decap_8
XFILLER_21_48 VGND VGND VPWR VPWR sky130_fd_sc_hd__decap_8
XFILLER_46_67 VGND VGND VPWR VPWR sky130_fd_sc_hd__decap_8
X_1030_ net64 _0406_ _0407_ net105 VGND VGND VPWR VPWR _0039_ sky130_fd_sc_hd__o211a_1
Xinput20 s_axis_tvalid VGND VGND VPWR VPWR net20 sky130_fd_sc_hd__buf_1
X_0814_ _0206_ _0207_ VGND VGND VPWR VPWR _0208_ sky130_fd_sc_hd__xor2_1
XFILLER_14_192 VGND VGND VPWR VPWR sky130_fd_sc_hd__decap_4
XFILLER_21_118 VPWR VGND VPWR VGND sky130_ef_sc_hd__decap_12
X_0676_ cnn_mac_wrapper.core_inst.product\[6\] net49 VGND VGND VPWR VPWR _0087_ sky130_fd_sc_hd__or2_1
X_0745_ net26 net68 VGND VGND VPWR VPWR _0148_ sky130_fd_sc_hd__or2_1
X_1228_ _0565_ _0568_ _0599_ VGND VGND VPWR VPWR _0600_ sky130_fd_sc_hd__nor3_1
XFILLER_37_273 VGND VGND VPWR VPWR sky130_fd_sc_hd__decap_6
X_1159_ _0499_ _0532_ VGND VGND VPWR VPWR _0533_ sky130_fd_sc_hd__xor2_1
XFILLER_16_15 VPWR VGND VPWR VGND sky130_ef_sc_hd__decap_12
XFILLER_16_37 VGND VGND VPWR VPWR sky130_fd_sc_hd__fill_2
XFILLER_43_254 VPWR VGND VPWR VGND sky130_ef_sc_hd__decap_12
XTAP_TAPCELL_ROW_13_168 VGND VPWR sky130_fd_sc_hd__tapvpwrvgnd_1
XFILLER_7_166 VGND VGND VPWR VPWR sky130_fd_sc_hd__fill_2
XFILLER_34_221 VGND VGND VPWR VPWR sky130_fd_sc_hd__decap_3
X_1013_ _0388_ _0389_ _0390_ VGND VGND VPWR VPWR _0391_ sky130_fd_sc_hd__nand3_2
XFILLER_8_82 VGND VGND VPWR VPWR sky130_fd_sc_hd__fill_2
XFILLER_8_93 VGND VGND VPWR VPWR sky130_fd_sc_hd__decap_6
X_0659_ _0071_ _0072_ net71 VGND VGND VPWR VPWR _0073_ sky130_fd_sc_hd__o21ai_1
XPHY_EDGE_ROW_4_Right_4 VGND VGND VPWR VPWR sky130_fd_sc_hd__decap_3
X_0728_ _0128_ _0132_ VGND VGND VPWR VPWR _0133_ sky130_fd_sc_hd__or2_1
XTAP_TAPCELL_ROW_4_125 VGND VPWR sky130_fd_sc_hd__tapvpwrvgnd_1
XFILLER_27_69 VGND VGND VPWR VPWR sky130_fd_sc_hd__decap_4
XTAP_TAPCELL_ROW_27_238 VGND VPWR sky130_fd_sc_hd__tapvpwrvgnd_1
XFILLER_43_57 VPWR VGND VPWR VGND sky130_ef_sc_hd__decap_12
XFILLER_40_268 VGND VGND VPWR VPWR sky130_fd_sc_hd__fill_2
XFILLER_4_29 VPWR VGND VPWR VGND sky130_ef_sc_hd__decap_12
XFILLER_31_202 VPWR VGND VPWR VGND sky130_ef_sc_hd__decap_12
XFILLER_16_276 VGND VGND VPWR VPWR sky130_fd_sc_hd__decap_4
XTAP_TAPCELL_ROW_1_106 VGND VPWR sky130_fd_sc_hd__tapvpwrvgnd_1
XTAP_TAPCELL_ROW_32_263 VGND VPWR sky130_fd_sc_hd__tapvpwrvgnd_1
XFILLER_9_217 VGND VGND VPWR VPWR sky130_fd_sc_hd__decap_6
XTAP_TAPCELL_ROW_46_333 VGND VPWR sky130_fd_sc_hd__tapvpwrvgnd_1
XFILLER_0_161 VGND VGND VPWR VPWR sky130_fd_sc_hd__decap_3
X_0993_ _0370_ VGND VGND VPWR VPWR _0371_ sky130_fd_sc_hd__inv_2
XFILLER_39_110 VGND VGND VPWR VPWR sky130_fd_sc_hd__fill_2
XFILLER_5_50 VGND VGND VPWR VPWR sky130_fd_sc_hd__fill_1
XFILLER_39_176 VGND VGND VPWR VPWR sky130_fd_sc_hd__decap_4
XFILLER_10_227 VGND VGND VPWR VPWR sky130_fd_sc_hd__decap_4
XFILLER_24_26 VGND VGND VPWR VPWR sky130_fd_sc_hd__fill_2
XFILLER_45_113 VPWR VGND VPWR VGND sky130_ef_sc_hd__decap_12
XPHY_EDGE_ROW_39_Left_87 VGND VGND VPWR VPWR sky130_fd_sc_hd__decap_3
XFILLER_14_81 VGND VGND VPWR VPWR sky130_fd_sc_hd__decap_3
XFILLER_14_92 VPWR VGND VPWR VGND sky130_ef_sc_hd__decap_12
XFILLER_5_275 VGND VGND VPWR VPWR sky130_fd_sc_hd__fill_1
X_1261_ net61 net67 _0630_ net102 VGND VGND VPWR VPWR _0047_ sky130_fd_sc_hd__o211a_1
XFILLER_36_168 VPWR VGND VPWR VGND sky130_ef_sc_hd__decap_12
Xinput7 s_axis_tdata[13] VGND VGND VPWR VPWR net7 sky130_fd_sc_hd__clkbuf_1
X_1192_ _0535_ _0537_ _0564_ VGND VGND VPWR VPWR _0565_ sky130_fd_sc_hd__a21oi_1
X_0976_ _0344_ _0353_ _0354_ VGND VGND VPWR VPWR _0355_ sky130_fd_sc_hd__nand3_1
XFILLER_19_26 VPWR VGND VPWR VGND sky130_ef_sc_hd__decap_12
XFILLER_4_3 VPWR VGND VPWR VGND sky130_ef_sc_hd__decap_12
X_0830_ net59 net38 VGND VGND VPWR VPWR _0222_ sky130_fd_sc_hd__xor2_2
XFILLER_26_190 VGND VGND VPWR VPWR sky130_fd_sc_hd__fill_2
X_0692_ cnn_mac_wrapper.core_inst.product\[8\] net51 VGND VGND VPWR VPWR _0101_ sky130_fd_sc_hd__nand2_1
X_0761_ net58 net28 VGND VGND VPWR VPWR _0162_ sky130_fd_sc_hd__and2_1
X_1244_ _0614_ _0613_ VGND VGND VPWR VPWR _0615_ sky130_fd_sc_hd__nand2b_1
X_1313_ clknet_2_0__leaf_aclk _0043_ VGND VGND VPWR VPWR cnn_mac_wrapper.core_inst.product\[11\]
+ sky130_fd_sc_hd__dfxtp_1
X_1175_ net118 net67 _0547_ _0548_ net104 VGND VGND VPWR VPWR _0043_ sky130_fd_sc_hd__o221a_1
XTAP_TAPCELL_ROW_19_196 VGND VPWR sky130_fd_sc_hd__tapvpwrvgnd_1
XFILLER_24_105 VPWR VGND VPWR VGND sky130_ef_sc_hd__decap_12
XFILLER_24_127 VPWR VGND VPWR VGND sky130_ef_sc_hd__decap_12
X_0959_ _0336_ _0337_ VGND VGND VPWR VPWR _0338_ sky130_fd_sc_hd__nor2_1
Xinput10 s_axis_tdata[1] VGND VGND VPWR VPWR net10 sky130_fd_sc_hd__clkbuf_1
X_0813_ _0199_ _0203_ _0200_ VGND VGND VPWR VPWR _0207_ sky130_fd_sc_hd__a21bo_1
XPHY_EDGE_ROW_26_Left_74 VGND VGND VPWR VPWR sky130_fd_sc_hd__decap_3
X_0675_ cnn_mac_wrapper.core_inst.product\[6\] net49 VGND VGND VPWR VPWR _0086_ sky130_fd_sc_hd__and2_1
X_0744_ _0142_ _0146_ VGND VGND VPWR VPWR _0147_ sky130_fd_sc_hd__xnor2_1
XPHY_EDGE_ROW_10_Left_58 VGND VGND VPWR VPWR sky130_fd_sc_hd__decap_3
X_1227_ _0596_ _0597_ VGND VGND VPWR VPWR _0599_ sky130_fd_sc_hd__xnor2_1
X_1158_ _0530_ _0531_ VGND VGND VPWR VPWR _0532_ sky130_fd_sc_hd__or2_1
XFILLER_32_26 VGND VGND VPWR VPWR sky130_fd_sc_hd__fill_2
XFILLER_16_27 VGND VGND VPWR VPWR sky130_fd_sc_hd__fill_1
XFILLER_20_141 VPWR VGND VPWR VGND sky130_ef_sc_hd__decap_12
X_1089_ _0422_ _0423_ _0463_ VGND VGND VPWR VPWR _0465_ sky130_fd_sc_hd__a21o_1
XFILLER_43_266 VPWR VGND VPWR VGND sky130_ef_sc_hd__decap_12
XTAP_TAPCELL_ROW_38_291 VGND VPWR sky130_fd_sc_hd__tapvpwrvgnd_1
XTAP_TAPCELL_ROW_13_169 VGND VPWR sky130_fd_sc_hd__tapvpwrvgnd_1
XFILLER_7_178 VPWR VGND VPWR VGND sky130_ef_sc_hd__decap_12
X_1012_ _0344_ _0354_ _0353_ VGND VGND VPWR VPWR _0390_ sky130_fd_sc_hd__a21bo_1
X_0727_ _0130_ _0131_ VGND VGND VPWR VPWR _0132_ sky130_fd_sc_hd__or2_1
X_0658_ _0068_ _0069_ _0070_ VGND VGND VPWR VPWR _0072_ sky130_fd_sc_hd__a21oi_1
XFILLER_25_244 VGND VGND VPWR VPWR sky130_fd_sc_hd__decap_8
XTAP_TAPCELL_ROW_27_239 VGND VPWR sky130_fd_sc_hd__tapvpwrvgnd_1
XFILLER_43_69 VPWR VGND VPWR VGND sky130_ef_sc_hd__decap_12
XFILLER_31_214 VGND VGND VPWR VPWR sky130_fd_sc_hd__fill_1
XTAP_TAPCELL_ROW_1_107 VGND VPWR sky130_fd_sc_hd__tapvpwrvgnd_1
XTAP_TAPCELL_ROW_32_264 VGND VPWR sky130_fd_sc_hd__tapvpwrvgnd_1
XPHY_EDGE_ROW_13_Left_61 VGND VGND VPWR VPWR sky130_fd_sc_hd__decap_3
XTAP_TAPCELL_ROW_23_220 VGND VPWR sky130_fd_sc_hd__tapvpwrvgnd_1
XTAP_TAPCELL_ROW_46_334 VGND VPWR sky130_fd_sc_hd__tapvpwrvgnd_1
XFILLER_12_280 VGND VGND VPWR VPWR sky130_fd_sc_hd__decap_4
X_0992_ net84 net88 net94 net92 VGND VGND VPWR VPWR _0370_ sky130_fd_sc_hd__and4_1
XFILLER_39_166 VGND VGND VPWR VPWR sky130_fd_sc_hd__fill_2
XTAP_TAPCELL_ROW_20_201 VGND VPWR sky130_fd_sc_hd__tapvpwrvgnd_1
XFILLER_45_147 VGND VGND VPWR VPWR sky130_fd_sc_hd__fill_1
XFILLER_14_71 VGND VGND VPWR VPWR sky130_fd_sc_hd__fill_2
XFILLER_5_210 VPWR VGND VPWR VGND sky130_ef_sc_hd__decap_12
X_1260_ _0617_ _0621_ _0629_ net63 VGND VGND VPWR VPWR _0630_ sky130_fd_sc_hd__a31o_1
X_1191_ _0562_ _0563_ VGND VGND VPWR VPWR _0564_ sky130_fd_sc_hd__nand2_1
Xinput8 s_axis_tdata[14] VGND VGND VPWR VPWR net8 sky130_fd_sc_hd__clkbuf_1
XFILLER_44_180 VGND VGND VPWR VPWR sky130_fd_sc_hd__decap_4
X_0975_ _0350_ _0351_ _0352_ VGND VGND VPWR VPWR _0354_ sky130_fd_sc_hd__a21o_1
XFILLER_10_29 VPWR VGND VPWR VGND sky130_ef_sc_hd__decap_12
XPHY_EDGE_ROW_40_Left_88 VGND VGND VPWR VPWR sky130_fd_sc_hd__decap_3
XFILLER_19_38 VPWR VGND VPWR VGND sky130_ef_sc_hd__decap_12
XFILLER_42_139 VGND VGND VPWR VPWR sky130_fd_sc_hd__fill_1
XFILLER_18_125 VPWR VGND VPWR VGND sky130_ef_sc_hd__decap_12
XFILLER_41_161 VGND VGND VPWR VPWR sky130_fd_sc_hd__decap_6
X_0760_ net58 net28 VGND VGND VPWR VPWR _0161_ sky130_fd_sc_hd__nor2_1
XFILLER_41_91 VPWR VGND VPWR VGND sky130_ef_sc_hd__decap_12
X_0691_ cnn_mac_wrapper.core_inst.product\[8\] net51 VGND VGND VPWR VPWR _0100_ sky130_fd_sc_hd__or2_1
XFILLER_2_85 VPWR VGND VPWR VGND sky130_ef_sc_hd__decap_12
XFILLER_2_41 VPWR VGND VPWR VGND sky130_ef_sc_hd__decap_12
X_1243_ _0558_ _0588_ _0587_ VGND VGND VPWR VPWR _0614_ sky130_fd_sc_hd__o21ba_1
X_1174_ _0519_ _0546_ net67 VGND VGND VPWR VPWR _0548_ sky130_fd_sc_hd__o21ai_1
X_1312_ clknet_2_0__leaf_aclk _0042_ VGND VGND VPWR VPWR cnn_mac_wrapper.core_inst.product\[10\]
+ sky130_fd_sc_hd__dfxtp_1
XTAP_TAPCELL_ROW_19_197 VGND VPWR sky130_fd_sc_hd__tapvpwrvgnd_1
XFILLER_24_117 VGND VGND VPWR VPWR sky130_fd_sc_hd__decap_3
XFILLER_24_139 VGND VGND VPWR VPWR sky130_fd_sc_hd__fill_1
X_0889_ net90 _0263_ _0270_ VGND VGND VPWR VPWR _0272_ sky130_fd_sc_hd__a21oi_1
X_0958_ net89 net92 _0318_ _0320_ VGND VGND VPWR VPWR _0337_ sky130_fd_sc_hd__a211oi_1
XFILLER_47_209 VGND VGND VPWR VPWR sky130_fd_sc_hd__decap_4
XFILLER_30_109 VPWR VGND VPWR VGND sky130_ef_sc_hd__decap_12
XFILLER_46_253 VPWR VGND VPWR VGND sky130_ef_sc_hd__decap_12
Xinput11 s_axis_tdata[2] VGND VGND VPWR VPWR net11 sky130_fd_sc_hd__clkbuf_1
X_0812_ net57 net36 VGND VGND VPWR VPWR _0206_ sky130_fd_sc_hd__xor2_1
X_0743_ _0132_ _0145_ _0144_ VGND VGND VPWR VPWR _0146_ sky130_fd_sc_hd__o21ai_1
X_0674_ net65 _0083_ _0084_ _0085_ net106 VGND VGND VPWR VPWR _0005_ sky130_fd_sc_hd__o311a_1
XFILLER_37_253 VGND VGND VPWR VPWR sky130_fd_sc_hd__decap_3
X_1226_ _0596_ _0597_ VGND VGND VPWR VPWR _0598_ sky130_fd_sc_hd__and2b_1
X_1157_ net76 net93 _0529_ VGND VGND VPWR VPWR _0531_ sky130_fd_sc_hd__and3_1
Xclkbuf_2_1__f_aclk clknet_0_aclk VGND VGND VPWR VPWR clknet_2_1__leaf_aclk sky130_fd_sc_hd__clkbuf_16
XFILLER_20_131 VGND VGND VPWR VPWR sky130_fd_sc_hd__fill_1
XFILLER_20_153 VPWR VGND VPWR VGND sky130_ef_sc_hd__decap_12
X_1088_ _0422_ _0423_ _0463_ VGND VGND VPWR VPWR _0464_ sky130_fd_sc_hd__nand3_1
XPHY_EDGE_ROW_43_Left_91 VGND VGND VPWR VPWR sky130_fd_sc_hd__decap_3
XFILLER_43_278 VGND VGND VPWR VPWR sky130_fd_sc_hd__fill_2
XFILLER_43_201 VGND VGND VPWR VPWR sky130_fd_sc_hd__decap_8
XTAP_TAPCELL_ROW_38_292 VGND VPWR sky130_fd_sc_hd__tapvpwrvgnd_1
XFILLER_28_253 VGND VGND VPWR VPWR sky130_fd_sc_hd__decap_4
XFILLER_7_113 VPWR VGND VPWR VGND sky130_ef_sc_hd__decap_12
X_1011_ _0386_ _0387_ _0381_ VGND VGND VPWR VPWR _0389_ sky130_fd_sc_hd__a21o_1
XFILLER_8_51 VGND VGND VPWR VPWR sky130_fd_sc_hd__decap_8
X_0726_ _0111_ _0121_ _0119_ VGND VGND VPWR VPWR _0131_ sky130_fd_sc_hd__a21bo_1
X_0657_ _0068_ _0069_ _0070_ VGND VGND VPWR VPWR _0071_ sky130_fd_sc_hd__and3_1
XFILLER_43_26 VGND VGND VPWR VPWR sky130_fd_sc_hd__fill_1
X_1209_ _0580_ VGND VGND VPWR VPWR _0581_ sky130_fd_sc_hd__inv_2
XFILLER_25_223 VGND VGND VPWR VPWR sky130_fd_sc_hd__fill_1
XFILLER_27_38 VPWR VGND VPWR VGND sky130_ef_sc_hd__decap_12
XFILLER_12_3 VGND VGND VPWR VPWR sky130_fd_sc_hd__decap_8
XTAP_TAPCELL_ROW_1_108 VGND VPWR sky130_fd_sc_hd__tapvpwrvgnd_1
XTAP_TAPCELL_ROW_32_265 VGND VPWR sky130_fd_sc_hd__tapvpwrvgnd_1
X_0709_ _0099_ _0114_ _0115_ VGND VGND VPWR VPWR _0116_ sky130_fd_sc_hd__a21oi_1
XFILLER_13_204 VGND VGND VPWR VPWR sky130_fd_sc_hd__decap_3
XFILLER_21_281 VGND VGND VPWR VPWR sky130_fd_sc_hd__decap_3
XFILLER_0_141 VGND VGND VPWR VPWR sky130_fd_sc_hd__fill_2
XTAP_TAPCELL_ROW_46_335 VGND VPWR sky130_fd_sc_hd__tapvpwrvgnd_1
X_0991_ net88 net94 _0342_ _0341_ VGND VGND VPWR VPWR _0369_ sky130_fd_sc_hd__a31o_1
XFILLER_40_27 VGND VGND VPWR VPWR sky130_fd_sc_hd__fill_1
XTAP_TAPCELL_ROW_20_202 VGND VPWR sky130_fd_sc_hd__tapvpwrvgnd_1
XTAP_TAPCELL_ROW_43_316 VGND VPWR sky130_fd_sc_hd__tapvpwrvgnd_1
XFILLER_5_255 VGND VGND VPWR VPWR sky130_fd_sc_hd__fill_2
XFILLER_5_222 VGND VGND VPWR VPWR sky130_fd_sc_hd__fill_2
X_1190_ _0555_ _0561_ VGND VGND VPWR VPWR _0563_ sky130_fd_sc_hd__nand2_1
Xinput9 s_axis_tdata[15] VGND VGND VPWR VPWR net9 sky130_fd_sc_hd__buf_1
XFILLER_44_192 VGND VGND VPWR VPWR sky130_fd_sc_hd__decap_4
X_0974_ _0350_ _0351_ _0352_ VGND VGND VPWR VPWR _0353_ sky130_fd_sc_hd__nand3_1
XFILLER_35_38 VGND VGND VPWR VPWR sky130_fd_sc_hd__fill_2
XFILLER_27_137 VGND VGND VPWR VPWR sky130_fd_sc_hd__decap_3
XFILLER_27_148 VGND VGND VPWR VPWR sky130_fd_sc_hd__fill_1
XFILLER_35_181 VGND VGND VPWR VPWR sky130_fd_sc_hd__decap_4
XFILLER_18_137 VGND VGND VPWR VPWR sky130_fd_sc_hd__decap_3
X_0690_ _0094_ _0096_ _0093_ VGND VGND VPWR VPWR _0099_ sky130_fd_sc_hd__a21bo_1
XFILLER_44_6 VPWR VGND VPWR VGND sky130_ef_sc_hd__decap_12
X_1311_ clknet_2_2__leaf_aclk _0041_ VGND VGND VPWR VPWR cnn_mac_wrapper.core_inst.product\[9\]
+ sky130_fd_sc_hd__dfxtp_1
X_1242_ _0611_ _0612_ VGND VGND VPWR VPWR _0613_ sky130_fd_sc_hd__and2_1
XFILLER_2_97 VPWR VGND VPWR VGND sky130_ef_sc_hd__decap_12
XFILLER_2_53 VPWR VGND VPWR VGND sky130_ef_sc_hd__decap_12
XPHY_EDGE_ROW_10_Right_10 VGND VGND VPWR VPWR sky130_fd_sc_hd__decap_3
X_1173_ _0519_ _0546_ VGND VGND VPWR VPWR _0547_ sky130_fd_sc_hd__and2_1
XFILLER_32_184 VGND VGND VPWR VPWR sky130_fd_sc_hd__fill_1
XTAP_TAPCELL_ROW_19_198 VGND VPWR sky130_fd_sc_hd__tapvpwrvgnd_1
X_0888_ net90 _0263_ _0270_ VGND VGND VPWR VPWR _0271_ sky130_fd_sc_hd__and3_1
X_0957_ _0318_ _0320_ net89 net91 VGND VGND VPWR VPWR _0336_ sky130_fd_sc_hd__o211a_1
XFILLER_46_15 VPWR VGND VPWR VGND sky130_ef_sc_hd__decap_12
XFILLER_23_162 VGND VGND VPWR VPWR sky130_fd_sc_hd__decap_6
XFILLER_11_73 VGND VGND VPWR VPWR sky130_fd_sc_hd__decap_3
XFILLER_46_265 VPWR VGND VPWR VGND sky130_ef_sc_hd__decap_12
Xinput12 s_axis_tdata[3] VGND VGND VPWR VPWR net12 sky130_fd_sc_hd__clkbuf_1
X_0673_ net48 net74 VGND VGND VPWR VPWR _0085_ sky130_fd_sc_hd__or2_1
X_0811_ net62 _0204_ _0205_ net103 VGND VGND VPWR VPWR _0022_ sky130_fd_sc_hd__o211a_1
X_0742_ _0128_ _0136_ VGND VGND VPWR VPWR _0145_ sky130_fd_sc_hd__nand2b_1
XFILLER_37_210 VGND VGND VPWR VPWR sky130_fd_sc_hd__decap_3
X_1225_ _0556_ _0557_ _0558_ _0560_ _0523_ VGND VGND VPWR VPWR _0597_ sky130_fd_sc_hd__a32o_1
X_1156_ net76 net93 _0529_ VGND VGND VPWR VPWR _0530_ sky130_fd_sc_hd__a21oi_1
XFILLER_16_29 VGND VGND VPWR VPWR sky130_fd_sc_hd__decap_8
X_1087_ net99 net9 VGND VGND VPWR VPWR _0463_ sky130_fd_sc_hd__nand2_1
XFILLER_20_165 VPWR VGND VPWR VGND sky130_ef_sc_hd__decap_12
XTAP_TAPCELL_ROW_7_136 VGND VPWR sky130_fd_sc_hd__tapvpwrvgnd_1
XTAP_TAPCELL_ROW_38_293 VGND VPWR sky130_fd_sc_hd__tapvpwrvgnd_1
XFILLER_11_121 VPWR VGND VPWR VGND sky130_ef_sc_hd__decap_12
XFILLER_7_125 VGND VGND VPWR VPWR sky130_fd_sc_hd__decap_4
XFILLER_22_83 VGND VGND VPWR VPWR sky130_fd_sc_hd__fill_1
X_1010_ _0381_ _0386_ _0387_ VGND VGND VPWR VPWR _0388_ sky130_fd_sc_hd__nand3_1
X_0656_ _0063_ _0064_ _0062_ VGND VGND VPWR VPWR _0070_ sky130_fd_sc_hd__a21bo_1
X_0725_ _0099_ _0114_ _0129_ VGND VGND VPWR VPWR _0130_ sky130_fd_sc_hd__a21oi_1
X_1208_ _0499_ _0579_ _0578_ VGND VGND VPWR VPWR _0580_ sky130_fd_sc_hd__a21oi_2
X_1139_ _0511_ _0512_ VGND VGND VPWR VPWR _0514_ sky130_fd_sc_hd__xnor2_1
XFILLER_4_139 VGND VGND VPWR VPWR sky130_fd_sc_hd__fill_1
Xclkbuf_0_aclk aclk VGND VGND VPWR VPWR clknet_0_aclk sky130_fd_sc_hd__clkbuf_16
XFILLER_16_235 VPWR VGND VPWR VGND sky130_ef_sc_hd__decap_12
XFILLER_33_60 VGND VGND VPWR VPWR sky130_fd_sc_hd__decap_8
XFILLER_31_249 VGND VGND VPWR VPWR sky130_fd_sc_hd__decap_3
XFILLER_3_150 VPWR VGND VPWR VGND sky130_ef_sc_hd__decap_12
XTAP_TAPCELL_ROW_1_109 VGND VPWR sky130_fd_sc_hd__tapvpwrvgnd_1
Xhold1 cnn_mac_wrapper.core_inst.product\[10\] VGND VGND VPWR VPWR net108 sky130_fd_sc_hd__dlygate4sd3_1
XPHY_EDGE_ROW_8_Right_8 VGND VGND VPWR VPWR sky130_fd_sc_hd__decap_3
XFILLER_22_249 VGND VGND VPWR VPWR sky130_fd_sc_hd__decap_3
XPHY_EDGE_ROW_39_Right_39 VGND VGND VPWR VPWR sky130_fd_sc_hd__decap_3
X_0639_ net2 net20 cnn_mac_wrapper.core_inst.product\[0\] net21 VGND VGND VPWR VPWR
+ _0056_ sky130_fd_sc_hd__a31o_1
X_0708_ _0101_ _0106_ _0105_ VGND VGND VPWR VPWR _0115_ sky130_fd_sc_hd__a21oi_1
XFILLER_0_175 VGND VGND VPWR VPWR sky130_fd_sc_hd__decap_3
XFILLER_0_197 VPWR VGND VPWR VGND sky130_ef_sc_hd__decap_12
XFILLER_28_82 VGND VGND VPWR VPWR sky130_fd_sc_hd__fill_2
X_0990_ net64 _0367_ _0368_ net107 VGND VGND VPWR VPWR _0038_ sky130_fd_sc_hd__o211a_1
XFILLER_39_102 VGND VGND VPWR VPWR sky130_fd_sc_hd__decap_8
XTAP_TAPCELL_ROW_20_203 VGND VPWR sky130_fd_sc_hd__tapvpwrvgnd_1
XFILLER_24_18 VGND VGND VPWR VPWR sky130_fd_sc_hd__decap_8
XTAP_TAPCELL_ROW_43_317 VGND VPWR sky130_fd_sc_hd__tapvpwrvgnd_1
XFILLER_14_51 VPWR VGND VPWR VGND sky130_ef_sc_hd__decap_12
XFILLER_5_245 VGND VGND VPWR VPWR sky130_fd_sc_hd__fill_1
X_0973_ _0311_ _0312_ _0313_ VGND VGND VPWR VPWR _0352_ sky130_fd_sc_hd__o21bai_1
XFILLER_27_105 VGND VGND VPWR VPWR sky130_fd_sc_hd__fill_1
XFILLER_2_248 VGND VGND VPWR VPWR sky130_fd_sc_hd__fill_1
XFILLER_41_185 VGND VGND VPWR VPWR sky130_fd_sc_hd__fill_1
XFILLER_37_6 VPWR VGND VPWR VGND sky130_ef_sc_hd__decap_12
X_1310_ clknet_2_2__leaf_aclk _0040_ VGND VGND VPWR VPWR cnn_mac_wrapper.core_inst.product\[8\]
+ sky130_fd_sc_hd__dfxtp_1
X_1241_ _0578_ _0591_ _0610_ VGND VGND VPWR VPWR _0612_ sky130_fd_sc_hd__or3_1
XFILLER_1_281 VGND VGND VPWR VPWR sky130_fd_sc_hd__decap_3
XFILLER_2_65 VPWR VGND VPWR VGND sky130_ef_sc_hd__decap_12
X_1172_ _0544_ _0545_ VGND VGND VPWR VPWR _0546_ sky130_fd_sc_hd__and2b_1
X_0956_ net64 _0334_ _0335_ net107 VGND VGND VPWR VPWR _0037_ sky130_fd_sc_hd__o211a_1
XFILLER_32_141 VPWR VGND VPWR VGND sky130_ef_sc_hd__decap_12
XTAP_TAPCELL_ROW_19_199 VGND VPWR sky130_fd_sc_hd__tapvpwrvgnd_1
X_0887_ _0266_ _0269_ VGND VGND VPWR VPWR _0270_ sky130_fd_sc_hd__xnor2_1
XFILLER_46_49 VGND VGND VPWR VPWR sky130_fd_sc_hd__fill_2
XFILLER_46_27 VGND VGND VPWR VPWR sky130_fd_sc_hd__fill_1
XFILLER_23_185 VGND VGND VPWR VPWR sky130_fd_sc_hd__decap_6
XFILLER_23_196 VGND VGND VPWR VPWR sky130_fd_sc_hd__fill_2
XFILLER_2_3 VPWR VGND VPWR VGND sky130_ef_sc_hd__decap_12
XFILLER_46_277 VGND VGND VPWR VPWR sky130_fd_sc_hd__decap_6
XFILLER_36_71 VGND VGND VPWR VPWR sky130_fd_sc_hd__fill_1
Xinput13 s_axis_tdata[4] VGND VGND VPWR VPWR net13 sky130_fd_sc_hd__clkbuf_1
X_0810_ net35 net68 VGND VGND VPWR VPWR _0205_ sky130_fd_sc_hd__or2_1
XFILLER_14_141 VGND VGND VPWR VPWR sky130_fd_sc_hd__decap_8
X_0672_ _0081_ _0082_ _0080_ VGND VGND VPWR VPWR _0084_ sky130_fd_sc_hd__a21oi_1
X_0741_ cnn_mac_wrapper.core_inst.product\[13\] net25 _0143_ VGND VGND VPWR VPWR _0144_
+ sky130_fd_sc_hd__o21ai_1
XFILLER_37_233 VPWR VGND VPWR VGND sky130_ef_sc_hd__decap_12
XFILLER_35_3 VGND VGND VPWR VPWR sky130_fd_sc_hd__fill_2
X_1224_ _0594_ _0595_ VGND VGND VPWR VPWR _0596_ sky130_fd_sc_hd__or2_1
X_1155_ _0494_ _0528_ net75 VGND VGND VPWR VPWR _0529_ sky130_fd_sc_hd__and3b_1
X_1086_ _0458_ _0461_ VGND VGND VPWR VPWR _0462_ sky130_fd_sc_hd__xor2_1
X_0939_ net85 net98 net96 net18 VGND VGND VPWR VPWR _0319_ sky130_fd_sc_hd__a22oi_1
XFILLER_32_29 VPWR VGND VPWR VGND sky130_ef_sc_hd__decap_12
XFILLER_32_18 VGND VGND VPWR VPWR sky130_fd_sc_hd__decap_8
XTAP_TAPCELL_ROW_15_180 VGND VPWR sky130_fd_sc_hd__tapvpwrvgnd_1
XFILLER_20_177 VPWR VGND VPWR VGND sky130_ef_sc_hd__decap_12
XTAP_TAPCELL_ROW_7_137 VGND VPWR sky130_fd_sc_hd__tapvpwrvgnd_1
XFILLER_28_222 VPWR VGND VPWR VGND sky130_ef_sc_hd__decap_12
XTAP_TAPCELL_ROW_38_294 VGND VPWR sky130_fd_sc_hd__tapvpwrvgnd_1
XFILLER_11_133 VGND VGND VPWR VPWR sky130_fd_sc_hd__decap_6
XFILLER_11_166 VGND VGND VPWR VPWR sky130_fd_sc_hd__fill_2
XFILLER_22_73 VGND VGND VPWR VPWR sky130_fd_sc_hd__fill_2
XFILLER_19_222 VGND VGND VPWR VPWR sky130_fd_sc_hd__fill_2
XFILLER_47_81 VGND VGND VPWR VPWR sky130_fd_sc_hd__decap_3
XTAP_TAPCELL_ROW_29_250 VGND VPWR sky130_fd_sc_hd__tapvpwrvgnd_1
XTAP_TAPCELL_ROW_12_161 VGND VPWR sky130_fd_sc_hd__tapvpwrvgnd_1
X_0655_ cnn_mac_wrapper.core_inst.product\[3\] net46 VGND VGND VPWR VPWR _0069_ sky130_fd_sc_hd__or2_1
XFILLER_6_181 VPWR VGND VPWR VGND sky130_ef_sc_hd__decap_12
X_0724_ _0112_ _0119_ _0120_ _0115_ VGND VGND VPWR VPWR _0129_ sky130_fd_sc_hd__a211o_1
X_1207_ _0466_ _0551_ VGND VGND VPWR VPWR _0579_ sky130_fd_sc_hd__nor2_1
XFILLER_43_17 VGND VGND VPWR VPWR sky130_fd_sc_hd__decap_6
XFILLER_40_217 VGND VGND VPWR VPWR sky130_fd_sc_hd__decap_3
X_1138_ _0509_ _0510_ _0512_ VGND VGND VPWR VPWR _0513_ sky130_fd_sc_hd__and3_1
XFILLER_25_225 VGND VGND VPWR VPWR sky130_fd_sc_hd__decap_6
XFILLER_25_269 VGND VGND VPWR VPWR sky130_fd_sc_hd__decap_6
X_1069_ _0444_ _0445_ VGND VGND VPWR VPWR _0446_ sky130_fd_sc_hd__and2b_1
XFILLER_16_247 VGND VGND VPWR VPWR sky130_fd_sc_hd__decap_4
XTAP_TAPCELL_ROW_26_231 VGND VPWR sky130_fd_sc_hd__tapvpwrvgnd_1
XFILLER_3_162 VGND VGND VPWR VPWR sky130_fd_sc_hd__decap_6
XFILLER_3_140 VGND VGND VPWR VPWR sky130_fd_sc_hd__fill_1
Xhold2 cnn_mac_wrapper.core_inst.product\[3\] VGND VGND VPWR VPWR net109 sky130_fd_sc_hd__dlygate4sd3_1
X_0707_ _0102_ _0107_ VGND VGND VPWR VPWR _0114_ sky130_fd_sc_hd__and2_1
X_0638_ net2 net20 VGND VGND VPWR VPWR _0055_ sky130_fd_sc_hd__nand2_1
XFILLER_0_154 VGND VGND VPWR VPWR sky130_fd_sc_hd__decap_3
XFILLER_44_82 VGND VGND VPWR VPWR sky130_fd_sc_hd__fill_2
XPHY_EDGE_ROW_17_Left_65 VGND VGND VPWR VPWR sky130_fd_sc_hd__decap_3
XTAP_TAPCELL_ROW_20_204 VGND VPWR sky130_fd_sc_hd__tapvpwrvgnd_1
XTAP_TAPCELL_ROW_43_318 VGND VPWR sky130_fd_sc_hd__tapvpwrvgnd_1
XFILLER_14_63 VGND VGND VPWR VPWR sky130_fd_sc_hd__decap_8
XFILLER_30_73 VGND VGND VPWR VPWR sky130_fd_sc_hd__fill_1
XFILLER_36_139 VGND VGND VPWR VPWR sky130_fd_sc_hd__fill_1
X_0972_ _0347_ _0348_ _0345_ VGND VGND VPWR VPWR _0351_ sky130_fd_sc_hd__o21ai_1
XFILLER_27_117 VPWR VGND VPWR VGND sky130_ef_sc_hd__decap_12
XFILLER_42_109 VPWR VGND VPWR VGND sky130_ef_sc_hd__decap_12
XFILLER_33_109 VGND VGND VPWR VPWR sky130_fd_sc_hd__decap_3
XFILLER_18_117 VGND VGND VPWR VPWR sky130_fd_sc_hd__fill_1
X_1240_ _0578_ _0591_ _0610_ VGND VGND VPWR VPWR _0611_ sky130_fd_sc_hd__o21ai_1
XFILLER_2_77 VGND VGND VPWR VPWR sky130_fd_sc_hd__decap_6
X_1171_ _0507_ _0509_ _0543_ VGND VGND VPWR VPWR _0545_ sky130_fd_sc_hd__a21o_1
XFILLER_32_120 VPWR VGND VPWR VGND sky130_ef_sc_hd__decap_12
X_0886_ _0267_ _0268_ VGND VGND VPWR VPWR _0269_ sky130_fd_sc_hd__nor2_1
X_0955_ cnn_mac_wrapper.core_inst.product\[5\] net73 VGND VGND VPWR VPWR _0335_ sky130_fd_sc_hd__or2_1
XFILLER_32_197 VGND VGND VPWR VPWR sky130_fd_sc_hd__decap_8
XFILLER_32_153 VPWR VGND VPWR VGND sky130_ef_sc_hd__decap_12
XFILLER_36_83 VGND VGND VPWR VPWR sky130_fd_sc_hd__fill_1
Xinput14 s_axis_tdata[5] VGND VGND VPWR VPWR net14 sky130_fd_sc_hd__buf_1
X_0740_ cnn_mac_wrapper.core_inst.product\[13\] net25 net24 cnn_mac_wrapper.core_inst.product\[12\]
+ VGND VGND VPWR VPWR _0143_ sky130_fd_sc_hd__a22o_1
XFILLER_14_197 VGND VGND VPWR VPWR sky130_fd_sc_hd__fill_1
X_0671_ _0080_ _0081_ _0082_ VGND VGND VPWR VPWR _0083_ sky130_fd_sc_hd__and3_1
XFILLER_37_245 VGND VGND VPWR VPWR sky130_fd_sc_hd__decap_8
XFILLER_37_223 VGND VGND VPWR VPWR sky130_fd_sc_hd__fill_1
X_1223_ _0554_ _0562_ _0593_ VGND VGND VPWR VPWR _0595_ sky130_fd_sc_hd__and3_1
X_1154_ net97 net95 VGND VGND VPWR VPWR _0528_ sky130_fd_sc_hd__or2_1
X_1085_ net76 _0459_ _0460_ VGND VGND VPWR VPWR _0461_ sky130_fd_sc_hd__a21bo_1
X_0869_ net65 _0254_ _0255_ net107 VGND VGND VPWR VPWR _0030_ sky130_fd_sc_hd__o211a_1
X_0938_ net85 net18 net98 net96 VGND VGND VPWR VPWR _0318_ sky130_fd_sc_hd__and4_1
XFILLER_20_189 VGND VGND VPWR VPWR sky130_fd_sc_hd__fill_2
XTAP_TAPCELL_ROW_7_138 VGND VPWR sky130_fd_sc_hd__tapvpwrvgnd_1
XTAP_TAPCELL_ROW_38_295 VGND VPWR sky130_fd_sc_hd__tapvpwrvgnd_1
XFILLER_28_234 VPWR VGND VPWR VGND sky130_ef_sc_hd__decap_12
XPHY_EDGE_ROW_5_Left_53 VGND VGND VPWR VPWR sky130_fd_sc_hd__decap_3
XFILLER_22_85 VPWR VGND VPWR VGND sky130_ef_sc_hd__decap_12
XFILLER_14_9 VGND VGND VPWR VPWR sky130_fd_sc_hd__fill_1
X_0723_ _0126_ _0127_ VGND VGND VPWR VPWR _0128_ sky130_fd_sc_hd__nand2_1
XTAP_TAPCELL_ROW_12_162 VGND VPWR sky130_fd_sc_hd__tapvpwrvgnd_1
X_0654_ cnn_mac_wrapper.core_inst.product\[3\] net46 VGND VGND VPWR VPWR _0068_ sky130_fd_sc_hd__nand2_1
X_1206_ _0466_ _0551_ VGND VGND VPWR VPWR _0578_ sky130_fd_sc_hd__and2_1
X_1137_ _0476_ _0478_ VGND VGND VPWR VPWR _0512_ sky130_fd_sc_hd__nand2_1
XTAP_TAPCELL_ROW_35_276 VGND VPWR sky130_fd_sc_hd__tapvpwrvgnd_1
XFILLER_33_281 VGND VGND VPWR VPWR sky130_fd_sc_hd__decap_3
X_1068_ _0441_ _0442_ _0443_ VGND VGND VPWR VPWR _0445_ sky130_fd_sc_hd__a21o_1
XPHY_EDGE_ROW_47_Left_95 VGND VGND VPWR VPWR sky130_fd_sc_hd__decap_3
XPHY_EDGE_ROW_31_Left_79 VGND VGND VPWR VPWR sky130_fd_sc_hd__decap_3
XTAP_TAPCELL_ROW_26_232 VGND VPWR sky130_fd_sc_hd__tapvpwrvgnd_1
Xhold3 cnn_mac_wrapper.core_inst.product\[4\] VGND VGND VPWR VPWR net110 sky130_fd_sc_hd__dlygate4sd3_1
XFILLER_30_251 VGND VGND VPWR VPWR sky130_fd_sc_hd__fill_1
XFILLER_15_281 VGND VGND VPWR VPWR sky130_fd_sc_hd__decap_3
X_0706_ _0111_ _0112_ VGND VGND VPWR VPWR _0113_ sky130_fd_sc_hd__nor2_1
XFILLER_38_29 VPWR VGND VPWR VGND sky130_ef_sc_hd__decap_12
X_0637_ net2 net20 VGND VGND VPWR VPWR _0054_ sky130_fd_sc_hd__and2_1
XTAP_TAPCELL_ROW_0_100 VGND VPWR sky130_fd_sc_hd__tapvpwrvgnd_1
XFILLER_21_251 VGND VGND VPWR VPWR sky130_fd_sc_hd__fill_1
XFILLER_5_44 VGND VGND VPWR VPWR sky130_fd_sc_hd__fill_1
XFILLER_10_3 VGND VGND VPWR VPWR sky130_fd_sc_hd__decap_8
XTAP_TAPCELL_ROW_20_205 VGND VPWR sky130_fd_sc_hd__tapvpwrvgnd_1
XFILLER_45_107 VGND VGND VPWR VPWR sky130_fd_sc_hd__fill_1
XTAP_TAPCELL_ROW_43_319 VGND VPWR sky130_fd_sc_hd__tapvpwrvgnd_1
XFILLER_14_20 VGND VGND VPWR VPWR sky130_fd_sc_hd__fill_1
XFILLER_14_42 VGND VGND VPWR VPWR sky130_fd_sc_hd__fill_1
XFILLER_5_225 VPWR VGND VPWR VGND sky130_ef_sc_hd__decap_12
XFILLER_30_85 VPWR VGND VPWR VGND sky130_ef_sc_hd__decap_12
XFILLER_44_162 VGND VGND VPWR VPWR sky130_fd_sc_hd__fill_1
XPHY_EDGE_ROW_34_Left_82 VGND VGND VPWR VPWR sky130_fd_sc_hd__decap_3
XFILLER_29_181 VPWR VGND VPWR VGND sky130_ef_sc_hd__decap_12
X_0971_ _0345_ _0347_ _0348_ VGND VGND VPWR VPWR _0350_ sky130_fd_sc_hd__or3_1
XFILLER_27_129 VGND VGND VPWR VPWR sky130_fd_sc_hd__decap_8
XFILLER_1_250 VGND VGND VPWR VPWR sky130_fd_sc_hd__decap_4
X_1170_ _0507_ _0509_ _0543_ VGND VGND VPWR VPWR _0544_ sky130_fd_sc_hd__and3_1
XFILLER_32_165 VPWR VGND VPWR VGND sky130_ef_sc_hd__decap_12
XFILLER_32_132 VGND VGND VPWR VPWR sky130_fd_sc_hd__decap_8
X_0954_ _0306_ _0332_ VGND VGND VPWR VPWR _0334_ sky130_fd_sc_hd__xnor2_1
X_0885_ net87 net84 net100 net88 VGND VGND VPWR VPWR _0268_ sky130_fd_sc_hd__a22oi_1
XFILLER_46_29 VPWR VGND VPWR VGND sky130_ef_sc_hd__decap_12
X_1299_ clknet_2_3__leaf_aclk _0029_ VGND VGND VPWR VPWR net42 sky130_fd_sc_hd__dfxtp_1
XFILLER_23_154 VGND VGND VPWR VPWR sky130_fd_sc_hd__fill_1
XFILLER_11_65 VGND VGND VPWR VPWR sky130_fd_sc_hd__decap_8
XFILLER_11_87 VPWR VGND VPWR VGND sky130_ef_sc_hd__decap_12
XFILLER_46_213 VPWR VGND VPWR VGND sky130_ef_sc_hd__decap_12
X_0670_ cnn_mac_wrapper.core_inst.product\[5\] net48 VGND VGND VPWR VPWR _0082_ sky130_fd_sc_hd__nand2_1
Xinput15 s_axis_tdata[6] VGND VGND VPWR VPWR net15 sky130_fd_sc_hd__buf_1
XFILLER_37_279 VGND VGND VPWR VPWR sky130_fd_sc_hd__fill_1
X_1222_ _0554_ _0562_ _0593_ VGND VGND VPWR VPWR _0594_ sky130_fd_sc_hd__a21oi_1
X_1153_ _0488_ _0526_ VGND VGND VPWR VPWR _0527_ sky130_fd_sc_hd__xnor2_1
X_1084_ net97 net76 net78 net95 VGND VGND VPWR VPWR _0460_ sky130_fd_sc_hd__a22o_1
X_0868_ net44 net74 VGND VGND VPWR VPWR _0255_ sky130_fd_sc_hd__or2_1
X_0937_ _0314_ _0315_ _0310_ VGND VGND VPWR VPWR _0317_ sky130_fd_sc_hd__a21o_1
X_0799_ net57 net34 VGND VGND VPWR VPWR _0195_ sky130_fd_sc_hd__xor2_2
XTAP_TAPCELL_ROW_7_139 VGND VPWR sky130_fd_sc_hd__tapvpwrvgnd_1
XFILLER_28_213 VGND VGND VPWR VPWR sky130_fd_sc_hd__fill_1
XFILLER_28_246 VGND VGND VPWR VPWR sky130_fd_sc_hd__decap_6
XFILLER_28_257 VGND VGND VPWR VPWR sky130_fd_sc_hd__fill_1
XFILLER_11_146 VPWR VGND VPWR VGND sky130_ef_sc_hd__decap_12
XFILLER_22_97 VGND VGND VPWR VPWR sky130_fd_sc_hd__decap_4
XFILLER_34_205 VGND VGND VPWR VPWR sky130_fd_sc_hd__fill_1
XFILLER_8_11 VGND VGND VPWR VPWR sky130_fd_sc_hd__decap_3
X_0653_ net115 net71 _0067_ net105 VGND VGND VPWR VPWR _0002_ sky130_fd_sc_hd__o211a_1
X_0722_ cnn_mac_wrapper.core_inst.product\[12\] net24 VGND VGND VPWR VPWR _0127_ sky130_fd_sc_hd__nand2_1
XTAP_TAPCELL_ROW_12_163 VGND VPWR sky130_fd_sc_hd__tapvpwrvgnd_1
X_1205_ net63 _0576_ _0577_ net104 VGND VGND VPWR VPWR _0044_ sky130_fd_sc_hd__o211a_1
X_1136_ _0509_ _0510_ VGND VGND VPWR VPWR _0511_ sky130_fd_sc_hd__nand2_1
XFILLER_25_205 VPWR VGND VPWR VGND sky130_ef_sc_hd__decap_12
XFILLER_25_238 VGND VGND VPWR VPWR sky130_fd_sc_hd__fill_1
X_1067_ _0441_ _0442_ _0443_ VGND VGND VPWR VPWR _0444_ sky130_fd_sc_hd__and3_1
XTAP_TAPCELL_ROW_35_277 VGND VPWR sky130_fd_sc_hd__tapvpwrvgnd_1
XFILLER_4_109 VPWR VGND VPWR VGND sky130_ef_sc_hd__decap_12
XTAP_TAPCELL_ROW_3_120 VGND VPWR sky130_fd_sc_hd__tapvpwrvgnd_1
XFILLER_17_75 VGND VGND VPWR VPWR sky130_fd_sc_hd__decap_6
XTAP_TAPCELL_ROW_26_233 VGND VPWR sky130_fd_sc_hd__tapvpwrvgnd_1
XFILLER_33_85 VPWR VGND VPWR VGND sky130_ef_sc_hd__decap_12
Xhold4 cnn_mac_wrapper.core_inst.product\[14\] VGND VGND VPWR VPWR net111 sky130_fd_sc_hd__dlygate4sd3_1
X_0636_ net16 VGND VGND VPWR VPWR _0053_ sky130_fd_sc_hd__inv_2
X_0705_ cnn_mac_wrapper.core_inst.product\[10\] net22 VGND VGND VPWR VPWR _0112_ sky130_fd_sc_hd__and2_1
XTAP_TAPCELL_ROW_0_101 VGND VPWR sky130_fd_sc_hd__tapvpwrvgnd_1
X_1119_ net97 net95 net75 VGND VGND VPWR VPWR _0494_ sky130_fd_sc_hd__and3_1
XPHY_EDGE_ROW_17_Right_17 VGND VGND VPWR VPWR sky130_fd_sc_hd__decap_3
XFILLER_21_274 VGND VGND VPWR VPWR sky130_fd_sc_hd__fill_2
XPHY_EDGE_ROW_26_Right_26 VGND VGND VPWR VPWR sky130_fd_sc_hd__decap_3
XFILLER_0_189 VGND VGND VPWR VPWR sky130_fd_sc_hd__decap_3
XFILLER_28_41 VGND VGND VPWR VPWR sky130_fd_sc_hd__decap_4
XPHY_EDGE_ROW_35_Right_35 VGND VGND VPWR VPWR sky130_fd_sc_hd__decap_3
XFILLER_8_212 VPWR VGND VPWR VGND sky130_ef_sc_hd__decap_12
XFILLER_12_241 VGND VGND VPWR VPWR sky130_fd_sc_hd__fill_1
XFILLER_5_67 VPWR VGND VPWR VGND sky130_ef_sc_hd__decap_12
XPHY_EDGE_ROW_44_Right_44 VGND VGND VPWR VPWR sky130_fd_sc_hd__decap_3
XFILLER_47_182 VGND VGND VPWR VPWR sky130_fd_sc_hd__decap_3
XFILLER_30_97 VPWR VGND VPWR VGND sky130_ef_sc_hd__decap_12
XFILLER_39_84 VGND VGND VPWR VPWR sky130_fd_sc_hd__fill_1
XFILLER_29_193 VGND VGND VPWR VPWR sky130_fd_sc_hd__fill_2
X_0970_ _0345_ _0347_ _0348_ VGND VGND VPWR VPWR _0349_ sky130_fd_sc_hd__nor3_1
XFILLER_35_185 VGND VGND VPWR VPWR sky130_fd_sc_hd__fill_1
XFILLER_2_218 VGND VGND VPWR VPWR sky130_fd_sc_hd__decap_4
XFILLER_41_111 VGND VGND VPWR VPWR sky130_fd_sc_hd__fill_1
XFILLER_25_20 VGND VGND VPWR VPWR sky130_fd_sc_hd__fill_2
XFILLER_41_63 VGND VGND VPWR VPWR sky130_fd_sc_hd__fill_1
XFILLER_25_86 VPWR VGND VPWR VGND sky130_ef_sc_hd__decap_12
XFILLER_1_262 VGND VGND VPWR VPWR sky130_fd_sc_hd__fill_2
XFILLER_32_177 VGND VGND VPWR VPWR sky130_fd_sc_hd__fill_2
XFILLER_17_185 VPWR VGND VPWR VGND sky130_ef_sc_hd__decap_12
X_0884_ net84 _0263_ VGND VGND VPWR VPWR _0267_ sky130_fd_sc_hd__and2_1
X_0953_ _0286_ _0304_ _0305_ _0330_ VGND VGND VPWR VPWR _0333_ sky130_fd_sc_hd__and4_1
X_1298_ clknet_2_3__leaf_aclk _0028_ VGND VGND VPWR VPWR net41 sky130_fd_sc_hd__dfxtp_1
XFILLER_23_111 VGND VGND VPWR VPWR sky130_fd_sc_hd__fill_1
XTAP_TAPCELL_ROW_18_191 VGND VPWR sky130_fd_sc_hd__tapvpwrvgnd_1
XFILLER_11_99 VGND VGND VPWR VPWR sky130_fd_sc_hd__decap_4
XFILLER_46_225 VPWR VGND VPWR VGND sky130_ef_sc_hd__decap_12
XFILLER_36_85 VPWR VGND VPWR VGND sky130_ef_sc_hd__decap_12
XFILLER_36_41 VGND VGND VPWR VPWR sky130_fd_sc_hd__decap_8
Xinput16 s_axis_tdata[7] VGND VGND VPWR VPWR net16 sky130_fd_sc_hd__buf_2
X_1221_ _0591_ _0592_ VGND VGND VPWR VPWR _0593_ sky130_fd_sc_hd__or2_1
X_1152_ _0524_ _0525_ VGND VGND VPWR VPWR _0526_ sky130_fd_sc_hd__and2_1
X_1083_ net97 net95 net78 VGND VGND VPWR VPWR _0459_ sky130_fd_sc_hd__and3_1
X_0936_ _0310_ _0314_ _0315_ VGND VGND VPWR VPWR _0316_ sky130_fd_sc_hd__nand3_1
X_0867_ _0251_ _0253_ VGND VGND VPWR VPWR _0254_ sky130_fd_sc_hd__xnor2_1
X_0798_ net33 net68 _0194_ net103 VGND VGND VPWR VPWR _0020_ sky130_fd_sc_hd__o211a_1
XFILLER_11_158 VGND VGND VPWR VPWR sky130_fd_sc_hd__decap_8
XFILLER_11_169 VGND VGND VPWR VPWR sky130_fd_sc_hd__decap_3
XFILLER_0_3 VPWR VGND VPWR VGND sky130_ef_sc_hd__decap_12
XFILLER_19_225 VPWR VGND VPWR VGND sky130_ef_sc_hd__decap_12
XFILLER_42_283 VGND VGND VPWR VPWR sky130_fd_sc_hd__fill_1
XFILLER_42_250 VGND VGND VPWR VPWR sky130_fd_sc_hd__fill_2
X_0652_ _0065_ _0066_ net71 VGND VGND VPWR VPWR _0067_ sky130_fd_sc_hd__o21ai_1
X_0721_ cnn_mac_wrapper.core_inst.product\[12\] net24 VGND VGND VPWR VPWR _0126_ sky130_fd_sc_hd__or2_1
XTAP_TAPCELL_ROW_12_164 VGND VPWR sky130_fd_sc_hd__tapvpwrvgnd_1
XFILLER_33_3 VPWR VGND VPWR VGND sky130_ef_sc_hd__decap_12
X_1204_ cnn_mac_wrapper.core_inst.product\[12\] net67 VGND VGND VPWR VPWR _0577_ sky130_fd_sc_hd__or2_1
XFILLER_40_209 VGND VGND VPWR VPWR sky130_fd_sc_hd__decap_8
XTAP_TAPCELL_ROW_35_278 VGND VPWR sky130_fd_sc_hd__tapvpwrvgnd_1
XFILLER_33_261 VGND VGND VPWR VPWR sky130_fd_sc_hd__decap_3
X_1066_ _0336_ _0398_ _0396_ VGND VGND VPWR VPWR _0443_ sky130_fd_sc_hd__a21o_1
X_1135_ _0454_ _0456_ _0508_ VGND VGND VPWR VPWR _0510_ sky130_fd_sc_hd__or3_1
XFILLER_25_217 VGND VGND VPWR VPWR sky130_fd_sc_hd__decap_6
X_0919_ _0298_ _0299_ VGND VGND VPWR VPWR _0300_ sky130_fd_sc_hd__nor2_1
XFILLER_17_21 VGND VGND VPWR VPWR sky130_fd_sc_hd__fill_1
XFILLER_17_32 VGND VGND VPWR VPWR sky130_fd_sc_hd__fill_2
XFILLER_17_54 VGND VGND VPWR VPWR sky130_fd_sc_hd__fill_2
XFILLER_17_65 VGND VGND VPWR VPWR sky130_fd_sc_hd__fill_2
XFILLER_33_75 VGND VGND VPWR VPWR sky130_fd_sc_hd__decap_4
XTAP_TAPCELL_ROW_26_234 VGND VPWR sky130_fd_sc_hd__tapvpwrvgnd_1
XFILLER_33_97 VPWR VGND VPWR VGND sky130_ef_sc_hd__decap_12
Xhold5 cnn_mac_wrapper.core_inst.product\[9\] VGND VGND VPWR VPWR net112 sky130_fd_sc_hd__dlygate4sd3_1
XFILLER_30_253 VPWR VGND VPWR VGND sky130_ef_sc_hd__decap_12
X_0635_ net76 VGND VGND VPWR VPWR _0052_ sky130_fd_sc_hd__inv_2
X_0704_ cnn_mac_wrapper.core_inst.product\[10\] net22 VGND VGND VPWR VPWR _0111_ sky130_fd_sc_hd__nor2_1
XTAP_TAPCELL_ROW_0_102 VGND VPWR sky130_fd_sc_hd__tapvpwrvgnd_1
X_1118_ net95 net77 net75 net97 VGND VGND VPWR VPWR _0493_ sky130_fd_sc_hd__a22oi_1
X_1049_ net99 net77 _0422_ _0423_ VGND VGND VPWR VPWR _0426_ sky130_fd_sc_hd__nand4_1
XFILLER_0_113 VPWR VGND VPWR VGND sky130_ef_sc_hd__decap_12
XFILLER_0_146 VGND VGND VPWR VPWR sky130_fd_sc_hd__decap_4
XFILLER_28_53 VPWR VGND VPWR VGND sky130_ef_sc_hd__decap_12
XFILLER_28_97 VGND VGND VPWR VPWR sky130_fd_sc_hd__decap_4
XFILLER_8_224 VPWR VGND VPWR VGND sky130_ef_sc_hd__decap_12
XFILLER_12_253 VGND VGND VPWR VPWR sky130_fd_sc_hd__fill_1
XFILLER_5_79 VPWR VGND VPWR VGND sky130_ef_sc_hd__decap_12
XFILLER_39_117 VPWR VGND VPWR VGND sky130_ef_sc_hd__decap_12
XFILLER_36_109 VPWR VGND VPWR VGND sky130_ef_sc_hd__decap_12
XFILLER_44_197 VGND VGND VPWR VPWR sky130_fd_sc_hd__decap_4
XFILLER_18_109 VGND VGND VPWR VPWR sky130_fd_sc_hd__decap_8
XFILLER_26_164 VGND VGND VPWR VPWR sky130_fd_sc_hd__decap_3
XFILLER_41_167 VGND VGND VPWR VPWR sky130_fd_sc_hd__fill_1
XFILLER_41_53 VGND VGND VPWR VPWR sky130_fd_sc_hd__decap_3
XFILLER_25_98 VPWR VGND VPWR VGND sky130_ef_sc_hd__decap_12
XFILLER_17_164 VGND VGND VPWR VPWR sky130_fd_sc_hd__decap_4
X_0952_ _0303_ _0330_ VGND VGND VPWR VPWR _0332_ sky130_fd_sc_hd__xnor2_1
XFILLER_17_197 VPWR VGND VPWR VGND sky130_ef_sc_hd__decap_12
X_0883_ net99 net89 VGND VGND VPWR VPWR _0266_ sky130_fd_sc_hd__nand2_1
XTAP_TAPCELL_ROW_18_192 VGND VPWR sky130_fd_sc_hd__tapvpwrvgnd_1
XFILLER_23_134 VPWR VGND VPWR VGND sky130_ef_sc_hd__decap_12
X_1297_ clknet_2_3__leaf_aclk _0027_ VGND VGND VPWR VPWR net40 sky130_fd_sc_hd__dfxtp_1
XFILLER_11_45 VGND VGND VPWR VPWR sky130_fd_sc_hd__fill_1
XFILLER_46_237 VPWR VGND VPWR VGND sky130_ef_sc_hd__decap_12
XFILLER_36_53 VPWR VGND VPWR VGND sky130_ef_sc_hd__decap_12
XFILLER_36_97 VPWR VGND VPWR VGND sky130_ef_sc_hd__decap_12
Xinput17 s_axis_tdata[8] VGND VGND VPWR VPWR net17 sky130_fd_sc_hd__buf_1
X_1220_ _0581_ _0590_ VGND VGND VPWR VPWR _0592_ sky130_fd_sc_hd__and2_1
X_1151_ _0522_ _0523_ _0521_ VGND VGND VPWR VPWR _0525_ sky130_fd_sc_hd__o21ai_1
XFILLER_28_6 VGND VGND VPWR VPWR sky130_fd_sc_hd__decap_4
XFILLER_45_281 VGND VGND VPWR VPWR sky130_fd_sc_hd__decap_3
X_1082_ net80 net93 VGND VGND VPWR VPWR _0458_ sky130_fd_sc_hd__nand2_1
X_0935_ _0312_ _0313_ _0311_ VGND VGND VPWR VPWR _0315_ sky130_fd_sc_hd__o21ai_1
X_0866_ _0239_ _0242_ _0246_ _0252_ VGND VGND VPWR VPWR _0253_ sky130_fd_sc_hd__a31o_1
X_0797_ _0191_ _0193_ net68 VGND VGND VPWR VPWR _0194_ sky130_fd_sc_hd__o21ai_1
XFILLER_47_85 VPWR VGND VPWR VGND sky130_ef_sc_hd__decap_12
XFILLER_47_41 VPWR VGND VPWR VGND sky130_ef_sc_hd__decap_12
XFILLER_19_237 VPWR VGND VPWR VGND sky130_ef_sc_hd__decap_12
XFILLER_27_270 VGND VGND VPWR VPWR sky130_fd_sc_hd__decap_6
XFILLER_27_281 VGND VGND VPWR VPWR sky130_fd_sc_hd__decap_3
XTAP_TAPCELL_ROW_12_165 VGND VPWR sky130_fd_sc_hd__tapvpwrvgnd_1
X_0720_ net62 _0124_ _0125_ net103 VGND VGND VPWR VPWR _0011_ sky130_fd_sc_hd__o211a_1
X_0651_ _0062_ _0063_ _0064_ VGND VGND VPWR VPWR _0066_ sky130_fd_sc_hd__a21oi_1
XFILLER_10_192 VGND VGND VPWR VPWR sky130_fd_sc_hd__decap_4
X_1203_ _0574_ _0575_ VGND VGND VPWR VPWR _0576_ sky130_fd_sc_hd__and2_1
X_1134_ _0454_ _0456_ _0508_ VGND VGND VPWR VPWR _0509_ sky130_fd_sc_hd__o21ai_1
XTAP_TAPCELL_ROW_35_279 VGND VPWR sky130_fd_sc_hd__tapvpwrvgnd_1
X_1065_ _0438_ _0439_ _0376_ VGND VGND VPWR VPWR _0442_ sky130_fd_sc_hd__o21ai_1
X_0918_ _0295_ _0296_ _0297_ VGND VGND VPWR VPWR _0299_ sky130_fd_sc_hd__a21oi_1
X_0849_ net40 net39 net38 net37 net59 VGND VGND VPWR VPWR _0238_ sky130_fd_sc_hd__o41a_1
XPHY_EDGE_ROW_9_Left_57 VGND VGND VPWR VPWR sky130_fd_sc_hd__decap_3
XFILLER_16_207 VPWR VGND VPWR VGND sky130_ef_sc_hd__decap_12
XFILLER_17_88 VGND VGND VPWR VPWR sky130_fd_sc_hd__decap_6
XTAP_TAPCELL_ROW_26_235 VGND VPWR sky130_fd_sc_hd__tapvpwrvgnd_1
XFILLER_33_43 VGND VGND VPWR VPWR sky130_fd_sc_hd__fill_1
XFILLER_3_133 VGND VGND VPWR VPWR sky130_fd_sc_hd__fill_2
XFILLER_3_111 VGND VGND VPWR VPWR sky130_fd_sc_hd__fill_1
Xhold6 net46 VGND VGND VPWR VPWR net113 sky130_fd_sc_hd__dlygate4sd3_1
XFILLER_3_188 VGND VGND VPWR VPWR sky130_fd_sc_hd__fill_2
XFILLER_30_265 VPWR VGND VPWR VGND sky130_ef_sc_hd__decap_12
X_0703_ net121 net73 _0110_ net106 VGND VGND VPWR VPWR _0009_ sky130_fd_sc_hd__o211a_1
XTAP_TAPCELL_ROW_0_103 VGND VPWR sky130_fd_sc_hd__tapvpwrvgnd_1
X_1117_ _0452_ _0491_ VGND VGND VPWR VPWR _0492_ sky130_fd_sc_hd__xnor2_1
XTAP_TAPCELL_ROW_31_260 VGND VPWR sky130_fd_sc_hd__tapvpwrvgnd_1
XPHY_EDGE_ROW_3_Right_3 VGND VGND VPWR VPWR sky130_fd_sc_hd__decap_3
X_1048_ net99 net77 _0422_ _0423_ VGND VGND VPWR VPWR _0425_ sky130_fd_sc_hd__a22o_1
XTAP_TAPCELL_ROW_23_216 VGND VPWR sky130_fd_sc_hd__tapvpwrvgnd_1
XFILLER_0_125 VPWR VGND VPWR VGND sky130_ef_sc_hd__decap_12
XFILLER_0_169 VGND VGND VPWR VPWR sky130_fd_sc_hd__fill_2
XFILLER_28_10 VGND VGND VPWR VPWR sky130_fd_sc_hd__fill_1
XFILLER_28_65 VGND VGND VPWR VPWR sky130_fd_sc_hd__fill_2
XFILLER_44_75 VGND VGND VPWR VPWR sky130_fd_sc_hd__fill_2
XFILLER_12_221 VGND VGND VPWR VPWR sky130_fd_sc_hd__fill_1
XFILLER_8_236 VGND VGND VPWR VPWR sky130_fd_sc_hd__decap_6
XFILLER_47_195 VGND VGND VPWR VPWR sky130_fd_sc_hd__fill_1
XFILLER_39_129 VGND VGND VPWR VPWR sky130_fd_sc_hd__fill_1
XTAP_TAPCELL_ROW_45_330 VGND VPWR sky130_fd_sc_hd__tapvpwrvgnd_1
XFILLER_39_31 VPWR VGND VPWR VGND sky130_ef_sc_hd__decap_12
XFILLER_30_33 VPWR VGND VPWR VGND sky130_ef_sc_hd__decap_12
XTAP_TAPCELL_ROW_42_311 VGND VPWR sky130_fd_sc_hd__tapvpwrvgnd_1
XFILLER_4_250 VGND VGND VPWR VPWR sky130_fd_sc_hd__fill_2
XFILLER_41_113 VPWR VGND VPWR VGND sky130_ef_sc_hd__decap_12
XFILLER_25_55 VGND VGND VPWR VPWR sky130_fd_sc_hd__fill_1
XFILLER_25_77 VGND VGND VPWR VPWR sky130_fd_sc_hd__decap_3
XPHY_EDGE_ROW_38_Left_86 VGND VGND VPWR VPWR sky130_fd_sc_hd__decap_3
XFILLER_2_15 VPWR VGND VPWR VGND sky130_ef_sc_hd__decap_12
XFILLER_17_121 VPWR VGND VPWR VGND sky130_ef_sc_hd__decap_12
X_0882_ net114 net71 _0265_ net105 VGND VGND VPWR VPWR _0033_ sky130_fd_sc_hd__o211a_1
X_0951_ _0328_ _0329_ _0303_ VGND VGND VPWR VPWR _0331_ sky130_fd_sc_hd__nand3b_1
X_1296_ clknet_2_3__leaf_aclk _0026_ VGND VGND VPWR VPWR net39 sky130_fd_sc_hd__dfxtp_1
XTAP_TAPCELL_ROW_18_193 VGND VPWR sky130_fd_sc_hd__tapvpwrvgnd_1
XFILLER_23_113 VGND VGND VPWR VPWR sky130_fd_sc_hd__fill_1
XFILLER_23_146 VGND VGND VPWR VPWR sky130_fd_sc_hd__decap_8
XFILLER_31_190 VPWR VGND VPWR VGND sky130_ef_sc_hd__decap_12
XFILLER_46_249 VGND VGND VPWR VPWR sky130_fd_sc_hd__decap_3
XFILLER_46_205 VGND VGND VPWR VPWR sky130_fd_sc_hd__decap_3
XFILLER_36_65 VGND VGND VPWR VPWR sky130_fd_sc_hd__decap_6
Xinput18 s_axis_tdata[9] VGND VGND VPWR VPWR net18 sky130_fd_sc_hd__buf_1
XTAP_TAPCELL_ROW_9_150 VGND VPWR sky130_fd_sc_hd__tapvpwrvgnd_1
X_1150_ _0521_ _0522_ _0523_ VGND VGND VPWR VPWR _0524_ sky130_fd_sc_hd__or3_1
X_1081_ _0411_ _0455_ VGND VGND VPWR VPWR _0457_ sky130_fd_sc_hd__xnor2_1
X_0934_ _0311_ _0312_ _0313_ VGND VGND VPWR VPWR _0314_ sky130_fd_sc_hd__or3_1
X_0865_ net42 net41 net60 VGND VGND VPWR VPWR _0252_ sky130_fd_sc_hd__o21a_1
X_0796_ _0186_ _0188_ _0190_ VGND VGND VPWR VPWR _0193_ sky130_fd_sc_hd__and3_1
X_1279_ clknet_2_3__leaf_aclk _0009_ VGND VGND VPWR VPWR net52 sky130_fd_sc_hd__dfxtp_1
XFILLER_28_205 VGND VGND VPWR VPWR sky130_fd_sc_hd__decap_8
XFILLER_7_109 VGND VGND VPWR VPWR sky130_fd_sc_hd__decap_3
XFILLER_47_53 VGND VGND VPWR VPWR sky130_fd_sc_hd__decap_3
XTAP_TAPCELL_ROW_6_131 VGND VPWR sky130_fd_sc_hd__tapvpwrvgnd_1
XFILLER_19_205 VPWR VGND VPWR VGND sky130_ef_sc_hd__decap_12
XFILLER_47_97 VPWR VGND VPWR VGND sky130_ef_sc_hd__decap_12
XFILLER_42_230 VPWR VGND VPWR VGND sky130_ef_sc_hd__decap_12
XFILLER_6_131 VGND VGND VPWR VPWR sky130_fd_sc_hd__fill_1
XFILLER_8_25 VGND VGND VPWR VPWR sky130_fd_sc_hd__decap_3
XFILLER_8_69 VGND VGND VPWR VPWR sky130_fd_sc_hd__decap_6
X_0650_ _0062_ _0063_ _0064_ VGND VGND VPWR VPWR _0065_ sky130_fd_sc_hd__and3_1
XFILLER_40_6 VGND VGND VPWR VPWR sky130_fd_sc_hd__fill_1
XFILLER_6_197 VGND VGND VPWR VPWR sky130_fd_sc_hd__fill_2
X_1202_ _0572_ _0573_ VGND VGND VPWR VPWR _0575_ sky130_fd_sc_hd__nand2_1
XFILLER_18_260 VPWR VGND VPWR VGND sky130_ef_sc_hd__decap_12
XFILLER_19_3 VGND VGND VPWR VPWR sky130_fd_sc_hd__fill_2
X_1133_ _0505_ _0506_ VGND VGND VPWR VPWR _0508_ sky130_fd_sc_hd__xnor2_1
XPHY_EDGE_ROW_25_Left_73 VGND VGND VPWR VPWR sky130_fd_sc_hd__decap_3
X_1064_ _0376_ _0438_ _0439_ VGND VGND VPWR VPWR _0441_ sky130_fd_sc_hd__or3_1
X_0917_ _0295_ _0296_ _0297_ VGND VGND VPWR VPWR _0298_ sky130_fd_sc_hd__and3_1
X_0779_ _0173_ _0175_ _0176_ VGND VGND VPWR VPWR _0178_ sky130_fd_sc_hd__nand3_1
X_0848_ net64 _0235_ _0236_ _0237_ net106 VGND VGND VPWR VPWR _0027_ sky130_fd_sc_hd__o311a_1
XFILLER_16_219 VGND VGND VPWR VPWR sky130_fd_sc_hd__decap_3
XFILLER_24_241 VGND VGND VPWR VPWR sky130_fd_sc_hd__decap_8
XFILLER_33_55 VGND VGND VPWR VPWR sky130_fd_sc_hd__fill_1
XFILLER_3_178 VGND VGND VPWR VPWR sky130_fd_sc_hd__fill_2
Xhold7 cnn_mac_wrapper.core_inst.product\[1\] VGND VGND VPWR VPWR net114 sky130_fd_sc_hd__dlygate4sd3_1
XFILLER_30_277 VGND VGND VPWR VPWR sky130_fd_sc_hd__decap_3
X_0702_ _0107_ _0108_ _0109_ VGND VGND VPWR VPWR _0110_ sky130_fd_sc_hd__a21o_1
XFILLER_0_81 VGND VGND VPWR VPWR sky130_fd_sc_hd__decap_3
XTAP_TAPCELL_ROW_0_104 VGND VPWR sky130_fd_sc_hd__tapvpwrvgnd_1
X_1116_ _0486_ _0489_ VGND VGND VPWR VPWR _0491_ sky130_fd_sc_hd__xnor2_1
X_1047_ _0423_ VGND VGND VPWR VPWR _0424_ sky130_fd_sc_hd__inv_2
XFILLER_21_211 VGND VGND VPWR VPWR sky130_fd_sc_hd__decap_8
XFILLER_21_233 VPWR VGND VPWR VGND sky130_ef_sc_hd__decap_12
XTAP_TAPCELL_ROW_23_217 VGND VPWR sky130_fd_sc_hd__tapvpwrvgnd_1
XFILLER_0_137 VGND VGND VPWR VPWR sky130_fd_sc_hd__decap_3
XFILLER_28_22 VGND VGND VPWR VPWR sky130_fd_sc_hd__decap_6
XFILLER_28_88 VGND VGND VPWR VPWR sky130_fd_sc_hd__decap_3
XFILLER_5_15 VPWR VGND VPWR VGND sky130_ef_sc_hd__decap_12
XFILLER_47_163 VGND VGND VPWR VPWR sky130_fd_sc_hd__fill_1
XFILLER_47_141 VGND VGND VPWR VPWR sky130_fd_sc_hd__fill_2
XPHY_EDGE_ROW_13_Right_13 VGND VGND VPWR VPWR sky130_fd_sc_hd__decap_3
XPHY_EDGE_ROW_22_Right_22 VGND VGND VPWR VPWR sky130_fd_sc_hd__decap_3
XFILLER_7_281 VGND VGND VPWR VPWR sky130_fd_sc_hd__decap_3
XPHY_EDGE_ROW_31_Right_31 VGND VGND VPWR VPWR sky130_fd_sc_hd__decap_3
XPHY_EDGE_ROW_40_Right_40 VGND VGND VPWR VPWR sky130_fd_sc_hd__decap_3
XPHY_EDGE_ROW_12_Left_60 VGND VGND VPWR VPWR sky130_fd_sc_hd__decap_3
XFILLER_30_45 VGND VGND VPWR VPWR sky130_fd_sc_hd__decap_4
XFILLER_39_43 VPWR VGND VPWR VGND sky130_ef_sc_hd__decap_12
XFILLER_30_78 VGND VGND VPWR VPWR sky130_fd_sc_hd__decap_6
XFILLER_29_152 VGND VGND VPWR VPWR sky130_fd_sc_hd__fill_1
XFILLER_29_163 VGND VGND VPWR VPWR sky130_fd_sc_hd__decap_4
XTAP_TAPCELL_ROW_42_312 VGND VPWR sky130_fd_sc_hd__tapvpwrvgnd_1
XFILLER_35_111 VGND VGND VPWR VPWR sky130_fd_sc_hd__fill_1
XFILLER_26_100 VPWR VGND VPWR VGND sky130_ef_sc_hd__decap_12
XFILLER_26_144 VPWR VGND VPWR VGND sky130_ef_sc_hd__decap_12
XFILLER_41_169 VPWR VGND VPWR VGND sky130_ef_sc_hd__decap_12
XFILLER_41_125 VPWR VGND VPWR VGND sky130_ef_sc_hd__decap_12
XFILLER_41_103 VGND VGND VPWR VPWR sky130_fd_sc_hd__decap_8
XFILLER_2_27 VGND VGND VPWR VPWR sky130_fd_sc_hd__fill_1
XFILLER_1_254 VGND VGND VPWR VPWR sky130_fd_sc_hd__fill_1
XFILLER_1_276 VGND VGND VPWR VPWR sky130_fd_sc_hd__decap_4
XFILLER_17_111 VGND VGND VPWR VPWR sky130_fd_sc_hd__fill_1
XFILLER_17_133 VPWR VGND VPWR VGND sky130_ef_sc_hd__decap_12
X_0950_ _0328_ _0329_ VGND VGND VPWR VPWR _0330_ sky130_fd_sc_hd__and2b_1
X_0881_ _0262_ _0264_ net66 VGND VGND VPWR VPWR _0265_ sky130_fd_sc_hd__a21o_1
X_1295_ clknet_2_3__leaf_aclk _0025_ VGND VGND VPWR VPWR net38 sky130_fd_sc_hd__dfxtp_1
XTAP_TAPCELL_ROW_18_194 VGND VPWR sky130_fd_sc_hd__tapvpwrvgnd_1
XFILLER_23_169 VGND VGND VPWR VPWR sky130_fd_sc_hd__fill_2
XFILLER_36_22 VGND VGND VPWR VPWR sky130_fd_sc_hd__decap_6
Xinput19 s_axis_tlast VGND VGND VPWR VPWR net19 sky130_fd_sc_hd__clkbuf_1
X_1080_ _0411_ _0455_ VGND VGND VPWR VPWR _0456_ sky130_fd_sc_hd__and2_1
XFILLER_20_139 VGND VGND VPWR VPWR sky130_fd_sc_hd__fill_1
X_0864_ _0249_ _0250_ VGND VGND VPWR VPWR _0251_ sky130_fd_sc_hd__nand2_1
X_0933_ net87 net101 net81 net79 VGND VGND VPWR VPWR _0313_ sky130_fd_sc_hd__and4_1
X_0795_ _0188_ _0190_ _0186_ VGND VGND VPWR VPWR _0192_ sky130_fd_sc_hd__a21o_1
XFILLER_9_151 VPWR VGND VPWR VGND sky130_ef_sc_hd__decap_12
XFILLER_13_180 VPWR VGND VPWR VGND sky130_ef_sc_hd__decap_12
XFILLER_3_81 VPWR VGND VPWR VGND sky130_ef_sc_hd__decap_12
XFILLER_43_209 VGND VGND VPWR VPWR sky130_fd_sc_hd__fill_2
XFILLER_36_283 VGND VGND VPWR VPWR sky130_fd_sc_hd__fill_1
X_1278_ clknet_2_3__leaf_aclk _0008_ VGND VGND VPWR VPWR net51 sky130_fd_sc_hd__dfxtp_1
XTAP_TAPCELL_ROW_6_132 VGND VPWR sky130_fd_sc_hd__tapvpwrvgnd_1
XFILLER_42_253 VPWR VGND VPWR VGND sky130_ef_sc_hd__decap_12
XFILLER_42_242 VGND VGND VPWR VPWR sky130_fd_sc_hd__decap_8
XFILLER_8_37 VGND VGND VPWR VPWR sky130_fd_sc_hd__fill_2
XFILLER_8_59 VGND VGND VPWR VPWR sky130_fd_sc_hd__decap_3
XFILLER_10_161 VPWR VGND VPWR VGND sky130_ef_sc_hd__decap_12
X_1201_ _0519_ _0545_ _0572_ _0544_ VGND VGND VPWR VPWR _0574_ sky130_fd_sc_hd__a211o_1
XFILLER_18_272 VPWR VGND VPWR VGND sky130_ef_sc_hd__decap_12
X_1132_ _0506_ _0505_ VGND VGND VPWR VPWR _0507_ sky130_fd_sc_hd__nand2b_1
X_1063_ _0376_ _0438_ _0439_ VGND VGND VPWR VPWR _0440_ sky130_fd_sc_hd__nor3_1
X_0916_ _0275_ _0277_ _0276_ VGND VGND VPWR VPWR _0297_ sky130_fd_sc_hd__o21bai_1
X_0778_ _0175_ _0176_ _0173_ VGND VGND VPWR VPWR _0177_ sky130_fd_sc_hd__a21o_1
X_0847_ net40 net73 VGND VGND VPWR VPWR _0237_ sky130_fd_sc_hd__or2_1
XFILLER_17_57 VGND VGND VPWR VPWR sky130_fd_sc_hd__decap_8
XFILLER_24_253 VGND VGND VPWR VPWR sky130_fd_sc_hd__decap_8
XPHY_EDGE_ROW_42_Left_90 VGND VGND VPWR VPWR sky130_fd_sc_hd__decap_3
XFILLER_3_113 VPWR VGND VPWR VGND sky130_ef_sc_hd__decap_12
Xhold8 net43 VGND VGND VPWR VPWR net115 sky130_fd_sc_hd__dlygate4sd3_1
X_0701_ _0107_ _0108_ net73 VGND VGND VPWR VPWR _0109_ sky130_fd_sc_hd__o21ai_1
XFILLER_2_190 VGND VGND VPWR VPWR sky130_fd_sc_hd__decap_6
XTAP_TAPCELL_ROW_0_105 VGND VPWR sky130_fd_sc_hd__tapvpwrvgnd_1
X_1115_ _0489_ _0486_ VGND VGND VPWR VPWR _0490_ sky130_fd_sc_hd__and2b_1
XTAP_TAPCELL_ROW_23_218 VGND VPWR sky130_fd_sc_hd__tapvpwrvgnd_1
X_1046_ net86 net100 net9 VGND VGND VPWR VPWR _0423_ sky130_fd_sc_hd__o21a_1
XFILLER_21_245 VGND VGND VPWR VPWR sky130_fd_sc_hd__decap_6
XFILLER_44_55 VGND VGND VPWR VPWR sky130_fd_sc_hd__decap_6
XFILLER_44_44 VGND VGND VPWR VPWR sky130_fd_sc_hd__decap_3
XFILLER_8_205 VGND VGND VPWR VPWR sky130_fd_sc_hd__decap_3
XFILLER_5_38 VGND VGND VPWR VPWR sky130_fd_sc_hd__decap_6
XFILLER_5_27 VGND VGND VPWR VPWR sky130_fd_sc_hd__decap_4
XFILLER_47_197 VPWR VGND VPWR VGND sky130_ef_sc_hd__decap_12
XFILLER_47_175 VGND VGND VPWR VPWR sky130_fd_sc_hd__decap_3
X_1029_ cnn_mac_wrapper.core_inst.product\[7\] net72 VGND VGND VPWR VPWR _0407_ sky130_fd_sc_hd__or2_1
XFILLER_14_36 VGND VGND VPWR VPWR sky130_fd_sc_hd__decap_6
XFILLER_30_13 VGND VGND VPWR VPWR sky130_fd_sc_hd__fill_1
XFILLER_30_57 VPWR VGND VPWR VGND sky130_ef_sc_hd__decap_12
XFILLER_39_55 VGND VGND VPWR VPWR sky130_fd_sc_hd__fill_1
XTAP_TAPCELL_ROW_42_313 VGND VPWR sky130_fd_sc_hd__tapvpwrvgnd_1
XFILLER_35_167 VGND VGND VPWR VPWR sky130_fd_sc_hd__fill_1
XFILLER_25_35 VPWR VGND VPWR VGND sky130_ef_sc_hd__decap_12
XFILLER_26_112 VPWR VGND VPWR VGND sky130_ef_sc_hd__decap_12
XFILLER_26_156 VGND VGND VPWR VPWR sky130_fd_sc_hd__decap_8
XFILLER_41_137 VPWR VGND VPWR VGND sky130_ef_sc_hd__decap_12
XFILLER_25_57 VPWR VGND VPWR VGND sky130_ef_sc_hd__decap_12
XFILLER_41_67 VPWR VGND VPWR VGND sky130_ef_sc_hd__decap_12
XFILLER_9_3 VGND VGND VPWR VPWR sky130_fd_sc_hd__decap_6
XFILLER_17_145 VGND VGND VPWR VPWR sky130_fd_sc_hd__decap_3
X_0880_ net89 _0263_ VGND VGND VPWR VPWR _0264_ sky130_fd_sc_hd__nand2_1
XFILLER_40_170 VPWR VGND VPWR VGND sky130_ef_sc_hd__decap_12
X_1294_ clknet_2_1__leaf_aclk _0024_ VGND VGND VPWR VPWR net37 sky130_fd_sc_hd__dfxtp_1
XTAP_TAPCELL_ROW_18_195 VGND VPWR sky130_fd_sc_hd__tapvpwrvgnd_1
XFILLER_11_15 VPWR VGND VPWR VGND sky130_ef_sc_hd__decap_12
XFILLER_39_281 VGND VGND VPWR VPWR sky130_fd_sc_hd__decap_3
XFILLER_14_104 VPWR VGND VPWR VGND sky130_ef_sc_hd__decap_12
XFILLER_45_251 VPWR VGND VPWR VGND sky130_ef_sc_hd__decap_12
X_0932_ net101 net81 net78 net87 VGND VGND VPWR VPWR _0312_ sky130_fd_sc_hd__a22oi_2
XFILLER_13_192 VPWR VGND VPWR VGND sky130_ef_sc_hd__decap_12
XTAP_TAPCELL_ROW_15_176 VGND VPWR sky130_fd_sc_hd__tapvpwrvgnd_1
XFILLER_20_107 VPWR VGND VPWR VGND sky130_ef_sc_hd__decap_12
X_0863_ net60 net44 VGND VGND VPWR VPWR _0250_ sky130_fd_sc_hd__or2_1
X_0794_ _0188_ _0190_ _0186_ VGND VGND VPWR VPWR _0191_ sky130_fd_sc_hd__a21oi_1
XFILLER_9_163 VGND VGND VPWR VPWR sky130_fd_sc_hd__decap_4
XFILLER_3_93 VPWR VGND VPWR VGND sky130_ef_sc_hd__decap_12
XFILLER_36_251 VGND VGND VPWR VPWR sky130_fd_sc_hd__fill_1
X_1277_ clknet_2_3__leaf_aclk _0007_ VGND VGND VPWR VPWR net50 sky130_fd_sc_hd__dfxtp_1
XFILLER_22_47 VGND VGND VPWR VPWR sky130_fd_sc_hd__decap_6
XTAP_TAPCELL_ROW_6_133 VGND VPWR sky130_fd_sc_hd__tapvpwrvgnd_1
XTAP_TAPCELL_ROW_29_246 VGND VPWR sky130_fd_sc_hd__tapvpwrvgnd_1
XFILLER_42_265 VPWR VGND VPWR VGND sky130_ef_sc_hd__decap_12
XTAP_TAPCELL_ROW_37_290 VGND VPWR sky130_fd_sc_hd__tapvpwrvgnd_1
XFILLER_10_173 VGND VGND VPWR VPWR sky130_fd_sc_hd__fill_2
X_1200_ _0519_ _0545_ _0544_ VGND VGND VPWR VPWR _0573_ sky130_fd_sc_hd__a21o_1
XFILLER_33_221 VGND VGND VPWR VPWR sky130_fd_sc_hd__decap_3
X_1131_ _0472_ _0474_ VGND VGND VPWR VPWR _0506_ sky130_fd_sc_hd__nor2_1
X_1062_ _0435_ _0437_ _0391_ _0394_ VGND VGND VPWR VPWR _0439_ sky130_fd_sc_hd__o211a_1
X_0915_ _0293_ _0294_ _0292_ VGND VGND VPWR VPWR _0296_ sky130_fd_sc_hd__o21ai_1
X_0777_ net29 net28 net58 VGND VGND VPWR VPWR _0176_ sky130_fd_sc_hd__o21ai_1
X_0846_ _0233_ _0234_ VGND VGND VPWR VPWR _0236_ sky130_fd_sc_hd__nor2_1
Xclkbuf_2_0__f_aclk clknet_0_aclk VGND VGND VPWR VPWR clknet_2_0__leaf_aclk sky130_fd_sc_hd__clkbuf_16
XFILLER_33_68 VGND VGND VPWR VPWR sky130_fd_sc_hd__fill_1
XTAP_TAPCELL_ROW_34_271 VGND VPWR sky130_fd_sc_hd__tapvpwrvgnd_1
XFILLER_3_125 VGND VGND VPWR VPWR sky130_fd_sc_hd__decap_8
Xhold9 net49 VGND VGND VPWR VPWR net116 sky130_fd_sc_hd__dlygate4sd3_1
X_0700_ _0099_ _0102_ _0101_ VGND VGND VPWR VPWR _0108_ sky130_fd_sc_hd__a21boi_1
X_1114_ _0487_ _0488_ VGND VGND VPWR VPWR _0489_ sky130_fd_sc_hd__or2_1
X_1045_ net86 net100 net75 VGND VGND VPWR VPWR _0422_ sky130_fd_sc_hd__nand3_2
XTAP_TAPCELL_ROW_23_219 VGND VPWR sky130_fd_sc_hd__tapvpwrvgnd_1
XFILLER_9_81 VGND VGND VPWR VPWR sky130_fd_sc_hd__decap_8
X_0829_ net37 net69 _0221_ net104 VGND VGND VPWR VPWR _0024_ sky130_fd_sc_hd__o211a_1
XFILLER_44_67 VGND VGND VPWR VPWR sky130_fd_sc_hd__decap_4
XFILLER_12_202 VGND VGND VPWR VPWR sky130_fd_sc_hd__decap_8
XFILLER_12_213 VGND VGND VPWR VPWR sky130_fd_sc_hd__decap_8
XFILLER_12_268 VPWR VGND VPWR VGND sky130_ef_sc_hd__decap_12
XPHY_EDGE_ROW_7_Right_7 VGND VGND VPWR VPWR sky130_fd_sc_hd__decap_3
X_1028_ _0404_ _0405_ VGND VGND VPWR VPWR _0406_ sky130_fd_sc_hd__xnor2_1
XFILLER_30_69 VGND VGND VPWR VPWR sky130_fd_sc_hd__decap_4
XFILLER_39_67 VGND VGND VPWR VPWR sky130_fd_sc_hd__fill_1
XFILLER_29_110 VGND VGND VPWR VPWR sky130_fd_sc_hd__fill_2
XTAP_TAPCELL_ROW_42_314 VGND VPWR sky130_fd_sc_hd__tapvpwrvgnd_1
XFILLER_4_253 VPWR VGND VPWR VGND sky130_ef_sc_hd__decap_12
XFILLER_35_113 VPWR VGND VPWR VGND sky130_ef_sc_hd__decap_12
XFILLER_25_47 VGND VGND VPWR VPWR sky130_fd_sc_hd__decap_8
XFILLER_25_69 VGND VGND VPWR VPWR sky130_fd_sc_hd__decap_8
XFILLER_26_124 VGND VGND VPWR VPWR sky130_fd_sc_hd__decap_4
XFILLER_41_149 VPWR VGND VPWR VGND sky130_ef_sc_hd__decap_12
XFILLER_41_79 VPWR VGND VPWR VGND sky130_ef_sc_hd__decap_12
XFILLER_41_57 VGND VGND VPWR VPWR sky130_fd_sc_hd__decap_6
XFILLER_1_201 VGND VGND VPWR VPWR sky130_fd_sc_hd__fill_1
XFILLER_2_29 VPWR VGND VPWR VGND sky130_ef_sc_hd__decap_12
XFILLER_40_182 VPWR VGND VPWR VGND sky130_ef_sc_hd__decap_12
X_1293_ clknet_2_1__leaf_aclk _0023_ VGND VGND VPWR VPWR net36 sky130_fd_sc_hd__dfxtp_1
XFILLER_16_190 VGND VGND VPWR VPWR sky130_fd_sc_hd__decap_6
XFILLER_11_27 VPWR VGND VPWR VGND sky130_ef_sc_hd__decap_12
XFILLER_36_79 VGND VGND VPWR VPWR sky130_fd_sc_hd__decap_4
XFILLER_14_116 VPWR VGND VPWR VGND sky130_ef_sc_hd__decap_12
XFILLER_14_138 VGND VGND VPWR VPWR sky130_fd_sc_hd__fill_2
XFILLER_14_149 VGND VGND VPWR VPWR sky130_fd_sc_hd__decap_3
XFILLER_22_193 VGND VGND VPWR VPWR sky130_fd_sc_hd__decap_3
XFILLER_45_263 VPWR VGND VPWR VGND sky130_ef_sc_hd__decap_12
X_0862_ net60 net44 VGND VGND VPWR VPWR _0249_ sky130_fd_sc_hd__nand2_1
X_0931_ net11 net83 VGND VGND VPWR VPWR _0311_ sky130_fd_sc_hd__nand2_1
XTAP_TAPCELL_ROW_15_177 VGND VPWR sky130_fd_sc_hd__tapvpwrvgnd_1
XFILLER_20_119 VPWR VGND VPWR VGND sky130_ef_sc_hd__decap_12
XFILLER_26_90 VGND VGND VPWR VPWR sky130_fd_sc_hd__fill_2
X_0793_ _0175_ _0189_ VGND VGND VPWR VPWR _0190_ sky130_fd_sc_hd__or2_1
X_1276_ clknet_2_3__leaf_aclk _0006_ VGND VGND VPWR VPWR net49 sky130_fd_sc_hd__dfxtp_1
XFILLER_22_15 VPWR VGND VPWR VGND sky130_ef_sc_hd__decap_12
XTAP_TAPCELL_ROW_6_134 VGND VPWR sky130_fd_sc_hd__tapvpwrvgnd_1
XTAP_TAPCELL_ROW_29_247 VGND VPWR sky130_fd_sc_hd__tapvpwrvgnd_1
XFILLER_42_277 VGND VGND VPWR VPWR sky130_fd_sc_hd__decap_6
XFILLER_6_112 VGND VGND VPWR VPWR sky130_fd_sc_hd__decap_3
XFILLER_12_81 VGND VGND VPWR VPWR sky130_fd_sc_hd__decap_3
X_1130_ _0492_ _0503_ VGND VGND VPWR VPWR _0505_ sky130_fd_sc_hd__xor2_1
XFILLER_26_7 VGND VGND VPWR VPWR sky130_fd_sc_hd__decap_4
X_1061_ _0391_ _0394_ _0435_ _0437_ VGND VGND VPWR VPWR _0438_ sky130_fd_sc_hd__a211oi_2
X_0914_ _0292_ _0293_ _0294_ VGND VGND VPWR VPWR _0295_ sky130_fd_sc_hd__or3_1
X_0845_ _0233_ _0234_ VGND VGND VPWR VPWR _0235_ sky130_fd_sc_hd__and2_1
X_0776_ _0157_ _0159_ _0174_ VGND VGND VPWR VPWR _0175_ sky130_fd_sc_hd__a21o_1
X_1259_ _0624_ _0628_ VGND VGND VPWR VPWR _0629_ sky130_fd_sc_hd__xnor2_1
XFILLER_17_15 VGND VGND VPWR VPWR sky130_fd_sc_hd__decap_6
XTAP_TAPCELL_ROW_34_272 VGND VPWR sky130_fd_sc_hd__tapvpwrvgnd_1
XFILLER_15_222 VGND VGND VPWR VPWR sky130_fd_sc_hd__fill_2
XFILLER_15_255 VGND VGND VPWR VPWR sky130_fd_sc_hd__fill_1
XPHY_EDGE_ROW_29_Left_77 VGND VGND VPWR VPWR sky130_fd_sc_hd__decap_3
XFILLER_17_3 VPWR VGND VPWR VGND sky130_ef_sc_hd__decap_12
X_1113_ net82 net80 net91 net16 VGND VGND VPWR VPWR _0488_ sky130_fd_sc_hd__and4b_1
X_1044_ _0417_ _0420_ VGND VGND VPWR VPWR _0421_ sky130_fd_sc_hd__xor2_1
X_0759_ _0157_ _0159_ VGND VGND VPWR VPWR _0160_ sky130_fd_sc_hd__nand2_1
X_0828_ _0218_ _0220_ net69 VGND VGND VPWR VPWR _0221_ sky130_fd_sc_hd__o21ai_1
XFILLER_12_247 VGND VGND VPWR VPWR sky130_fd_sc_hd__fill_1
XFILLER_47_155 VGND VGND VPWR VPWR sky130_fd_sc_hd__decap_8
X_1027_ _0333_ _0365_ _0364_ VGND VGND VPWR VPWR _0405_ sky130_fd_sc_hd__a21o_1
XFILLER_44_158 VGND VGND VPWR VPWR sky130_fd_sc_hd__decap_4
XTAP_TAPCELL_ROW_42_315 VGND VPWR sky130_fd_sc_hd__tapvpwrvgnd_1
XFILLER_4_265 VPWR VGND VPWR VGND sky130_ef_sc_hd__decap_12
XFILLER_35_169 VPWR VGND VPWR VGND sky130_ef_sc_hd__decap_12
XFILLER_35_147 VPWR VGND VPWR VGND sky130_ef_sc_hd__decap_12
XFILLER_35_125 VPWR VGND VPWR VGND sky130_ef_sc_hd__decap_12
XFILLER_29_90 VPWR VGND VPWR VGND sky130_ef_sc_hd__decap_12
XFILLER_6_83 VGND VGND VPWR VPWR sky130_fd_sc_hd__fill_1
XPHY_EDGE_ROW_16_Left_64 VGND VGND VPWR VPWR sky130_fd_sc_hd__decap_3
XFILLER_17_169 VGND VGND VPWR VPWR sky130_fd_sc_hd__decap_8
XFILLER_40_194 VGND VGND VPWR VPWR sky130_fd_sc_hd__fill_2
X_1292_ clknet_2_1__leaf_aclk _0022_ VGND VGND VPWR VPWR net35 sky130_fd_sc_hd__dfxtp_1
XFILLER_11_39 VGND VGND VPWR VPWR sky130_fd_sc_hd__decap_6
XPHY_EDGE_ROW_1_Left_49 VGND VGND VPWR VPWR sky130_fd_sc_hd__decap_3
XFILLER_14_128 VGND VGND VPWR VPWR sky130_fd_sc_hd__decap_3
XFILLER_45_275 VGND VGND VPWR VPWR sky130_fd_sc_hd__decap_4
X_0930_ _0292_ _0294_ _0293_ VGND VGND VPWR VPWR _0310_ sky130_fd_sc_hd__o21bai_1
X_0861_ net42 net73 _0247_ _0248_ net106 VGND VGND VPWR VPWR _0029_ sky130_fd_sc_hd__o221a_1
XFILLER_9_198 VGND VGND VPWR VPWR sky130_fd_sc_hd__fill_2
X_0792_ _0173_ _0181_ VGND VGND VPWR VPWR _0189_ sky130_fd_sc_hd__nand2b_1
XTAP_TAPCELL_ROW_15_178 VGND VPWR sky130_fd_sc_hd__tapvpwrvgnd_1
XFILLER_47_3 VPWR VGND VPWR VGND sky130_ef_sc_hd__decap_12
X_1275_ clknet_2_3__leaf_aclk _0005_ VGND VGND VPWR VPWR net48 sky130_fd_sc_hd__dfxtp_1
XFILLER_36_253 VPWR VGND VPWR VGND sky130_ef_sc_hd__decap_12
XFILLER_3_51 VGND VGND VPWR VPWR sky130_fd_sc_hd__decap_4
XFILLER_22_27 VGND VGND VPWR VPWR sky130_fd_sc_hd__fill_1
Xfanout100 net10 VGND VGND VPWR VPWR net100 sky130_fd_sc_hd__buf_2
XTAP_TAPCELL_ROW_6_135 VGND VPWR sky130_fd_sc_hd__tapvpwrvgnd_1
XFILLER_47_57 VPWR VGND VPWR VGND sky130_ef_sc_hd__decap_12
XTAP_TAPCELL_ROW_29_248 VGND VPWR sky130_fd_sc_hd__tapvpwrvgnd_1
XPHY_EDGE_ROW_29_Right_29 VGND VGND VPWR VPWR sky130_fd_sc_hd__decap_3
XPHY_EDGE_ROW_38_Right_38 VGND VGND VPWR VPWR sky130_fd_sc_hd__decap_3
XFILLER_8_29 VGND VGND VPWR VPWR sky130_fd_sc_hd__decap_8
XFILLER_10_186 VGND VGND VPWR VPWR sky130_fd_sc_hd__decap_3
XFILLER_6_157 VGND VGND VPWR VPWR sky130_fd_sc_hd__decap_8
XFILLER_10_197 VGND VGND VPWR VPWR sky130_fd_sc_hd__fill_1
XPHY_EDGE_ROW_47_Right_47 VGND VGND VPWR VPWR sky130_fd_sc_hd__decap_3
X_1060_ _0433_ _0434_ _0416_ VGND VGND VPWR VPWR _0437_ sky130_fd_sc_hd__a21oi_1
X_0913_ net101 net83 net81 net87 VGND VGND VPWR VPWR _0294_ sky130_fd_sc_hd__a22oi_2
X_0775_ _0163_ _0167_ VGND VGND VPWR VPWR _0174_ sky130_fd_sc_hd__nand2_1
X_0844_ _0228_ _0230_ _0226_ VGND VGND VPWR VPWR _0234_ sky130_fd_sc_hd__a21boi_1
XTAP_TAPCELL_ROW_3_116 VGND VPWR sky130_fd_sc_hd__tapvpwrvgnd_1
X_1258_ _0625_ _0627_ VGND VGND VPWR VPWR _0628_ sky130_fd_sc_hd__xnor2_1
X_1189_ _0555_ _0561_ VGND VGND VPWR VPWR _0562_ sky130_fd_sc_hd__or2_1
XTAP_TAPCELL_ROW_34_273 VGND VPWR sky130_fd_sc_hd__tapvpwrvgnd_1
XFILLER_33_37 VGND VGND VPWR VPWR sky130_fd_sc_hd__decap_6
XFILLER_33_15 VPWR VGND VPWR VGND sky130_ef_sc_hd__decap_12
XFILLER_24_267 VPWR VGND VPWR VGND sky130_ef_sc_hd__decap_12
XFILLER_3_105 VGND VGND VPWR VPWR sky130_fd_sc_hd__decap_6
XFILLER_30_215 VPWR VGND VPWR VGND sky130_ef_sc_hd__decap_12
XPHY_EDGE_ROW_4_Left_52 VGND VGND VPWR VPWR sky130_fd_sc_hd__decap_3
XFILLER_31_6 VPWR VGND VPWR VGND sky130_ef_sc_hd__decap_12
XFILLER_0_41 VPWR VGND VPWR VGND sky130_ef_sc_hd__decap_12
XFILLER_0_85 VPWR VGND VPWR VGND sky130_ef_sc_hd__decap_12
X_1112_ net80 net91 _0053_ net82 VGND VGND VPWR VPWR _0487_ sky130_fd_sc_hd__o2bb2a_1
X_1043_ net95 _0418_ _0419_ VGND VGND VPWR VPWR _0420_ sky130_fd_sc_hd__a21bo_1
XFILLER_9_94 VPWR VGND VPWR VGND sky130_ef_sc_hd__decap_12
X_0758_ _0130_ _0131_ _0156_ _0158_ VGND VGND VPWR VPWR _0159_ sky130_fd_sc_hd__o31a_1
X_0827_ _0214_ _0217_ VGND VGND VPWR VPWR _0220_ sky130_fd_sc_hd__nor2_1
X_0689_ net64 _0097_ _0098_ net106 VGND VGND VPWR VPWR _0007_ sky130_fd_sc_hd__o211a_1
XPHY_EDGE_ROW_46_Left_94 VGND VGND VPWR VPWR sky130_fd_sc_hd__decap_3
XFILLER_44_36 VGND VGND VPWR VPWR sky130_fd_sc_hd__decap_8
XPHY_EDGE_ROW_30_Left_78 VGND VGND VPWR VPWR sky130_fd_sc_hd__decap_3
XFILLER_47_189 VGND VGND VPWR VPWR sky130_fd_sc_hd__decap_6
XFILLER_47_167 VGND VGND VPWR VPWR sky130_fd_sc_hd__fill_1
XFILLER_7_274 VGND VGND VPWR VPWR sky130_fd_sc_hd__fill_2
XFILLER_11_281 VGND VGND VPWR VPWR sky130_fd_sc_hd__decap_3
X_1026_ _0401_ _0403_ VGND VGND VPWR VPWR _0404_ sky130_fd_sc_hd__or2_1
XFILLER_44_115 VGND VGND VPWR VPWR sky130_fd_sc_hd__decap_6
XFILLER_29_167 VGND VGND VPWR VPWR sky130_fd_sc_hd__fill_1
XFILLER_4_277 VGND VGND VPWR VPWR sky130_fd_sc_hd__decap_4
XFILLER_35_159 VGND VGND VPWR VPWR sky130_fd_sc_hd__decap_8
XFILLER_35_137 VGND VGND VPWR VPWR sky130_fd_sc_hd__decap_6
XFILLER_43_181 VGND VGND VPWR VPWR sky130_fd_sc_hd__decap_3
X_1009_ _0384_ _0385_ _0347_ _0349_ VGND VGND VPWR VPWR _0387_ sky130_fd_sc_hd__a211o_1
XFILLER_41_37 VGND VGND VPWR VPWR sky130_fd_sc_hd__decap_8
XFILLER_1_225 VGND VGND VPWR VPWR sky130_fd_sc_hd__decap_4
XFILLER_40_151 VGND VGND VPWR VPWR sky130_fd_sc_hd__decap_8
XFILLER_25_181 VPWR VGND VPWR VGND sky130_ef_sc_hd__decap_12
XPHY_EDGE_ROW_33_Left_81 VGND VGND VPWR VPWR sky130_fd_sc_hd__decap_3
X_1291_ clknet_2_1__leaf_aclk _0021_ VGND VGND VPWR VPWR net34 sky130_fd_sc_hd__dfxtp_1
XFILLER_31_173 VGND VGND VPWR VPWR sky130_fd_sc_hd__fill_1
XFILLER_22_184 VGND VGND VPWR VPWR sky130_fd_sc_hd__fill_1
XFILLER_7_3 VPWR VGND VPWR VGND sky130_ef_sc_hd__decap_12
XFILLER_45_221 VGND VGND VPWR VPWR sky130_fd_sc_hd__decap_3
XFILLER_26_70 VPWR VGND VPWR VGND sky130_ef_sc_hd__decap_12
X_0860_ _0241_ _0243_ _0246_ net64 VGND VGND VPWR VPWR _0248_ sky130_fd_sc_hd__a31o_1
XFILLER_9_188 VGND VGND VPWR VPWR sky130_fd_sc_hd__decap_6
X_0791_ _0187_ VGND VGND VPWR VPWR _0188_ sky130_fd_sc_hd__inv_2
XTAP_TAPCELL_ROW_15_179 VGND VPWR sky130_fd_sc_hd__tapvpwrvgnd_1
X_1274_ clknet_2_3__leaf_aclk _0004_ VGND VGND VPWR VPWR net47 sky130_fd_sc_hd__dfxtp_1
XFILLER_36_265 VPWR VGND VPWR VGND sky130_ef_sc_hd__decap_12
XFILLER_36_221 VPWR VGND VPWR VGND sky130_ef_sc_hd__decap_12
X_0989_ net124 net74 VGND VGND VPWR VPWR _0368_ sky130_fd_sc_hd__or2_1
XFILLER_47_69 VPWR VGND VPWR VGND sky130_ef_sc_hd__decap_12
Xfanout101 net10 VGND VGND VPWR VPWR net101 sky130_fd_sc_hd__dlymetal6s2s_1
XTAP_TAPCELL_ROW_29_249 VGND VPWR sky130_fd_sc_hd__tapvpwrvgnd_1
XFILLER_10_121 VPWR VGND VPWR VGND sky130_ef_sc_hd__decap_12
XFILLER_18_221 VPWR VGND VPWR VGND sky130_ef_sc_hd__decap_12
X_0912_ net87 net101 net83 net81 VGND VGND VPWR VPWR _0293_ sky130_fd_sc_hd__and4_1
X_0774_ _0171_ _0172_ VGND VGND VPWR VPWR _0173_ sky130_fd_sc_hd__nand2_1
XTAP_TAPCELL_ROW_11_160 VGND VPWR sky130_fd_sc_hd__tapvpwrvgnd_1
X_0843_ net59 net40 VGND VGND VPWR VPWR _0233_ sky130_fd_sc_hd__xor2_1
XTAP_TAPCELL_ROW_3_117 VGND VPWR sky130_fd_sc_hd__tapvpwrvgnd_1
X_1257_ _0580_ _0626_ VGND VGND VPWR VPWR _0627_ sky130_fd_sc_hd__xnor2_1
X_1188_ _0523_ _0560_ VGND VGND VPWR VPWR _0561_ sky130_fd_sc_hd__xnor2_1
XTAP_TAPCELL_ROW_34_274 VGND VPWR sky130_fd_sc_hd__tapvpwrvgnd_1
XFILLER_24_279 VGND VGND VPWR VPWR sky130_fd_sc_hd__fill_1
XFILLER_30_227 VPWR VGND VPWR VGND sky130_ef_sc_hd__decap_12
XTAP_TAPCELL_ROW_25_230 VGND VPWR sky130_fd_sc_hd__tapvpwrvgnd_1
XFILLER_24_6 VPWR VGND VPWR VGND sky130_ef_sc_hd__decap_12
XFILLER_0_53 VGND VGND VPWR VPWR sky130_fd_sc_hd__decap_3
XFILLER_0_97 VPWR VGND VPWR VGND sky130_ef_sc_hd__decap_12
X_1111_ net80 net93 _0460_ _0459_ net77 VGND VGND VPWR VPWR _0486_ sky130_fd_sc_hd__a32o_1
X_1042_ net80 net95 net78 net97 VGND VGND VPWR VPWR _0419_ sky130_fd_sc_hd__a22o_1
X_0688_ net50 net73 VGND VGND VPWR VPWR _0098_ sky130_fd_sc_hd__or2_1
XFILLER_0_109 VGND VGND VPWR VPWR sky130_fd_sc_hd__decap_3
X_0757_ _0144_ _0155_ VGND VGND VPWR VPWR _0158_ sky130_fd_sc_hd__or2_1
X_0826_ _0214_ _0217_ VGND VGND VPWR VPWR _0219_ sky130_fd_sc_hd__nand2_1
XTAP_TAPCELL_ROW_39_300 VGND VPWR sky130_fd_sc_hd__tapvpwrvgnd_1
X_1309_ clknet_2_2__leaf_aclk _0039_ VGND VGND VPWR VPWR cnn_mac_wrapper.core_inst.product\[7\]
+ sky130_fd_sc_hd__dfxtp_1
XFILLER_44_26 VGND VGND VPWR VPWR sky130_fd_sc_hd__fill_2
XTAP_TAPCELL_ROW_22_211 VGND VPWR sky130_fd_sc_hd__tapvpwrvgnd_1
XFILLER_47_113 VPWR VGND VPWR VGND sky130_ef_sc_hd__decap_12
XFILLER_18_82 VGND VGND VPWR VPWR sky130_fd_sc_hd__fill_2
XFILLER_34_70 VGND VGND VPWR VPWR sky130_fd_sc_hd__fill_1
XFILLER_22_3 VPWR VGND VPWR VGND sky130_ef_sc_hd__decap_12
X_1025_ _0362_ _0399_ _0400_ VGND VGND VPWR VPWR _0403_ sky130_fd_sc_hd__and3_1
X_0809_ _0201_ _0203_ VGND VGND VPWR VPWR _0204_ sky130_fd_sc_hd__xnor2_1
XFILLER_29_102 VGND VGND VPWR VPWR sky130_fd_sc_hd__decap_8
XFILLER_29_113 VGND VGND VPWR VPWR sky130_fd_sc_hd__decap_6
XFILLER_20_83 VGND VGND VPWR VPWR sky130_fd_sc_hd__fill_1
XFILLER_6_85 VPWR VGND VPWR VGND sky130_ef_sc_hd__decap_12
XFILLER_41_27 VGND VGND VPWR VPWR sky130_fd_sc_hd__fill_1
X_1008_ _0347_ _0349_ _0384_ _0385_ VGND VGND VPWR VPWR _0386_ sky130_fd_sc_hd__o211ai_2
XFILLER_25_193 VPWR VGND VPWR VGND sky130_ef_sc_hd__decap_12
XFILLER_40_141 VGND VGND VPWR VPWR sky130_fd_sc_hd__fill_2
XFILLER_0_281 VGND VGND VPWR VPWR sky130_fd_sc_hd__decap_3
X_1290_ clknet_2_1__leaf_aclk _0020_ VGND VGND VPWR VPWR net33 sky130_fd_sc_hd__dfxtp_1
XFILLER_31_141 VPWR VGND VPWR VGND sky130_ef_sc_hd__decap_12
XFILLER_22_141 VGND VGND VPWR VPWR sky130_fd_sc_hd__decap_3
XFILLER_22_163 VGND VGND VPWR VPWR sky130_fd_sc_hd__fill_1
XFILLER_9_123 VGND VGND VPWR VPWR sky130_fd_sc_hd__decap_4
XFILLER_26_82 VGND VGND VPWR VPWR sky130_fd_sc_hd__fill_2
XFILLER_9_167 VGND VGND VPWR VPWR sky130_fd_sc_hd__fill_1
X_0790_ net31 net30 net29 net28 net58 VGND VGND VPWR VPWR _0187_ sky130_fd_sc_hd__o41a_1
X_1273_ clknet_2_2__leaf_aclk _0003_ VGND VGND VPWR VPWR net46 sky130_fd_sc_hd__dfxtp_1
XFILLER_36_277 VGND VGND VPWR VPWR sky130_fd_sc_hd__decap_6
XFILLER_36_233 VPWR VGND VPWR VGND sky130_ef_sc_hd__decap_12
X_0988_ _0333_ _0366_ VGND VGND VPWR VPWR _0367_ sky130_fd_sc_hd__xnor2_1
XFILLER_22_29 VGND VGND VPWR VPWR sky130_fd_sc_hd__decap_3
Xfanout102 net104 VGND VGND VPWR VPWR net102 sky130_fd_sc_hd__buf_2
XFILLER_47_15 VPWR VGND VPWR VGND sky130_ef_sc_hd__decap_12
XFILLER_27_233 VGND VGND VPWR VPWR sky130_fd_sc_hd__decap_3
XFILLER_27_244 VGND VGND VPWR VPWR sky130_fd_sc_hd__decap_4
XFILLER_10_133 VGND VGND VPWR VPWR sky130_fd_sc_hd__decap_6
XFILLER_18_233 VPWR VGND VPWR VGND sky130_ef_sc_hd__decap_12
X_0911_ net85 net99 VGND VGND VPWR VPWR _0292_ sky130_fd_sc_hd__nand2_1
X_0842_ net64 _0231_ _0232_ net106 VGND VGND VPWR VPWR _0026_ sky130_fd_sc_hd__o211a_1
XFILLER_5_181 VPWR VGND VPWR VGND sky130_ef_sc_hd__decap_12
X_0773_ net58 net30 VGND VGND VPWR VPWR _0172_ sky130_fd_sc_hd__nand2_1
XTAP_TAPCELL_ROW_3_118 VGND VPWR sky130_fd_sc_hd__tapvpwrvgnd_1
X_1256_ _0585_ _0607_ _0606_ VGND VGND VPWR VPWR _0626_ sky130_fd_sc_hd__o21ai_1
XTAP_TAPCELL_ROW_34_275 VGND VPWR sky130_fd_sc_hd__tapvpwrvgnd_1
X_1187_ _0556_ _0559_ VGND VGND VPWR VPWR _0560_ sky130_fd_sc_hd__xnor2_1
XFILLER_15_225 VPWR VGND VPWR VGND sky130_ef_sc_hd__decap_12
XFILLER_30_239 VPWR VGND VPWR VGND sky130_ef_sc_hd__decap_12
XFILLER_30_206 VGND VGND VPWR VPWR sky130_fd_sc_hd__decap_6
X_1110_ net112 net72 _0484_ _0485_ net105 VGND VGND VPWR VPWR _0041_ sky130_fd_sc_hd__o221a_1
X_1041_ net97 net80 net78 VGND VGND VPWR VPWR _0418_ sky130_fd_sc_hd__and3_1
XTAP_TAPCELL_ROW_31_256 VGND VPWR sky130_fd_sc_hd__tapvpwrvgnd_1
X_0825_ _0187_ _0212_ _0213_ _0217_ VGND VGND VPWR VPWR _0218_ sky130_fd_sc_hd__o31a_1
X_0687_ _0095_ _0096_ VGND VGND VPWR VPWR _0097_ sky130_fd_sc_hd__xnor2_1
X_0756_ _0141_ _0149_ _0150_ VGND VGND VPWR VPWR _0157_ sky130_fd_sc_hd__o21ba_1
X_1308_ clknet_2_2__leaf_aclk _0038_ VGND VGND VPWR VPWR cnn_mac_wrapper.core_inst.product\[6\]
+ sky130_fd_sc_hd__dfxtp_1
X_1239_ _0580_ _0609_ VGND VGND VPWR VPWR _0610_ sky130_fd_sc_hd__xor2_1
XTAP_TAPCELL_ROW_22_212 VGND VPWR sky130_fd_sc_hd__tapvpwrvgnd_1
XFILLER_20_283 VGND VGND VPWR VPWR sky130_fd_sc_hd__fill_1
XFILLER_47_125 VPWR VGND VPWR VGND sky130_ef_sc_hd__decap_12
XFILLER_47_169 VGND VGND VPWR VPWR sky130_fd_sc_hd__fill_2
XTAP_TAPCELL_ROW_45_326 VGND VPWR sky130_fd_sc_hd__tapvpwrvgnd_1
XFILLER_7_221 VGND VGND VPWR VPWR sky130_fd_sc_hd__decap_3
XFILLER_38_125 VGND VGND VPWR VPWR sky130_fd_sc_hd__decap_6
X_1024_ _0399_ _0400_ _0362_ VGND VGND VPWR VPWR _0402_ sky130_fd_sc_hd__a21o_1
XFILLER_15_3 VGND VGND VPWR VPWR sky130_fd_sc_hd__decap_8
X_0808_ _0191_ _0195_ _0202_ VGND VGND VPWR VPWR _0203_ sky130_fd_sc_hd__a21o_1
X_0739_ _0140_ _0141_ VGND VGND VPWR VPWR _0142_ sky130_fd_sc_hd__nand2_1
XFILLER_29_169 VPWR VGND VPWR VGND sky130_ef_sc_hd__decap_12
XFILLER_4_202 VPWR VGND VPWR VGND sky130_ef_sc_hd__decap_12
XFILLER_20_95 VPWR VGND VPWR VGND sky130_ef_sc_hd__decap_12
XFILLER_6_53 VPWR VGND VPWR VGND sky130_ef_sc_hd__decap_12
XFILLER_6_97 VGND VGND VPWR VPWR sky130_fd_sc_hd__decap_6
X_1007_ _0382_ _0383_ _0346_ VGND VGND VPWR VPWR _0385_ sky130_fd_sc_hd__o21ai_1
XFILLER_26_128 VGND VGND VPWR VPWR sky130_fd_sc_hd__fill_1
XFILLER_26_139 VGND VGND VPWR VPWR sky130_fd_sc_hd__fill_1
XFILLER_1_238 VPWR VGND VPWR VGND sky130_ef_sc_hd__decap_12
XFILLER_32_109 VGND VGND VPWR VPWR sky130_fd_sc_hd__fill_2
XFILLER_25_161 VGND VGND VPWR VPWR sky130_fd_sc_hd__decap_6
XFILLER_40_197 VPWR VGND VPWR VGND sky130_ef_sc_hd__decap_12
Xoutput50 net50 VGND VGND VPWR VPWR m_axis_tdata[7] sky130_fd_sc_hd__buf_2
XFILLER_31_153 VPWR VGND VPWR VGND sky130_ef_sc_hd__decap_12
XFILLER_22_120 VGND VGND VPWR VPWR sky130_fd_sc_hd__fill_1
XTAP_TAPCELL_ROW_9_146 VGND VPWR sky130_fd_sc_hd__tapvpwrvgnd_1
XFILLER_9_113 VGND VGND VPWR VPWR sky130_fd_sc_hd__fill_2
X_1272_ clknet_2_2__leaf_aclk _0002_ VGND VGND VPWR VPWR net43 sky130_fd_sc_hd__dfxtp_1
XFILLER_36_245 VGND VGND VPWR VPWR sky130_fd_sc_hd__decap_6
X_0987_ _0364_ _0365_ VGND VGND VPWR VPWR _0366_ sky130_fd_sc_hd__nand2b_1
Xfanout103 net104 VGND VGND VPWR VPWR net103 sky130_fd_sc_hd__buf_2
XFILLER_47_27 VGND VGND VPWR VPWR sky130_fd_sc_hd__fill_1
XPHY_EDGE_ROW_16_Right_16 VGND VGND VPWR VPWR sky130_fd_sc_hd__decap_3
XFILLER_18_245 VGND VGND VPWR VPWR sky130_fd_sc_hd__fill_2
XFILLER_41_281 VGND VGND VPWR VPWR sky130_fd_sc_hd__decap_3
X_0910_ _0289_ _0290_ VGND VGND VPWR VPWR _0291_ sky130_fd_sc_hd__or2_1
X_0772_ net58 net30 VGND VGND VPWR VPWR _0171_ sky130_fd_sc_hd__or2_1
XPHY_EDGE_ROW_25_Right_25 VGND VGND VPWR VPWR sky130_fd_sc_hd__decap_3
X_0841_ net39 net73 VGND VGND VPWR VPWR _0232_ sky130_fd_sc_hd__or2_1
XPHY_EDGE_ROW_34_Right_34 VGND VGND VPWR VPWR sky130_fd_sc_hd__decap_3
X_1255_ _0580_ _0609_ _0578_ VGND VGND VPWR VPWR _0625_ sky130_fd_sc_hd__a21oi_1
XTAP_TAPCELL_ROW_3_119 VGND VPWR sky130_fd_sc_hd__tapvpwrvgnd_1
X_1186_ _0557_ _0558_ VGND VGND VPWR VPWR _0559_ sky130_fd_sc_hd__nand2_1
XPHY_EDGE_ROW_43_Right_43 VGND VGND VPWR VPWR sky130_fd_sc_hd__decap_3
XFILLER_15_237 VPWR VGND VPWR VGND sky130_ef_sc_hd__decap_12
XFILLER_23_281 VGND VGND VPWR VPWR sky130_fd_sc_hd__decap_3
X_1040_ net82 net93 VGND VGND VPWR VPWR _0417_ sky130_fd_sc_hd__nand2_1
XTAP_TAPCELL_ROW_31_257 VGND VPWR sky130_fd_sc_hd__tapvpwrvgnd_1
X_0755_ _0145_ _0155_ VGND VGND VPWR VPWR _0156_ sky130_fd_sc_hd__or2_1
X_0824_ _0215_ _0216_ VGND VGND VPWR VPWR _0217_ sky130_fd_sc_hd__and2_1
X_0686_ _0081_ _0087_ _0089_ _0086_ VGND VGND VPWR VPWR _0096_ sky130_fd_sc_hd__a31o_1
XFILLER_28_29 VGND VGND VPWR VPWR sky130_fd_sc_hd__fill_2
X_1307_ clknet_2_2__leaf_aclk _0037_ VGND VGND VPWR VPWR cnn_mac_wrapper.core_inst.product\[5\]
+ sky130_fd_sc_hd__dfxtp_1
X_1238_ _0582_ _0585_ _0606_ _0608_ VGND VGND VPWR VPWR _0609_ sky130_fd_sc_hd__a22o_1
X_1169_ _0520_ _0542_ VGND VGND VPWR VPWR _0543_ sky130_fd_sc_hd__xor2_1
XFILLER_12_229 VPWR VGND VPWR VGND sky130_ef_sc_hd__decap_12
XFILLER_20_251 VGND VGND VPWR VPWR sky130_fd_sc_hd__fill_1
XTAP_TAPCELL_ROW_22_213 VGND VPWR sky130_fd_sc_hd__tapvpwrvgnd_1
XPHY_EDGE_ROW_8_Left_56 VGND VGND VPWR VPWR sky130_fd_sc_hd__decap_3
XFILLER_47_137 VGND VGND VPWR VPWR sky130_fd_sc_hd__decap_3
XTAP_TAPCELL_ROW_45_327 VGND VPWR sky130_fd_sc_hd__tapvpwrvgnd_1
XFILLER_34_83 VGND VGND VPWR VPWR sky130_fd_sc_hd__fill_1
XFILLER_7_266 VGND VGND VPWR VPWR sky130_fd_sc_hd__decap_8
X_1023_ _0399_ _0400_ _0362_ VGND VGND VPWR VPWR _0401_ sky130_fd_sc_hd__a21oi_1
X_0807_ net34 net33 net57 VGND VGND VPWR VPWR _0202_ sky130_fd_sc_hd__o21a_1
X_0738_ cnn_mac_wrapper.core_inst.product\[14\] net26 VGND VGND VPWR VPWR _0141_ sky130_fd_sc_hd__nand2_1
X_0669_ cnn_mac_wrapper.core_inst.product\[5\] net48 VGND VGND VPWR VPWR _0081_ sky130_fd_sc_hd__or2_1
XPHY_EDGE_ROW_2_Right_2 VGND VGND VPWR VPWR sky130_fd_sc_hd__decap_3
XFILLER_29_137 VGND VGND VPWR VPWR sky130_fd_sc_hd__fill_2
XFILLER_29_148 VGND VGND VPWR VPWR sky130_fd_sc_hd__decap_4
XFILLER_4_214 VPWR VGND VPWR VGND sky130_ef_sc_hd__decap_12
XFILLER_20_41 VPWR VGND VPWR VGND sky130_ef_sc_hd__decap_12
XFILLER_20_85 VGND VGND VPWR VPWR sky130_fd_sc_hd__decap_4
XFILLER_35_107 VGND VGND VPWR VPWR sky130_fd_sc_hd__decap_4
XFILLER_28_192 VGND VGND VPWR VPWR sky130_fd_sc_hd__fill_1
XFILLER_43_173 VGND VGND VPWR VPWR sky130_fd_sc_hd__decap_8
XFILLER_6_65 VPWR VGND VPWR VGND sky130_ef_sc_hd__decap_12
XFILLER_19_181 VPWR VGND VPWR VGND sky130_ef_sc_hd__decap_12
X_1006_ _0346_ _0382_ _0383_ VGND VGND VPWR VPWR _0384_ sky130_fd_sc_hd__or3_1
XFILLER_9_9 VGND VGND VPWR VPWR sky130_fd_sc_hd__fill_1
XFILLER_17_107 VGND VGND VPWR VPWR sky130_fd_sc_hd__decap_4
Xoutput51 net51 VGND VGND VPWR VPWR m_axis_tdata[8] sky130_fd_sc_hd__buf_2
Xoutput40 net40 VGND VGND VPWR VPWR m_axis_tdata[27] sky130_fd_sc_hd__buf_2
XFILLER_31_165 VGND VGND VPWR VPWR sky130_fd_sc_hd__decap_3
XFILLER_36_29 VPWR VGND VPWR VGND sky130_ef_sc_hd__decap_12
XTAP_TAPCELL_ROW_17_190 VGND VPWR sky130_fd_sc_hd__tapvpwrvgnd_1
XTAP_TAPCELL_ROW_9_147 VGND VPWR sky130_fd_sc_hd__tapvpwrvgnd_1
XFILLER_45_279 VGND VGND VPWR VPWR sky130_fd_sc_hd__fill_1
XFILLER_45_213 VGND VGND VPWR VPWR sky130_fd_sc_hd__fill_1
XPHY_EDGE_ROW_37_Left_85 VGND VGND VPWR VPWR sky130_fd_sc_hd__decap_3
XFILLER_42_83 VGND VGND VPWR VPWR sky130_fd_sc_hd__fill_1
XPHY_EDGE_ROW_21_Left_69 VGND VGND VPWR VPWR sky130_fd_sc_hd__decap_3
X_1271_ clknet_2_2__leaf_aclk _0001_ VGND VGND VPWR VPWR net32 sky130_fd_sc_hd__dfxtp_1
XFILLER_3_55 VGND VGND VPWR VPWR sky130_fd_sc_hd__fill_1
X_0986_ _0362_ _0363_ _0331_ VGND VGND VPWR VPWR _0365_ sky130_fd_sc_hd__o21ai_1
XTAP_TAPCELL_ROW_14_171 VGND VPWR sky130_fd_sc_hd__tapvpwrvgnd_1
Xfanout104 net1 VGND VGND VPWR VPWR net104 sky130_fd_sc_hd__buf_2
XFILLER_5_3 VPWR VGND VPWR VGND sky130_ef_sc_hd__decap_12
XTAP_TAPCELL_ROW_28_241 VGND VPWR sky130_fd_sc_hd__tapvpwrvgnd_1
X_0771_ net62 _0169_ _0170_ net103 VGND VGND VPWR VPWR _0017_ sky130_fd_sc_hd__o211a_1
X_0840_ _0227_ _0230_ VGND VGND VPWR VPWR _0231_ sky130_fd_sc_hd__xnor2_1
X_1254_ _0611_ _0615_ VGND VGND VPWR VPWR _0624_ sky130_fd_sc_hd__nand2_1
X_1185_ _0052_ _0053_ net78 net91 VGND VGND VPWR VPWR _0558_ sky130_fd_sc_hd__or4b_2
XFILLER_24_249 VGND VGND VPWR VPWR sky130_fd_sc_hd__decap_3
X_0969_ net86 net77 net79 net100 VGND VGND VPWR VPWR _0348_ sky130_fd_sc_hd__a22oi_2
XFILLER_15_249 VGND VGND VPWR VPWR sky130_fd_sc_hd__decap_6
XFILLER_23_52 VGND VGND VPWR VPWR sky130_fd_sc_hd__decap_4
XTAP_TAPCELL_ROW_31_258 VGND VPWR sky130_fd_sc_hd__tapvpwrvgnd_1
XFILLER_9_43 VGND VGND VPWR VPWR sky130_fd_sc_hd__fill_1
X_0685_ _0093_ _0094_ VGND VGND VPWR VPWR _0095_ sky130_fd_sc_hd__nand2_1
X_0754_ _0142_ _0151_ VGND VGND VPWR VPWR _0155_ sky130_fd_sc_hd__or2_1
X_0823_ net59 net37 VGND VGND VPWR VPWR _0216_ sky130_fd_sc_hd__nand2_1
XPHY_EDGE_ROW_24_Left_72 VGND VGND VPWR VPWR sky130_fd_sc_hd__decap_3
X_1306_ clknet_2_2__leaf_aclk _0036_ VGND VGND VPWR VPWR cnn_mac_wrapper.core_inst.product\[4\]
+ sky130_fd_sc_hd__dfxtp_1
XFILLER_44_18 VGND VGND VPWR VPWR sky130_fd_sc_hd__decap_8
X_1237_ _0585_ _0607_ VGND VGND VPWR VPWR _0608_ sky130_fd_sc_hd__nor2_1
X_1168_ _0540_ _0541_ VGND VGND VPWR VPWR _0542_ sky130_fd_sc_hd__nand2_1
X_1099_ _0472_ _0473_ _0457_ VGND VGND VPWR VPWR _0475_ sky130_fd_sc_hd__o21a_1
XTAP_TAPCELL_ROW_22_214 VGND VPWR sky130_fd_sc_hd__tapvpwrvgnd_1
XFILLER_18_41 VPWR VGND VPWR VGND sky130_ef_sc_hd__decap_12
XFILLER_18_85 VGND VGND VPWR VPWR sky130_fd_sc_hd__fill_1
XTAP_TAPCELL_ROW_45_328 VGND VPWR sky130_fd_sc_hd__tapvpwrvgnd_1
XFILLER_11_252 VPWR VGND VPWR VGND sky130_ef_sc_hd__decap_12
X_1022_ _0396_ _0397_ _0336_ VGND VGND VPWR VPWR _0400_ sky130_fd_sc_hd__o21bai_1
X_0668_ _0076_ _0077_ _0074_ VGND VGND VPWR VPWR _0080_ sky130_fd_sc_hd__a21oi_1
X_0737_ cnn_mac_wrapper.core_inst.product\[14\] net26 VGND VGND VPWR VPWR _0140_ sky130_fd_sc_hd__or2_1
X_0806_ _0199_ _0200_ VGND VGND VPWR VPWR _0201_ sky130_fd_sc_hd__nand2_1
XFILLER_44_108 VGND VGND VPWR VPWR sky130_fd_sc_hd__decap_3
XFILLER_4_226 VPWR VGND VPWR VGND sky130_ef_sc_hd__decap_12
XFILLER_20_53 VPWR VGND VPWR VGND sky130_ef_sc_hd__decap_12
XFILLER_29_40 VGND VGND VPWR VPWR sky130_fd_sc_hd__decap_4
XFILLER_45_72 VGND VGND VPWR VPWR sky130_fd_sc_hd__fill_1
XFILLER_43_152 VPWR VGND VPWR VGND sky130_ef_sc_hd__decap_12
XFILLER_6_77 VGND VGND VPWR VPWR sky130_fd_sc_hd__decap_6
XFILLER_3_281 VGND VGND VPWR VPWR sky130_fd_sc_hd__decap_3
XFILLER_3_270 VGND VGND VPWR VPWR sky130_fd_sc_hd__fill_2
XFILLER_20_3 VGND VGND VPWR VPWR sky130_fd_sc_hd__decap_4
XFILLER_34_141 VGND VGND VPWR VPWR sky130_fd_sc_hd__fill_2
XFILLER_34_130 VGND VGND VPWR VPWR sky130_fd_sc_hd__fill_1
XFILLER_19_193 VGND VGND VPWR VPWR sky130_fd_sc_hd__fill_1
X_1005_ net86 net75 net16 VGND VGND VPWR VPWR _0383_ sky130_fd_sc_hd__and3_1
XFILLER_1_218 VGND VGND VPWR VPWR sky130_fd_sc_hd__decap_6
XFILLER_1_229 VGND VGND VPWR VPWR sky130_fd_sc_hd__fill_1
XFILLER_15_75 VPWR VGND VPWR VGND sky130_ef_sc_hd__decap_12
Xoutput41 net41 VGND VGND VPWR VPWR m_axis_tdata[28] sky130_fd_sc_hd__buf_2
Xoutput30 net30 VGND VGND VPWR VPWR m_axis_tdata[18] sky130_fd_sc_hd__buf_2
Xoutput52 net52 VGND VGND VPWR VPWR m_axis_tdata[9] sky130_fd_sc_hd__buf_2
XFILLER_0_251 VGND VGND VPWR VPWR sky130_fd_sc_hd__fill_1
XFILLER_31_111 VGND VGND VPWR VPWR sky130_fd_sc_hd__fill_1
XFILLER_16_141 VGND VGND VPWR VPWR sky130_fd_sc_hd__decap_6
.ends
